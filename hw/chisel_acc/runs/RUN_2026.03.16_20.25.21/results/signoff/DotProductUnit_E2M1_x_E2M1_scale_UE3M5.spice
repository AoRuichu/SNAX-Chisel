* NGSPICE file created from DotProductUnit_E2M1_x_E2M1_scale_UE3M5.ext - technology: sky130A

* Black-box entry subcircuit for sky130_fd_sc_hd__o21a_1 abstract view
.subckt sky130_fd_sc_hd__o21a_1 A1 A2 B1 VGND VNB VPB VPWR X
.ends

* Black-box entry subcircuit for sky130_fd_sc_hd__and4_1 abstract view
.subckt sky130_fd_sc_hd__and4_1 A B C D VGND VNB VPB VPWR X
.ends

* Black-box entry subcircuit for sky130_fd_sc_hd__fill_1 abstract view
.subckt sky130_fd_sc_hd__fill_1 VGND VNB VPB VPWR
.ends

* Black-box entry subcircuit for sky130_fd_sc_hd__mux2_2 abstract view
.subckt sky130_fd_sc_hd__mux2_2 A0 A1 S VGND VNB VPB VPWR X
.ends

* Black-box entry subcircuit for sky130_fd_sc_hd__a21oi_1 abstract view
.subckt sky130_fd_sc_hd__a21oi_1 A1 A2 B1 VGND VNB VPB VPWR Y
.ends

* Black-box entry subcircuit for sky130_fd_sc_hd__decap_8 abstract view
.subckt sky130_fd_sc_hd__decap_8 VGND VNB VPB VPWR
.ends

* Black-box entry subcircuit for sky130_fd_sc_hd__decap_3 abstract view
.subckt sky130_fd_sc_hd__decap_3 VGND VNB VPB VPWR
.ends

* Black-box entry subcircuit for sky130_ef_sc_hd__decap_12 abstract view
.subckt sky130_ef_sc_hd__decap_12 VPWR VGND VPB VNB
.ends

* Black-box entry subcircuit for sky130_fd_sc_hd__and2_1 abstract view
.subckt sky130_fd_sc_hd__and2_1 A B VGND VNB VPB VPWR X
.ends

* Black-box entry subcircuit for sky130_fd_sc_hd__tapvpwrvgnd_1 abstract view
.subckt sky130_fd_sc_hd__tapvpwrvgnd_1 VGND VPWR
.ends

* Black-box entry subcircuit for sky130_fd_sc_hd__clkbuf_1 abstract view
.subckt sky130_fd_sc_hd__clkbuf_1 A VGND VNB VPB VPWR X
.ends

* Black-box entry subcircuit for sky130_fd_sc_hd__decap_6 abstract view
.subckt sky130_fd_sc_hd__decap_6 VGND VNB VPB VPWR
.ends

* Black-box entry subcircuit for sky130_fd_sc_hd__decap_4 abstract view
.subckt sky130_fd_sc_hd__decap_4 VGND VNB VPB VPWR
.ends

* Black-box entry subcircuit for sky130_fd_sc_hd__o22a_1 abstract view
.subckt sky130_fd_sc_hd__o22a_1 A1 A2 B1 B2 VGND VNB VPB VPWR X
.ends

* Black-box entry subcircuit for sky130_fd_sc_hd__nand2_1 abstract view
.subckt sky130_fd_sc_hd__nand2_1 A B VGND VNB VPB VPWR Y
.ends

* Black-box entry subcircuit for sky130_fd_sc_hd__a31o_1 abstract view
.subckt sky130_fd_sc_hd__a31o_1 A1 A2 A3 B1 VGND VNB VPB VPWR X
.ends

* Black-box entry subcircuit for sky130_fd_sc_hd__a221oi_2 abstract view
.subckt sky130_fd_sc_hd__a221oi_2 A1 A2 B1 B2 C1 VGND VNB VPB VPWR Y
.ends

* Black-box entry subcircuit for sky130_fd_sc_hd__clkbuf_4 abstract view
.subckt sky130_fd_sc_hd__clkbuf_4 A VGND VNB VPB VPWR X
.ends

* Black-box entry subcircuit for sky130_fd_sc_hd__o211ai_1 abstract view
.subckt sky130_fd_sc_hd__o211ai_1 A1 A2 B1 C1 VGND VNB VPB VPWR Y
.ends

* Black-box entry subcircuit for sky130_fd_sc_hd__and2b_1 abstract view
.subckt sky130_fd_sc_hd__and2b_1 A_N B VGND VNB VPB VPWR X
.ends

* Black-box entry subcircuit for sky130_fd_sc_hd__o31a_1 abstract view
.subckt sky130_fd_sc_hd__o31a_1 A1 A2 A3 B1 VGND VNB VPB VPWR X
.ends

* Black-box entry subcircuit for sky130_fd_sc_hd__mux2_4 abstract view
.subckt sky130_fd_sc_hd__mux2_4 A0 A1 S VGND VNB VPB VPWR X
.ends

* Black-box entry subcircuit for sky130_fd_sc_hd__inv_2 abstract view
.subckt sky130_fd_sc_hd__inv_2 A VGND VNB VPB VPWR Y
.ends

* Black-box entry subcircuit for sky130_fd_sc_hd__mux2_1 abstract view
.subckt sky130_fd_sc_hd__mux2_1 A0 A1 S VGND VNB VPB VPWR X
.ends

* Black-box entry subcircuit for sky130_fd_sc_hd__fill_2 abstract view
.subckt sky130_fd_sc_hd__fill_2 VGND VNB VPB VPWR
.ends

* Black-box entry subcircuit for sky130_fd_sc_hd__a21o_1 abstract view
.subckt sky130_fd_sc_hd__a21o_1 A1 A2 B1 VGND VNB VPB VPWR X
.ends

* Black-box entry subcircuit for sky130_fd_sc_hd__xnor2_4 abstract view
.subckt sky130_fd_sc_hd__xnor2_4 A B VGND VNB VPB VPWR Y
.ends

* Black-box entry subcircuit for sky130_fd_sc_hd__and3_1 abstract view
.subckt sky130_fd_sc_hd__and3_1 A B C VGND VNB VPB VPWR X
.ends

* Black-box entry subcircuit for sky130_fd_sc_hd__dfxtp_1 abstract view
.subckt sky130_fd_sc_hd__dfxtp_1 CLK D VGND VNB VPB VPWR Q
.ends

* Black-box entry subcircuit for sky130_fd_sc_hd__xor2_2 abstract view
.subckt sky130_fd_sc_hd__xor2_2 A B VGND VNB VPB VPWR X
.ends

* Black-box entry subcircuit for sky130_fd_sc_hd__nor2_1 abstract view
.subckt sky130_fd_sc_hd__nor2_1 A B VGND VNB VPB VPWR Y
.ends

* Black-box entry subcircuit for sky130_fd_sc_hd__dlygate4sd3_1 abstract view
.subckt sky130_fd_sc_hd__dlygate4sd3_1 A VGND VNB VPB VPWR X
.ends

* Black-box entry subcircuit for sky130_fd_sc_hd__dlymetal6s2s_1 abstract view
.subckt sky130_fd_sc_hd__dlymetal6s2s_1 A VGND VNB VPB VPWR X
.ends

* Black-box entry subcircuit for sky130_fd_sc_hd__clkbuf_2 abstract view
.subckt sky130_fd_sc_hd__clkbuf_2 A VGND VNB VPB VPWR X
.ends

* Black-box entry subcircuit for sky130_fd_sc_hd__buf_2 abstract view
.subckt sky130_fd_sc_hd__buf_2 A VGND VNB VPB VPWR X
.ends

* Black-box entry subcircuit for sky130_fd_sc_hd__dlygate4sd1_1 abstract view
.subckt sky130_fd_sc_hd__dlygate4sd1_1 A VGND VNB VPB VPWR X
.ends

* Black-box entry subcircuit for sky130_fd_sc_hd__a32o_1 abstract view
.subckt sky130_fd_sc_hd__a32o_1 A1 A2 A3 B1 B2 VGND VNB VPB VPWR X
.ends

* Black-box entry subcircuit for sky130_fd_sc_hd__dfxtp_2 abstract view
.subckt sky130_fd_sc_hd__dfxtp_2 CLK D VGND VNB VPB VPWR Q
.ends

* Black-box entry subcircuit for sky130_fd_sc_hd__or2_2 abstract view
.subckt sky130_fd_sc_hd__or2_2 A B VGND VNB VPB VPWR X
.ends

* Black-box entry subcircuit for sky130_fd_sc_hd__o221a_1 abstract view
.subckt sky130_fd_sc_hd__o221a_1 A1 A2 B1 B2 C1 VGND VNB VPB VPWR X
.ends

* Black-box entry subcircuit for sky130_fd_sc_hd__or3b_1 abstract view
.subckt sky130_fd_sc_hd__or3b_1 A B C_N VGND VNB VPB VPWR X
.ends

* Black-box entry subcircuit for sky130_fd_sc_hd__xor2_1 abstract view
.subckt sky130_fd_sc_hd__xor2_1 A B VGND VNB VPB VPWR X
.ends

* Black-box entry subcircuit for sky130_fd_sc_hd__o311ai_4 abstract view
.subckt sky130_fd_sc_hd__o311ai_4 A1 A2 A3 B1 C1 VGND VNB VPB VPWR Y
.ends

* Black-box entry subcircuit for sky130_fd_sc_hd__a21oi_2 abstract view
.subckt sky130_fd_sc_hd__a21oi_2 A1 A2 B1 VGND VNB VPB VPWR Y
.ends

* Black-box entry subcircuit for sky130_fd_sc_hd__or2_1 abstract view
.subckt sky130_fd_sc_hd__or2_1 A B VGND VNB VPB VPWR X
.ends

* Black-box entry subcircuit for sky130_fd_sc_hd__a22oi_1 abstract view
.subckt sky130_fd_sc_hd__a22oi_1 A1 A2 B1 B2 VGND VNB VPB VPWR Y
.ends

* Black-box entry subcircuit for sky130_fd_sc_hd__xnor2_2 abstract view
.subckt sky130_fd_sc_hd__xnor2_2 A B VGND VNB VPB VPWR Y
.ends

* Black-box entry subcircuit for sky130_fd_sc_hd__a21o_4 abstract view
.subckt sky130_fd_sc_hd__a21o_4 A1 A2 B1 VGND VNB VPB VPWR X
.ends

* Black-box entry subcircuit for sky130_fd_sc_hd__a2bb2o_1 abstract view
.subckt sky130_fd_sc_hd__a2bb2o_1 A1_N A2_N B1 B2 VGND VNB VPB VPWR X
.ends

* Black-box entry subcircuit for sky130_fd_sc_hd__buf_8 abstract view
.subckt sky130_fd_sc_hd__buf_8 A VGND VNB VPB VPWR X
.ends

* Black-box entry subcircuit for sky130_fd_sc_hd__o2bb2a_1 abstract view
.subckt sky130_fd_sc_hd__o2bb2a_1 A1_N A2_N B1 B2 VGND VNB VPB VPWR X
.ends

* Black-box entry subcircuit for sky130_fd_sc_hd__buf_4 abstract view
.subckt sky130_fd_sc_hd__buf_4 A VGND VNB VPB VPWR X
.ends

* Black-box entry subcircuit for sky130_fd_sc_hd__a22o_1 abstract view
.subckt sky130_fd_sc_hd__a22o_1 A1 A2 B1 B2 VGND VNB VPB VPWR X
.ends

* Black-box entry subcircuit for sky130_fd_sc_hd__buf_1 abstract view
.subckt sky130_fd_sc_hd__buf_1 A VGND VNB VPB VPWR X
.ends

* Black-box entry subcircuit for sky130_fd_sc_hd__or4_1 abstract view
.subckt sky130_fd_sc_hd__or4_1 A B C D VGND VNB VPB VPWR X
.ends

* Black-box entry subcircuit for sky130_fd_sc_hd__a32oi_4 abstract view
.subckt sky130_fd_sc_hd__a32oi_4 A1 A2 A3 B1 B2 VGND VNB VPB VPWR Y
.ends

* Black-box entry subcircuit for sky130_fd_sc_hd__o211a_1 abstract view
.subckt sky130_fd_sc_hd__o211a_1 A1 A2 B1 C1 VGND VNB VPB VPWR X
.ends

* Black-box entry subcircuit for sky130_fd_sc_hd__nand2_2 abstract view
.subckt sky130_fd_sc_hd__nand2_2 A B VGND VNB VPB VPWR Y
.ends

* Black-box entry subcircuit for sky130_fd_sc_hd__a21oi_4 abstract view
.subckt sky130_fd_sc_hd__a21oi_4 A1 A2 B1 VGND VNB VPB VPWR Y
.ends

* Black-box entry subcircuit for sky130_fd_sc_hd__xnor2_1 abstract view
.subckt sky130_fd_sc_hd__xnor2_1 A B VGND VNB VPB VPWR Y
.ends

* Black-box entry subcircuit for sky130_fd_sc_hd__a2bb2o_4 abstract view
.subckt sky130_fd_sc_hd__a2bb2o_4 A1_N A2_N B1 B2 VGND VNB VPB VPWR X
.ends

* Black-box entry subcircuit for sky130_fd_sc_hd__or3_1 abstract view
.subckt sky130_fd_sc_hd__or3_1 A B C VGND VNB VPB VPWR X
.ends

* Black-box entry subcircuit for sky130_fd_sc_hd__buf_6 abstract view
.subckt sky130_fd_sc_hd__buf_6 A VGND VNB VPB VPWR X
.ends

* Black-box entry subcircuit for sky130_fd_sc_hd__o21ai_1 abstract view
.subckt sky130_fd_sc_hd__o21ai_1 A1 A2 B1 VGND VNB VPB VPWR Y
.ends

* Black-box entry subcircuit for sky130_fd_sc_hd__a311o_1 abstract view
.subckt sky130_fd_sc_hd__a311o_1 A1 A2 A3 B1 C1 VGND VNB VPB VPWR X
.ends

* Black-box entry subcircuit for sky130_fd_sc_hd__nand4_1 abstract view
.subckt sky130_fd_sc_hd__nand4_1 A B C D VGND VNB VPB VPWR Y
.ends

* Black-box entry subcircuit for sky130_fd_sc_hd__a211o_1 abstract view
.subckt sky130_fd_sc_hd__a211o_1 A1 A2 B1 C1 VGND VNB VPB VPWR X
.ends

* Black-box entry subcircuit for sky130_fd_sc_hd__or3_4 abstract view
.subckt sky130_fd_sc_hd__or3_4 A B C VGND VNB VPB VPWR X
.ends

* Black-box entry subcircuit for sky130_fd_sc_hd__nor2b_2 abstract view
.subckt sky130_fd_sc_hd__nor2b_2 A B_N VGND VNB VPB VPWR Y
.ends

* Black-box entry subcircuit for sky130_fd_sc_hd__or4b_4 abstract view
.subckt sky130_fd_sc_hd__or4b_4 A B C D_N VGND VNB VPB VPWR X
.ends

* Black-box entry subcircuit for sky130_fd_sc_hd__nor2_2 abstract view
.subckt sky130_fd_sc_hd__nor2_2 A B VGND VNB VPB VPWR Y
.ends

* Black-box entry subcircuit for sky130_fd_sc_hd__xor2_4 abstract view
.subckt sky130_fd_sc_hd__xor2_4 A B VGND VNB VPB VPWR X
.ends

* Black-box entry subcircuit for sky130_fd_sc_hd__or2b_1 abstract view
.subckt sky130_fd_sc_hd__or2b_1 A B_N VGND VNB VPB VPWR X
.ends

* Black-box entry subcircuit for sky130_fd_sc_hd__clkbuf_16 abstract view
.subckt sky130_fd_sc_hd__clkbuf_16 A VGND VNB VPB VPWR X
.ends

* Black-box entry subcircuit for sky130_fd_sc_hd__o32ai_4 abstract view
.subckt sky130_fd_sc_hd__o32ai_4 A1 A2 A3 B1 B2 VGND VNB VPB VPWR Y
.ends

* Black-box entry subcircuit for sky130_fd_sc_hd__clkinvlp_2 abstract view
.subckt sky130_fd_sc_hd__clkinvlp_2 A VGND VNB VPB VPWR Y
.ends

* Black-box entry subcircuit for sky130_fd_sc_hd__o211a_4 abstract view
.subckt sky130_fd_sc_hd__o211a_4 A1 A2 B1 C1 VGND VNB VPB VPWR X
.ends

* Black-box entry subcircuit for sky130_fd_sc_hd__or2_4 abstract view
.subckt sky130_fd_sc_hd__or2_4 A B VGND VNB VPB VPWR X
.ends

* Black-box entry subcircuit for sky130_fd_sc_hd__clkinvlp_4 abstract view
.subckt sky130_fd_sc_hd__clkinvlp_4 A VGND VNB VPB VPWR Y
.ends

* Black-box entry subcircuit for sky130_fd_sc_hd__a21bo_1 abstract view
.subckt sky130_fd_sc_hd__a21bo_1 A1 A2 B1_N VGND VNB VPB VPWR X
.ends

* Black-box entry subcircuit for sky130_fd_sc_hd__o21ba_1 abstract view
.subckt sky130_fd_sc_hd__o21ba_1 A1 A2 B1_N VGND VNB VPB VPWR X
.ends

* Black-box entry subcircuit for sky130_fd_sc_hd__nand3_2 abstract view
.subckt sky130_fd_sc_hd__nand3_2 A B C VGND VNB VPB VPWR Y
.ends

* Black-box entry subcircuit for sky130_fd_sc_hd__o21a_2 abstract view
.subckt sky130_fd_sc_hd__o21a_2 A1 A2 B1 VGND VNB VPB VPWR X
.ends

* Black-box entry subcircuit for sky130_fd_sc_hd__o31ai_1 abstract view
.subckt sky130_fd_sc_hd__o31ai_1 A1 A2 A3 B1 VGND VNB VPB VPWR Y
.ends

* Black-box entry subcircuit for sky130_fd_sc_hd__clkinv_1 abstract view
.subckt sky130_fd_sc_hd__clkinv_1 A VGND VNB VPB VPWR Y
.ends

* Black-box entry subcircuit for sky130_fd_sc_hd__nand3_1 abstract view
.subckt sky130_fd_sc_hd__nand3_1 A B C VGND VNB VPB VPWR Y
.ends

* Black-box entry subcircuit for sky130_fd_sc_hd__or4_2 abstract view
.subckt sky130_fd_sc_hd__or4_2 A B C D VGND VNB VPB VPWR X
.ends

* Black-box entry subcircuit for sky130_fd_sc_hd__or3b_4 abstract view
.subckt sky130_fd_sc_hd__or3b_4 A B C_N VGND VNB VPB VPWR X
.ends

* Black-box entry subcircuit for sky130_fd_sc_hd__and2b_2 abstract view
.subckt sky130_fd_sc_hd__and2b_2 A_N B VGND VNB VPB VPWR X
.ends

* Black-box entry subcircuit for sky130_fd_sc_hd__a41o_1 abstract view
.subckt sky130_fd_sc_hd__a41o_1 A1 A2 A3 A4 B1 VGND VNB VPB VPWR X
.ends

* Black-box entry subcircuit for sky130_fd_sc_hd__nor2_4 abstract view
.subckt sky130_fd_sc_hd__nor2_4 A B VGND VNB VPB VPWR Y
.ends

* Black-box entry subcircuit for sky130_fd_sc_hd__and2_4 abstract view
.subckt sky130_fd_sc_hd__and2_4 A B VGND VNB VPB VPWR X
.ends

* Black-box entry subcircuit for sky130_fd_sc_hd__or4_4 abstract view
.subckt sky130_fd_sc_hd__or4_4 A B C D VGND VNB VPB VPWR X
.ends

* Black-box entry subcircuit for sky130_fd_sc_hd__a31o_2 abstract view
.subckt sky130_fd_sc_hd__a31o_2 A1 A2 A3 B1 VGND VNB VPB VPWR X
.ends

* Black-box entry subcircuit for sky130_fd_sc_hd__o211ai_2 abstract view
.subckt sky130_fd_sc_hd__o211ai_2 A1 A2 B1 C1 VGND VNB VPB VPWR Y
.ends

* Black-box entry subcircuit for sky130_fd_sc_hd__a2111o_1 abstract view
.subckt sky130_fd_sc_hd__a2111o_1 A1 A2 B1 C1 D1 VGND VNB VPB VPWR X
.ends

* Black-box entry subcircuit for sky130_fd_sc_hd__and3b_1 abstract view
.subckt sky130_fd_sc_hd__and3b_1 A_N B C VGND VNB VPB VPWR X
.ends

* Black-box entry subcircuit for sky130_fd_sc_hd__o32a_1 abstract view
.subckt sky130_fd_sc_hd__o32a_1 A1 A2 A3 B1 B2 VGND VNB VPB VPWR X
.ends

* Black-box entry subcircuit for sky130_fd_sc_hd__o22a_4 abstract view
.subckt sky130_fd_sc_hd__o22a_4 A1 A2 B1 B2 VGND VNB VPB VPWR X
.ends

* Black-box entry subcircuit for sky130_fd_sc_hd__o2bb2a_2 abstract view
.subckt sky130_fd_sc_hd__o2bb2a_2 A1_N A2_N B1 B2 VGND VNB VPB VPWR X
.ends

* Black-box entry subcircuit for sky130_fd_sc_hd__nand3b_1 abstract view
.subckt sky130_fd_sc_hd__nand3b_1 A_N B C VGND VNB VPB VPWR Y
.ends

* Black-box entry subcircuit for sky130_fd_sc_hd__o31ai_2 abstract view
.subckt sky130_fd_sc_hd__o31ai_2 A1 A2 A3 B1 VGND VNB VPB VPWR Y
.ends

* Black-box entry subcircuit for sky130_fd_sc_hd__a221o_1 abstract view
.subckt sky130_fd_sc_hd__a221o_1 A1 A2 B1 B2 C1 VGND VNB VPB VPWR X
.ends

* Black-box entry subcircuit for sky130_fd_sc_hd__a31oi_2 abstract view
.subckt sky130_fd_sc_hd__a31oi_2 A1 A2 A3 B1 VGND VNB VPB VPWR Y
.ends

* Black-box entry subcircuit for sky130_fd_sc_hd__a2bb2o_2 abstract view
.subckt sky130_fd_sc_hd__a2bb2o_2 A1_N A2_N B1 B2 VGND VNB VPB VPWR X
.ends

* Black-box entry subcircuit for sky130_fd_sc_hd__nand2b_2 abstract view
.subckt sky130_fd_sc_hd__nand2b_2 A_N B VGND VNB VPB VPWR Y
.ends

* Black-box entry subcircuit for sky130_fd_sc_hd__or4b_1 abstract view
.subckt sky130_fd_sc_hd__or4b_1 A B C D_N VGND VNB VPB VPWR X
.ends

* Black-box entry subcircuit for sky130_fd_sc_hd__o22ai_4 abstract view
.subckt sky130_fd_sc_hd__o22ai_4 A1 A2 B1 B2 VGND VNB VPB VPWR Y
.ends

* Black-box entry subcircuit for sky130_fd_sc_hd__and4b_1 abstract view
.subckt sky130_fd_sc_hd__and4b_1 A_N B C D VGND VNB VPB VPWR X
.ends

* Black-box entry subcircuit for sky130_fd_sc_hd__a311oi_1 abstract view
.subckt sky130_fd_sc_hd__a311oi_1 A1 A2 A3 B1 C1 VGND VNB VPB VPWR Y
.ends

* Black-box entry subcircuit for sky130_fd_sc_hd__a32o_2 abstract view
.subckt sky130_fd_sc_hd__a32o_2 A1 A2 A3 B1 B2 VGND VNB VPB VPWR X
.ends

* Black-box entry subcircuit for sky130_fd_sc_hd__o21bai_1 abstract view
.subckt sky130_fd_sc_hd__o21bai_1 A1 A2 B1_N VGND VNB VPB VPWR Y
.ends

* Black-box entry subcircuit for sky130_fd_sc_hd__nor3b_4 abstract view
.subckt sky130_fd_sc_hd__nor3b_4 A B C_N VGND VNB VPB VPWR Y
.ends

* Black-box entry subcircuit for sky130_fd_sc_hd__a22oi_2 abstract view
.subckt sky130_fd_sc_hd__a22oi_2 A1 A2 B1 B2 VGND VNB VPB VPWR Y
.ends

* Black-box entry subcircuit for sky130_fd_sc_hd__a31oi_1 abstract view
.subckt sky130_fd_sc_hd__a31oi_1 A1 A2 A3 B1 VGND VNB VPB VPWR Y
.ends

* Black-box entry subcircuit for sky130_fd_sc_hd__nand2b_4 abstract view
.subckt sky130_fd_sc_hd__nand2b_4 A_N B VGND VNB VPB VPWR Y
.ends

* Black-box entry subcircuit for sky130_fd_sc_hd__a211oi_1 abstract view
.subckt sky130_fd_sc_hd__a211oi_1 A1 A2 B1 C1 VGND VNB VPB VPWR Y
.ends

* Black-box entry subcircuit for sky130_fd_sc_hd__nor3_2 abstract view
.subckt sky130_fd_sc_hd__nor3_2 A B C VGND VNB VPB VPWR Y
.ends

* Black-box entry subcircuit for sky130_fd_sc_hd__o21bai_2 abstract view
.subckt sky130_fd_sc_hd__o21bai_2 A1 A2 B1_N VGND VNB VPB VPWR Y
.ends

* Black-box entry subcircuit for sky130_fd_sc_hd__conb_1 abstract view
.subckt sky130_fd_sc_hd__conb_1 VGND VNB VPB VPWR HI LO
.ends

* Black-box entry subcircuit for sky130_fd_sc_hd__o311a_1 abstract view
.subckt sky130_fd_sc_hd__o311a_1 A1 A2 A3 B1 C1 VGND VNB VPB VPWR X
.ends

* Black-box entry subcircuit for sky130_fd_sc_hd__a31oi_4 abstract view
.subckt sky130_fd_sc_hd__a31oi_4 A1 A2 A3 B1 VGND VNB VPB VPWR Y
.ends

* Black-box entry subcircuit for sky130_fd_sc_hd__or4b_2 abstract view
.subckt sky130_fd_sc_hd__or4b_2 A B C D_N VGND VNB VPB VPWR X
.ends

* Black-box entry subcircuit for sky130_fd_sc_hd__or4bb_1 abstract view
.subckt sky130_fd_sc_hd__or4bb_1 A B C_N D_N VGND VNB VPB VPWR X
.ends

* Black-box entry subcircuit for sky130_fd_sc_hd__nor2b_4 abstract view
.subckt sky130_fd_sc_hd__nor2b_4 A B_N VGND VNB VPB VPWR Y
.ends

* Black-box entry subcircuit for sky130_fd_sc_hd__or2b_2 abstract view
.subckt sky130_fd_sc_hd__or2b_2 A B_N VGND VNB VPB VPWR X
.ends

* Black-box entry subcircuit for sky130_fd_sc_hd__nor3_1 abstract view
.subckt sky130_fd_sc_hd__nor3_1 A B C VGND VNB VPB VPWR Y
.ends

* Black-box entry subcircuit for sky130_fd_sc_hd__a2111o_4 abstract view
.subckt sky130_fd_sc_hd__a2111o_4 A1 A2 B1 C1 D1 VGND VNB VPB VPWR X
.ends

* Black-box entry subcircuit for sky130_fd_sc_hd__or2b_4 abstract view
.subckt sky130_fd_sc_hd__or2b_4 A B_N VGND VNB VPB VPWR X
.ends

* Black-box entry subcircuit for sky130_fd_sc_hd__o22ai_1 abstract view
.subckt sky130_fd_sc_hd__o22ai_1 A1 A2 B1 B2 VGND VNB VPB VPWR Y
.ends

* Black-box entry subcircuit for sky130_fd_sc_hd__diode_2 abstract view
.subckt sky130_fd_sc_hd__diode_2 DIODE VGND VNB VPB VPWR
.ends

* Black-box entry subcircuit for sky130_fd_sc_hd__o21ba_4 abstract view
.subckt sky130_fd_sc_hd__o21ba_4 A1 A2 B1_N VGND VNB VPB VPWR X
.ends

* Black-box entry subcircuit for sky130_fd_sc_hd__o21ai_4 abstract view
.subckt sky130_fd_sc_hd__o21ai_4 A1 A2 B1 VGND VNB VPB VPWR Y
.ends

* Black-box entry subcircuit for sky130_fd_sc_hd__a21boi_2 abstract view
.subckt sky130_fd_sc_hd__a21boi_2 A1 A2 B1_N VGND VNB VPB VPWR Y
.ends

* Black-box entry subcircuit for sky130_fd_sc_hd__a211oi_2 abstract view
.subckt sky130_fd_sc_hd__a211oi_2 A1 A2 B1 C1 VGND VNB VPB VPWR Y
.ends

* Black-box entry subcircuit for sky130_fd_sc_hd__and4bb_1 abstract view
.subckt sky130_fd_sc_hd__and4bb_1 A_N B_N C D VGND VNB VPB VPWR X
.ends

.subckt DotProductUnit_E2M1_x_E2M1_scale_UE3M5 VGND VPWR clock io_accOut[0] io_accOut[10]
+ io_accOut[11] io_accOut[12] io_accOut[13] io_accOut[14] io_accOut[15] io_accOut[16]
+ io_accOut[17] io_accOut[18] io_accOut[19] io_accOut[1] io_accOut[20] io_accOut[21]
+ io_accOut[22] io_accOut[23] io_accOut[24] io_accOut[25] io_accOut[26] io_accOut[27]
+ io_accOut[28] io_accOut[29] io_accOut[2] io_accOut[30] io_accOut[31] io_accOut[3]
+ io_accOut[4] io_accOut[5] io_accOut[6] io_accOut[7] io_accOut[8] io_accOut[9] io_done
+ io_inA[0] io_inA[1] io_inA[2] io_inA[3] io_inB[0] io_inB[1] io_inB[2] io_inB[3]
+ io_inScaleA[0] io_inScaleA[1] io_inScaleA[2] io_inScaleA[3] io_inScaleA[4] io_inScaleA[5]
+ io_inScaleA[6] io_inScaleA[7] io_inScaleB[0] io_inScaleB[1] io_inScaleB[2] io_inScaleB[3]
+ io_inScaleB[4] io_inScaleB[5] io_inScaleB[6] io_inScaleB[7] io_resetAcc io_start
+ reset
Xaccumulator._2214_ accumulator._0103_ accumulator._0158_ accumulator._0384_ VGND
+ VGND VPWR VPWR accumulator._0168_ sky130_fd_sc_hd__o21a_1
Xaccumulator._1593_ accumulator.io_accOut\[5\] accumulator._0406_ accumulator._0418_
+ accumulator._0571_ VGND VGND VPWR VPWR accumulator._0688_ sky130_fd_sc_hd__and4_1
XFILLER_0_57_391 VGND VGND VPWR VPWR sky130_fd_sc_hd__fill_1
Xaccumulator._2145_ accumulator._0092_ accumulator._1147_ accumulator._1171_ VGND
+ VGND VPWR VPWR accumulator._0100_ sky130_fd_sc_hd__mux2_2
Xaccumulator._2076_ accumulator._0947_ accumulator._1152_ accumulator._1154_ VGND
+ VGND VPWR VPWR accumulator._1173_ sky130_fd_sc_hd__a21oi_1
XFILLER_0_43_70 VGND VGND VPWR VPWR sky130_fd_sc_hd__decap_8
XFILLER_0_17_200 VGND VGND VPWR VPWR sky130_fd_sc_hd__fill_1
XFILLER_0_17_233 VGND VGND VPWR VPWR sky130_fd_sc_hd__decap_3
XFILLER_0_17_255 VPWR VGND VPWR VGND sky130_ef_sc_hd__decap_12
Xaccumulator._1929_ accumulator._1022_ accumulator._1023_ VGND VGND VPWR VPWR accumulator._1024_
+ sky130_fd_sc_hd__and2_1
XFILLER_0_7_81 VGND VGND VPWR VPWR sky130_fd_sc_hd__fill_1
XTAP_TAPCELL_ROW_43_448 VGND VPWR sky130_fd_sc_hd__tapvpwrvgnd_1
XFILLER_0_63_361 VPWR VGND VPWR VGND sky130_ef_sc_hd__decap_12
XFILLER_0_23_225 VGND VGND VPWR VPWR sky130_fd_sc_hd__decap_8
Xrebuffer7 net67 VGND VGND VPWR VPWR net65 sky130_fd_sc_hd__clkbuf_1
XFILLER_0_3_39 VPWR VGND VPWR VGND sky130_ef_sc_hd__decap_12
XFILLER_0_58_188 VGND VGND VPWR VPWR sky130_fd_sc_hd__fill_1
XFILLER_0_58_166 VGND VGND VPWR VPWR sky130_fd_sc_hd__fill_1
XFILLER_0_58_122 VGND VGND VPWR VPWR sky130_fd_sc_hd__decap_6
XFILLER_0_46_328 VPWR VGND VPWR VGND sky130_ef_sc_hd__decap_12
XFILLER_0_13_51 VGND VGND VPWR VPWR sky130_fd_sc_hd__decap_4
Xaccumulator._1714_ accumulator._0804_ accumulator._0805_ accumulator._0806_ accumulator._0808_
+ VGND VGND VPWR VPWR accumulator._0809_ sky130_fd_sc_hd__o22a_1
Xaccumulator._1645_ accumulator.io_accOut\[0\] accumulator._0378_ VGND VGND VPWR VPWR
+ accumulator._0740_ sky130_fd_sc_hd__nand2_1
Xaccumulator._1576_ accumulator.io_accOut\[6\] accumulator._0387_ accumulator._0571_
+ accumulator._0473_ VGND VGND VPWR VPWR accumulator._0671_ sky130_fd_sc_hd__a31o_1
XFILLER_0_49_111 VGND VGND VPWR VPWR sky130_fd_sc_hd__fill_1
XFILLER_0_52_309 VPWR VGND VPWR VGND sky130_ef_sc_hd__decap_12
Xaccumulator._2059_ accumulator._0946_ accumulator._1152_ accumulator._1134_ accumulator._1140_
+ accumulator._1154_ VGND VGND VPWR VPWR accumulator._1155_ sky130_fd_sc_hd__a221oi_2
XFILLER_0_45_350 VPWR VGND VPWR VGND sky130_ef_sc_hd__decap_12
Xaccumulator._2128_ accumulator._0807_ accumulator._0384_ accumulator._0062_ accumulator._0083_
+ VGND VGND VPWR VPWR accumulator._0084_ sky130_fd_sc_hd__o22a_1
XTAP_TAPCELL_ROW_40_429 VGND VPWR sky130_fd_sc_hd__tapvpwrvgnd_1
XFILLER_0_20_239 VGND VGND VPWR VPWR sky130_fd_sc_hd__decap_6
XTAP_TAPCELL_ROW_56_540 VGND VPWR sky130_fd_sc_hd__tapvpwrvgnd_1
XTAP_TAPCELL_ROW_5_184 VGND VPWR sky130_fd_sc_hd__tapvpwrvgnd_1
XFILLER_0_18_29 VPWR VGND VPWR VGND sky130_ef_sc_hd__decap_12
XFILLER_0_50_27 VGND VGND VPWR VPWR sky130_fd_sc_hd__fill_1
XFILLER_0_55_169 VGND VGND VPWR VPWR sky130_fd_sc_hd__decap_8
XFILLER_0_51_353 VPWR VGND VPWR VGND sky130_ef_sc_hd__decap_12
XFILLER_0_36_361 VGND VGND VPWR VPWR sky130_fd_sc_hd__decap_3
Xaccumulator._1430_ accumulator._0457_ accumulator._0426_ accumulator._0519_ accumulator._0524_
+ VGND VGND VPWR VPWR accumulator._0525_ sky130_fd_sc_hd__a31o_1
Xaccumulator._1292_ accumulator._0388_ VGND VGND VPWR VPWR accumulator._0389_ sky130_fd_sc_hd__clkbuf_4
Xaccumulator._1361_ accumulator.io_accOut\[18\] accumulator._0455_ accumulator._0377_
+ VGND VGND VPWR VPWR accumulator._0456_ sky130_fd_sc_hd__mux2_2
XFILLER_0_24_72 VPWR VGND VPWR VGND sky130_ef_sc_hd__decap_12
XFILLER_0_6_277 VGND VGND VPWR VPWR sky130_fd_sc_hd__decap_4
XFILLER_0_49_91 VPWR VGND VPWR VGND sky130_ef_sc_hd__decap_12
Xaccumulator._1628_ accumulator._0421_ accumulator._0641_ accumulator._0673_ accumulator._0554_
+ VGND VGND VPWR VPWR accumulator._0723_ sky130_fd_sc_hd__o211ai_1
Xaccumulator._1559_ accumulator.io_accOut\[6\] accumulator._0406_ accumulator._0414_
+ accumulator._0571_ VGND VGND VPWR VPWR accumulator._0654_ sky130_fd_sc_hd__and4_1
Xoperator._17_ net6 net7 VGND VGND VPWR VPWR operator._03_ sky130_fd_sc_hd__and2b_1
XFILLER_0_60_183 VPWR VGND VPWR VGND sky130_ef_sc_hd__decap_12
XFILLER_0_37_169 VGND VGND VPWR VPWR sky130_fd_sc_hd__decap_8
XFILLER_0_33_353 VPWR VGND VPWR VGND sky130_ef_sc_hd__decap_12
XscaleAdd._280_ net16 net15 net14 net9 VGND VGND VPWR VPWR scaleAdd._222_ sky130_fd_sc_hd__o31a_1
XFILLER_0_61_15 VPWR VGND VPWR VGND sky130_ef_sc_hd__decap_12
XFILLER_0_45_27 VGND VGND VPWR VPWR sky130_fd_sc_hd__decap_6
XFILLER_0_0_29 VPWR VGND VPWR VGND sky130_ef_sc_hd__decap_12
XFILLER_0_9_27 VPWR VGND VPWR VGND sky130_ef_sc_hd__decap_12
XTAP_TAPCELL_ROW_16_256 VGND VPWR sky130_fd_sc_hd__tapvpwrvgnd_1
XFILLER_0_16_309 VGND VGND VPWR VPWR sky130_fd_sc_hd__fill_1
XFILLER_0_3_225 VGND VGND VPWR VPWR sky130_fd_sc_hd__decap_8
XFILLER_0_10_41 VPWR VGND VPWR VGND sky130_ef_sc_hd__decap_12
XFILLER_0_10_85 VPWR VGND VPWR VGND sky130_ef_sc_hd__decap_12
XTAP_TAPCELL_ROW_67_624 VGND VPWR sky130_fd_sc_hd__tapvpwrvgnd_1
XTAP_TAPCELL_ROW_67_613 VGND VPWR sky130_fd_sc_hd__tapvpwrvgnd_1
XFILLER_0_43_7 VGND VGND VPWR VPWR sky130_fd_sc_hd__fill_1
Xaccumulator._1413_ accumulator.io_accOut\[14\] accumulator._0507_ accumulator._0377_
+ VGND VGND VPWR VPWR accumulator._0508_ sky130_fd_sc_hd__mux2_4
XscaleAdd._478_ scaleAdd._167_ VGND VGND VPWR VPWR scaleAdd._172_ sky130_fd_sc_hd__inv_2
XFILLER_0_19_61 VGND VGND VPWR VPWR sky130_fd_sc_hd__decap_6
Xaccumulator._1275_ accumulator._0371_ accumulator.io_accOut\[29\] VGND VGND VPWR
+ VPWR accumulator._0372_ sky130_fd_sc_hd__and2b_1
Xaccumulator._1344_ accumulator._0435_ accumulator._0438_ accumulator._0427_ VGND
+ VGND VPWR VPWR accumulator._0439_ sky130_fd_sc_hd__mux2_1
XFILLER_0_19_147 VGND VGND VPWR VPWR sky130_fd_sc_hd__fill_1
XFILLER_0_34_106 VGND VGND VPWR VPWR sky130_fd_sc_hd__decap_8
XFILLER_0_15_364 VPWR VGND VPWR VGND sky130_ef_sc_hd__decap_12
XFILLER_0_30_334 VPWR VGND VPWR VGND sky130_ef_sc_hd__decap_12
XTAP_TAPCELL_ROW_13_237 VGND VPWR sky130_fd_sc_hd__tapvpwrvgnd_1
XscaleAdd._401_ scaleAdd._190_ scaleAdd._092_ VGND VGND VPWR VPWR scaleAdd._104_ sky130_fd_sc_hd__nand2_1
XTAP_TAPCELL_ROW_21_292 VGND VPWR sky130_fd_sc_hd__tapvpwrvgnd_1
XFILLER_0_0_217 VGND VGND VPWR VPWR sky130_fd_sc_hd__decap_3
XFILLER_0_0_239 VGND VGND VPWR VPWR sky130_fd_sc_hd__fill_2
XFILLER_0_18_191 VGND VGND VPWR VPWR sky130_fd_sc_hd__decap_4
XscaleAdd._332_ scaleAdd._035_ scaleAdd._036_ scaleAdd._037_ VGND VGND VPWR VPWR scaleAdd._039_
+ sky130_fd_sc_hd__a21o_1
XFILLER_0_56_15 VPWR VGND VPWR VGND sky130_ef_sc_hd__decap_12
XscaleAdd._263_ scaleAdd._185_ scaleAdd._192_ scaleAdd._182_ scaleAdd._205_ VGND VGND
+ VPWR VPWR scaleAdd._206_ sky130_fd_sc_hd__a31o_1
XFILLER_0_56_231 VPWR VGND VPWR VGND sky130_ef_sc_hd__decap_12
XFILLER_0_48_209 VGND VGND VPWR VPWR sky130_fd_sc_hd__decap_4
XPHY_EDGE_ROW_28_Left_96 VGND VGND VPWR VPWR sky130_fd_sc_hd__decap_3
XFILLER_0_8_317 VGND VGND VPWR VPWR sky130_fd_sc_hd__fill_2
XFILLER_0_56_275 VPWR VGND VPWR VGND sky130_ef_sc_hd__decap_12
XFILLER_0_56_253 VPWR VGND VPWR VGND sky130_ef_sc_hd__decap_12
Xaccumulator._1962_ accumulator._0891_ accumulator._1056_ VGND VGND VPWR VPWR accumulator._1057_
+ sky130_fd_sc_hd__xnor2_4
XFILLER_0_31_109 VGND VGND VPWR VPWR sky130_fd_sc_hd__decap_3
XFILLER_0_16_139 VGND VGND VPWR VPWR sky130_fd_sc_hd__fill_1
XFILLER_0_21_51 VGND VGND VPWR VPWR sky130_fd_sc_hd__decap_4
XFILLER_0_21_84 VGND VGND VPWR VPWR sky130_fd_sc_hd__decap_4
Xaccumulator._1893_ accumulator._0978_ accumulator._0983_ accumulator._0987_ VGND
+ VGND VPWR VPWR accumulator._0988_ sky130_fd_sc_hd__and3_1
XFILLER_0_12_345 VPWR VGND VPWR VGND sky130_ef_sc_hd__decap_12
XFILLER_0_46_70 VPWR VGND VPWR VGND sky130_ef_sc_hd__decap_12
Xaccumulator._2376_ clknet_2_1__leaf_clock accumulator._0021_ VGND VGND VPWR VPWR
+ accumulator.io_accOut\[19\] sky130_fd_sc_hd__dfxtp_1
Xaccumulator._1327_ accumulator._0369_ accumulator._0374_ VGND VGND VPWR VPWR accumulator._0422_
+ sky130_fd_sc_hd__xor2_2
XFILLER_0_62_91 VGND VGND VPWR VPWR sky130_fd_sc_hd__fill_1
XFILLER_0_47_297 VGND VGND VPWR VPWR sky130_fd_sc_hd__decap_4
Xaccumulator._1258_ accumulator.io_accOut\[25\] accumulator._0346_ VGND VGND VPWR
+ VPWR accumulator._0355_ sky130_fd_sc_hd__and2_1
Xaccumulator._1189_ accumulator._0095_ accumulator._0115_ VGND VGND VPWR VPWR accumulator._0125_
+ sky130_fd_sc_hd__nor2_1
XFILLER_0_62_289 VPWR VGND VPWR VGND sky130_ef_sc_hd__decap_12
XFILLER_0_30_164 VPWR VGND VPWR VGND sky130_ef_sc_hd__decap_12
XFILLER_0_30_153 VGND VGND VPWR VPWR sky130_fd_sc_hd__decap_4
XTAP_TAPCELL_ROW_10_218 VGND VPWR sky130_fd_sc_hd__tapvpwrvgnd_1
Xhold52 accumulator.io_accOut\[14\] VGND VGND VPWR VPWR net110 sky130_fd_sc_hd__dlygate4sd3_1
XFILLER_0_30_197 VGND VGND VPWR VPWR sky130_fd_sc_hd__fill_1
XFILLER_0_38_286 VPWR VGND VPWR VGND sky130_ef_sc_hd__decap_12
XFILLER_0_38_253 VGND VGND VPWR VPWR sky130_fd_sc_hd__decap_8
XFILLER_0_67_69 VPWR VGND VPWR VGND sky130_ef_sc_hd__decap_12
XFILLER_0_21_186 VPWR VGND VPWR VGND sky130_ef_sc_hd__decap_12
XscaleAdd._315_ scaleAdd._013_ scaleAdd._014_ scaleAdd._021_ VGND VGND VPWR VPWR scaleAdd._022_
+ sky130_fd_sc_hd__mux2_4
XFILLER_0_21_120 VPWR VGND VPWR VGND sky130_ef_sc_hd__decap_12
Xaccumulator._2230_ accumulator._1176_ accumulator._1142_ net101 VGND VGND VPWR VPWR
+ accumulator._0184_ sky130_fd_sc_hd__mux2_1
XTAP_TAPCELL_ROW_49_487 VGND VPWR sky130_fd_sc_hd__tapvpwrvgnd_1
Xrebuffer39 scaleAdd._145_ VGND VGND VPWR VPWR net97 sky130_fd_sc_hd__dlymetal6s2s_1
Xrebuffer28 accumulator._0055_ VGND VGND VPWR VPWR net86 sky130_fd_sc_hd__clkbuf_2
XscaleAdd._246_ operator.io_outMant\[2\] VGND VGND VPWR VPWR scaleAdd._191_ sky130_fd_sc_hd__buf_2
Xrebuffer17 net74 VGND VGND VPWR VPWR net75 sky130_fd_sc_hd__dlygate4sd1_1
Xaccumulator._2092_ net56 accumulator._0044_ accumulator._0047_ VGND VGND VPWR VPWR
+ accumulator._0048_ sky130_fd_sc_hd__and3_1
Xaccumulator._2161_ accumulator._0107_ accumulator._0077_ accumulator._0116_ accumulator._0034_
+ accumulator.io_accOut\[7\] VGND VGND VPWR VPWR accumulator._0117_ sky130_fd_sc_hd__a32o_1
XFILLER_0_8_158 VGND VGND VPWR VPWR sky130_fd_sc_hd__decap_4
Xaccumulator._1945_ accumulator._0857_ accumulator._0868_ accumulator._0872_ VGND
+ VGND VPWR VPWR accumulator._1040_ sky130_fd_sc_hd__and3_1
XFILLER_0_4_353 VGND VGND VPWR VPWR sky130_fd_sc_hd__decap_8
XFILLER_0_12_131 VGND VGND VPWR VPWR sky130_fd_sc_hd__fill_1
Xaccumulator._1876_ accumulator._0534_ accumulator._0797_ accumulator._0969_ accumulator._0970_
+ VGND VGND VPWR VPWR accumulator._0971_ sky130_fd_sc_hd__a31o_1
XFILLER_0_12_197 VGND VGND VPWR VPWR sky130_fd_sc_hd__decap_4
XFILLER_0_67_337 VPWR VGND VPWR VGND sky130_ef_sc_hd__decap_12
Xaccumulator._2359_ clknet_2_3__leaf_clock accumulator._0004_ VGND VGND VPWR VPWR
+ accumulator.io_accOut\[2\] sky130_fd_sc_hd__dfxtp_2
XTAP_TAPCELL_ROW_23_310 VGND VPWR sky130_fd_sc_hd__tapvpwrvgnd_1
XFILLER_0_7_191 VPWR VGND VPWR VGND sky130_ef_sc_hd__decap_12
Xoutput53 net53 VGND VGND VPWR VPWR io_accOut[8] sky130_fd_sc_hd__clkbuf_4
Xoutput42 net42 VGND VGND VPWR VPWR io_accOut[27] sky130_fd_sc_hd__buf_2
Xoutput31 net31 VGND VGND VPWR VPWR io_accOut[17] sky130_fd_sc_hd__buf_2
XFILLER_0_53_27 VGND VGND VPWR VPWR sky130_fd_sc_hd__decap_3
XFILLER_0_37_17 VGND VGND VPWR VPWR sky130_fd_sc_hd__fill_1
XTAP_TAPCELL_ROW_46_468 VGND VPWR sky130_fd_sc_hd__tapvpwrvgnd_1
XFILLER_0_26_201 VGND VGND VPWR VPWR sky130_fd_sc_hd__decap_8
Xaccumulator._1730_ accumulator._0514_ accumulator._0563_ accumulator._0725_ VGND
+ VGND VPWR VPWR accumulator._0825_ sky130_fd_sc_hd__and3_1
Xaccumulator._1661_ accumulator._0754_ accumulator._0755_ VGND VGND VPWR VPWR accumulator._0756_
+ sky130_fd_sc_hd__or2_2
Xaccumulator._1592_ accumulator.io_accOut\[4\] accumulator._0406_ accumulator._0414_
+ accumulator._0571_ VGND VGND VPWR VPWR accumulator._0687_ sky130_fd_sc_hd__and4_1
XFILLER_0_49_337 VPWR VGND VPWR VGND sky130_ef_sc_hd__decap_12
Xaccumulator._2213_ net113 accumulator._0147_ accumulator._0161_ accumulator._0167_
+ accumulator._0118_ VGND VGND VPWR VPWR accumulator._0015_ sky130_fd_sc_hd__o221a_1
Xaccumulator._2144_ accumulator._0074_ accumulator._0099_ VGND VGND VPWR VPWR accumulator._0007_
+ sky130_fd_sc_hd__nor2_1
XTAP_TAPCELL_ROW_37_402 VGND VPWR sky130_fd_sc_hd__tapvpwrvgnd_1
XFILLER_0_64_307 VGND VGND VPWR VPWR sky130_fd_sc_hd__fill_1
Xaccumulator._2075_ accumulator._1135_ accumulator._1140_ accumulator._1171_ VGND
+ VGND VPWR VPWR accumulator._1172_ sky130_fd_sc_hd__mux2_2
XFILLER_0_17_267 VGND VGND VPWR VPWR sky130_fd_sc_hd__decap_3
XFILLER_0_17_289 VPWR VGND VPWR VGND sky130_ef_sc_hd__decap_12
Xaccumulator._1928_ accumulator._0852_ accumulator._1016_ accumulator._1004_ VGND
+ VGND VPWR VPWR accumulator._1023_ sky130_fd_sc_hd__or3b_1
Xaccumulator._1859_ accumulator._0721_ accumulator._0953_ VGND VGND VPWR VPWR accumulator._0954_
+ sky130_fd_sc_hd__xor2_1
XPHY_EDGE_ROW_15_Left_83 VGND VGND VPWR VPWR sky130_fd_sc_hd__decap_3
XTAP_TAPCELL_ROW_43_449 VGND VPWR sky130_fd_sc_hd__tapvpwrvgnd_1
XFILLER_0_63_373 VPWR VGND VPWR VGND sky130_ef_sc_hd__decap_12
XFILLER_0_2_109 VPWR VGND VPWR VGND sky130_ef_sc_hd__decap_12
Xrebuffer8 net68 VGND VGND VPWR VPWR net66 sky130_fd_sc_hd__clkbuf_1
XFILLER_0_48_27 VGND VGND VPWR VPWR sky130_fd_sc_hd__fill_1
XFILLER_0_31_281 VPWR VGND VPWR VGND sky130_ef_sc_hd__decap_12
XFILLER_0_64_59 VGND VGND VPWR VPWR sky130_fd_sc_hd__fill_1
XFILLER_0_64_15 VPWR VGND VPWR VGND sky130_ef_sc_hd__decap_12
XTAP_TAPCELL_ROW_59_560 VGND VPWR sky130_fd_sc_hd__tapvpwrvgnd_1
XFILLER_0_14_204 VGND VGND VPWR VPWR sky130_fd_sc_hd__fill_2
Xaccumulator._1713_ accumulator._0807_ accumulator._0388_ accumulator._0704_ VGND
+ VGND VPWR VPWR accumulator._0808_ sky130_fd_sc_hd__or3b_1
Xaccumulator._1644_ accumulator._0412_ accumulator._0623_ accumulator._0628_ accumulator._0738_
+ accumulator._0410_ VGND VGND VPWR VPWR accumulator._0739_ sky130_fd_sc_hd__o311ai_4
Xaccumulator._1575_ accumulator._0608_ accumulator._0668_ accumulator._0669_ VGND
+ VGND VPWR VPWR accumulator._0670_ sky130_fd_sc_hd__a21oi_1
XFILLER_0_64_126 VGND VGND VPWR VPWR sky130_fd_sc_hd__decap_4
Xaccumulator._2127_ accumulator._0077_ accumulator._0060_ accumulator._0082_ VGND
+ VGND VPWR VPWR accumulator._0083_ sky130_fd_sc_hd__a21oi_2
XFILLER_0_49_167 VGND VGND VPWR VPWR sky130_fd_sc_hd__fill_1
XFILLER_0_37_307 VGND VGND VPWR VPWR sky130_fd_sc_hd__fill_2
XFILLER_0_60_365 VPWR VGND VPWR VGND sky130_ef_sc_hd__decap_12
XFILLER_0_60_321 VPWR VGND VPWR VGND sky130_ef_sc_hd__decap_12
Xaccumulator._2058_ accumulator._0831_ accumulator._1022_ accumulator._1153_ VGND
+ VGND VPWR VPWR accumulator._1154_ sky130_fd_sc_hd__and3_1
XFILLER_0_45_362 VPWR VGND VPWR VGND sky130_ef_sc_hd__decap_12
XFILLER_0_9_286 VPWR VGND VPWR VGND sky130_ef_sc_hd__decap_12
XPHY_EDGE_ROW_0_Left_68 VGND VGND VPWR VPWR sky130_fd_sc_hd__decap_3
XTAP_TAPCELL_ROW_56_541 VGND VPWR sky130_fd_sc_hd__tapvpwrvgnd_1
XFILLER_0_28_329 VGND VGND VPWR VPWR sky130_fd_sc_hd__fill_2
XFILLER_0_28_307 VGND VGND VPWR VPWR sky130_fd_sc_hd__fill_1
XFILLER_0_59_15 VPWR VGND VPWR VGND sky130_ef_sc_hd__decap_12
XFILLER_0_51_365 VPWR VGND VPWR VGND sky130_ef_sc_hd__decap_12
XFILLER_0_11_229 VGND VGND VPWR VPWR sky130_fd_sc_hd__fill_1
Xaccumulator._1360_ accumulator._0427_ accumulator._0335_ accumulator._0447_ accumulator._0454_
+ VGND VGND VPWR VPWR accumulator._0455_ sky130_fd_sc_hd__a31o_1
Xaccumulator._1291_ accumulator._0387_ VGND VGND VPWR VPWR accumulator._0388_ sky130_fd_sc_hd__buf_2
XTAP_TAPCELL_ROW_19_276 VGND VPWR sky130_fd_sc_hd__tapvpwrvgnd_1
XTAP_TAPCELL_ROW_62_577 VGND VPWR sky130_fd_sc_hd__tapvpwrvgnd_1
XFILLER_0_54_170 VPWR VGND VPWR VGND sky130_ef_sc_hd__decap_12
XFILLER_0_46_126 VPWR VGND VPWR VGND sky130_ef_sc_hd__decap_12
XFILLER_0_42_365 VPWR VGND VPWR VGND sky130_ef_sc_hd__decap_12
XFILLER_0_27_362 VGND VGND VPWR VPWR sky130_fd_sc_hd__fill_2
XFILLER_0_64_3 VPWR VGND VPWR VGND sky130_ef_sc_hd__decap_12
XPHY_EDGE_ROW_12_Right_12 VGND VGND VPWR VPWR sky130_fd_sc_hd__decap_3
Xaccumulator._1489_ accumulator._0581_ accumulator._0582_ VGND VGND VPWR VPWR accumulator._0584_
+ sky130_fd_sc_hd__and2_1
Xaccumulator._1627_ accumulator._0604_ accumulator._0637_ VGND VGND VPWR VPWR accumulator._0722_
+ sky130_fd_sc_hd__or2_1
XPHY_EDGE_ROW_21_Right_21 VGND VGND VPWR VPWR sky130_fd_sc_hd__decap_3
XFILLER_0_4_83 VGND VGND VPWR VPWR sky130_fd_sc_hd__fill_1
Xoperator._16_ net2 net3 net7 net6 VGND VGND VPWR VPWR operator._02_ sky130_fd_sc_hd__a22oi_1
Xaccumulator._1558_ accumulator._0386_ accumulator._0424_ VGND VGND VPWR VPWR accumulator._0653_
+ sky130_fd_sc_hd__and2_1
XFILLER_0_60_195 VGND VGND VPWR VPWR sky130_fd_sc_hd__fill_1
XFILLER_0_45_192 VGND VGND VPWR VPWR sky130_fd_sc_hd__decap_4
XPHY_EDGE_ROW_36_Left_104 VGND VGND VPWR VPWR sky130_fd_sc_hd__decap_3
XFILLER_0_33_365 VGND VGND VPWR VPWR sky130_fd_sc_hd__fill_1
XPHY_EDGE_ROW_30_Right_30 VGND VGND VPWR VPWR sky130_fd_sc_hd__decap_3
XPHY_EDGE_ROW_45_Left_113 VGND VGND VPWR VPWR sky130_fd_sc_hd__decap_3
XFILLER_0_61_27 VPWR VGND VPWR VGND sky130_ef_sc_hd__decap_12
XTAP_TAPCELL_ROW_16_257 VGND VPWR sky130_fd_sc_hd__tapvpwrvgnd_1
XPHY_EDGE_ROW_54_Left_122 VGND VGND VPWR VPWR sky130_fd_sc_hd__decap_3
XFILLER_0_24_321 VGND VGND VPWR VPWR sky130_fd_sc_hd__decap_6
XFILLER_0_9_39 VPWR VGND VPWR VGND sky130_ef_sc_hd__decap_12
XPHY_EDGE_ROW_63_Left_131 VGND VGND VPWR VPWR sky130_fd_sc_hd__decap_3
XFILLER_0_51_184 VGND VGND VPWR VPWR sky130_fd_sc_hd__fill_1
XFILLER_0_51_162 VGND VGND VPWR VPWR sky130_fd_sc_hd__decap_6
XFILLER_0_24_387 VGND VGND VPWR VPWR sky130_fd_sc_hd__fill_1
XFILLER_0_24_365 VGND VGND VPWR VPWR sky130_fd_sc_hd__decap_8
XscaleAdd._477_ scaleAdd._170_ scaleAdd._171_ VGND VGND VPWR VPWR accumulator.io_inExp\[2\]
+ sky130_fd_sc_hd__nor2_1
XFILLER_0_10_53 VPWR VGND VPWR VGND sky130_ef_sc_hd__decap_12
XFILLER_0_10_97 VPWR VGND VPWR VGND sky130_ef_sc_hd__decap_12
XTAP_TAPCELL_ROW_67_625 VGND VPWR sky130_fd_sc_hd__tapvpwrvgnd_1
XTAP_TAPCELL_ROW_67_614 VGND VPWR sky130_fd_sc_hd__tapvpwrvgnd_1
XFILLER_0_36_7 VGND VGND VPWR VPWR sky130_fd_sc_hd__fill_1
Xaccumulator._1343_ accumulator._0436_ accumulator._0437_ accumulator._0431_ VGND
+ VGND VPWR VPWR accumulator._0438_ sky130_fd_sc_hd__mux2_1
Xaccumulator._1412_ accumulator._0105_ accumulator._0506_ VGND VGND VPWR VPWR accumulator._0507_
+ sky130_fd_sc_hd__and2_1
XFILLER_0_19_84 VGND VGND VPWR VPWR sky130_fd_sc_hd__fill_1
XFILLER_0_59_262 VGND VGND VPWR VPWR sky130_fd_sc_hd__decap_6
XFILLER_0_59_240 VGND VGND VPWR VPWR sky130_fd_sc_hd__fill_1
Xaccumulator._1274_ accumulator._0340_ accumulator._0370_ VGND VGND VPWR VPWR accumulator._0371_
+ sky130_fd_sc_hd__and2b_1
XFILLER_0_30_346 VGND VGND VPWR VPWR sky130_fd_sc_hd__fill_1
XFILLER_0_27_181 VGND VGND VPWR VPWR sky130_fd_sc_hd__fill_2
XTAP_TAPCELL_ROW_13_238 VGND VPWR sky130_fd_sc_hd__tapvpwrvgnd_1
XFILLER_0_18_170 VGND VGND VPWR VPWR sky130_fd_sc_hd__decap_8
XscaleAdd._400_ scaleAdd._102_ scaleAdd._103_ VGND VGND VPWR VPWR accumulator.io_inMant\[10\]
+ sky130_fd_sc_hd__xor2_2
XFILLER_0_21_335 VGND VGND VPWR VPWR sky130_fd_sc_hd__fill_1
XTAP_TAPCELL_ROW_21_293 VGND VPWR sky130_fd_sc_hd__tapvpwrvgnd_1
XscaleAdd._331_ scaleAdd._035_ scaleAdd._036_ scaleAdd._037_ VGND VGND VPWR VPWR scaleAdd._038_
+ sky130_fd_sc_hd__and3_1
XFILLER_0_56_27 VGND VGND VPWR VPWR sky130_fd_sc_hd__fill_1
XPHY_EDGE_ROW_3_Left_71 VGND VGND VPWR VPWR sky130_fd_sc_hd__decap_3
XscaleAdd._262_ scaleAdd._182_ scaleAdd._193_ VGND VGND VPWR VPWR scaleAdd._205_ sky130_fd_sc_hd__nor2_1
XFILLER_0_56_265 VGND VGND VPWR VPWR sky130_fd_sc_hd__decap_6
XFILLER_0_56_243 VGND VGND VPWR VPWR sky130_fd_sc_hd__decap_3
XFILLER_0_56_287 VPWR VGND VPWR VGND sky130_ef_sc_hd__decap_12
Xaccumulator._1892_ accumulator._0752_ accumulator._0986_ VGND VGND VPWR VPWR accumulator._0987_
+ sky130_fd_sc_hd__xnor2_2
Xaccumulator._1961_ accumulator._0919_ accumulator._1053_ accumulator._1055_ VGND
+ VGND VPWR VPWR accumulator._1056_ sky130_fd_sc_hd__a21o_1
XFILLER_0_24_195 VGND VGND VPWR VPWR sky130_fd_sc_hd__fill_1
XFILLER_0_12_357 VGND VGND VPWR VPWR sky130_fd_sc_hd__decap_6
XFILLER_0_46_82 VGND VGND VPWR VPWR sky130_fd_sc_hd__fill_2
Xaccumulator._2375_ clknet_2_0__leaf_clock accumulator._0020_ VGND VGND VPWR VPWR
+ accumulator.io_accOut\[18\] sky130_fd_sc_hd__dfxtp_1
XFILLER_0_27_3 VGND VGND VPWR VPWR sky130_fd_sc_hd__decap_4
XFILLER_0_1_51 VGND VGND VPWR VPWR sky130_fd_sc_hd__decap_4
Xaccumulator._1326_ accumulator._0420_ VGND VGND VPWR VPWR accumulator._0421_ sky130_fd_sc_hd__clkbuf_4
XFILLER_0_62_224 VPWR VGND VPWR VGND sky130_ef_sc_hd__decap_12
XFILLER_0_7_351 VGND VGND VPWR VPWR sky130_fd_sc_hd__fill_2
XFILLER_0_7_384 VGND VGND VPWR VPWR sky130_fd_sc_hd__fill_1
XTAP_TAPCELL_ROW_10_219 VGND VPWR sky130_fd_sc_hd__tapvpwrvgnd_1
Xaccumulator._1188_ accumulator.io_inExp\[4\] accumulator._0105_ VGND VGND VPWR VPWR
+ accumulator._0115_ sky130_fd_sc_hd__nor2_1
Xaccumulator._1257_ accumulator._0352_ accumulator._0349_ accumulator._0353_ VGND
+ VGND VPWR VPWR accumulator._0354_ sky130_fd_sc_hd__a21o_4
XFILLER_0_30_176 VGND VGND VPWR VPWR sky130_fd_sc_hd__fill_2
XFILLER_0_15_173 VGND VGND VPWR VPWR sky130_fd_sc_hd__fill_1
Xhold53 accumulator.io_accOut\[27\] VGND VGND VPWR VPWR net111 sky130_fd_sc_hd__dlygate4sd3_1
XFILLER_0_42_29 VGND VGND VPWR VPWR sky130_fd_sc_hd__decap_3
XTAP_TAPCELL_ROW_26_330 VGND VPWR sky130_fd_sc_hd__tapvpwrvgnd_1
XFILLER_0_53_268 VGND VGND VPWR VPWR sky130_fd_sc_hd__fill_1
XFILLER_0_38_298 VGND VGND VPWR VPWR sky130_fd_sc_hd__decap_8
XFILLER_0_67_15 VPWR VGND VPWR VGND sky130_ef_sc_hd__decap_12
XscaleAdd._314_ scaleAdd._020_ scaleAdd._017_ VGND VGND VPWR VPWR scaleAdd._021_ sky130_fd_sc_hd__xnor2_2
XFILLER_0_6_29 VPWR VGND VPWR VGND sky130_ef_sc_hd__decap_12
XscaleAdd._245_ scaleAdd._187_ scaleAdd._188_ scaleAdd._189_ scaleAdd._190_ VGND VGND
+ VPWR VPWR accumulator.io_inMant\[3\] sky130_fd_sc_hd__a2bb2o_1
Xaccumulator._2160_ accumulator._0114_ VGND VGND VPWR VPWR accumulator._0116_ sky130_fd_sc_hd__inv_2
XTAP_TAPCELL_ROW_49_488 VGND VPWR sky130_fd_sc_hd__tapvpwrvgnd_1
Xrebuffer18 scaleAdd._088_ VGND VGND VPWR VPWR net76 sky130_fd_sc_hd__dlygate4sd1_1
Xrebuffer29 net86 VGND VGND VPWR VPWR net87 sky130_fd_sc_hd__dlygate4sd1_1
XFILLER_0_16_41 VGND VGND VPWR VPWR sky130_fd_sc_hd__decap_4
XFILLER_0_16_74 VGND VGND VPWR VPWR sky130_fd_sc_hd__decap_4
XFILLER_0_16_85 VGND VGND VPWR VPWR sky130_fd_sc_hd__fill_2
Xaccumulator._2091_ accumulator._0046_ VGND VGND VPWR VPWR accumulator._0047_ sky130_fd_sc_hd__buf_8
XFILLER_0_32_95 VGND VGND VPWR VPWR sky130_fd_sc_hd__decap_6
XFILLER_0_8_126 VGND VGND VPWR VPWR sky130_fd_sc_hd__fill_1
XFILLER_0_52_290 VPWR VGND VPWR VGND sky130_ef_sc_hd__decap_12
Xaccumulator._1944_ accumulator._0932_ accumulator._0933_ accumulator._0940_ VGND
+ VGND VPWR VPWR accumulator._1039_ sky130_fd_sc_hd__a21oi_2
Xaccumulator._1875_ accumulator._0917_ accumulator._0683_ accumulator._0749_ VGND
+ VGND VPWR VPWR accumulator._0970_ sky130_fd_sc_hd__and3_1
XFILLER_0_4_398 VGND VGND VPWR VPWR sky130_fd_sc_hd__decap_3
XFILLER_0_4_365 VGND VGND VPWR VPWR sky130_fd_sc_hd__decap_4
XPHY_EDGE_ROW_6_Right_6 VGND VGND VPWR VPWR sky130_fd_sc_hd__decap_3
XFILLER_0_67_349 VPWR VGND VPWR VGND sky130_ef_sc_hd__decap_12
Xaccumulator._2289_ accumulator._0041_ accumulator._0238_ VGND VGND VPWR VPWR accumulator._0240_
+ sky130_fd_sc_hd__nand2_1
Xaccumulator._2358_ clknet_2_2__leaf_clock accumulator._0003_ VGND VGND VPWR VPWR
+ accumulator.io_accOut\[1\] sky130_fd_sc_hd__dfxtp_1
Xaccumulator._1309_ accumulator._0377_ accumulator._0403_ VGND VGND VPWR VPWR accumulator._0404_
+ sky130_fd_sc_hd__nor2_1
XFILLER_0_50_249 VGND VGND VPWR VPWR sky130_fd_sc_hd__decap_3
XFILLER_0_7_181 VGND VGND VPWR VPWR sky130_fd_sc_hd__decap_4
Xoutput43 net43 VGND VGND VPWR VPWR io_accOut[28] sky130_fd_sc_hd__buf_2
Xoutput32 net32 VGND VGND VPWR VPWR io_accOut[18] sky130_fd_sc_hd__buf_2
XFILLER_0_37_29 VGND VGND VPWR VPWR sky130_fd_sc_hd__fill_2
Xoutput54 net54 VGND VGND VPWR VPWR io_accOut[9] sky130_fd_sc_hd__buf_2
XPHY_EDGE_ROW_59_Right_59 VGND VGND VPWR VPWR sky130_fd_sc_hd__decap_3
XTAP_TAPCELL_ROW_46_469 VGND VPWR sky130_fd_sc_hd__tapvpwrvgnd_1
XFILLER_0_5_107 VGND VGND VPWR VPWR sky130_fd_sc_hd__fill_1
XFILLER_0_1_335 VGND VGND VPWR VPWR sky130_fd_sc_hd__fill_1
Xaccumulator._1660_ accumulator._0753_ accumulator._0631_ VGND VGND VPWR VPWR accumulator._0755_
+ sky130_fd_sc_hd__and2_1
Xaccumulator._1591_ accumulator._0536_ accumulator._0685_ VGND VGND VPWR VPWR accumulator._0686_
+ sky130_fd_sc_hd__nand2_1
XFILLER_0_49_349 VPWR VGND VPWR VGND sky130_ef_sc_hd__decap_12
XFILLER_0_49_316 VPWR VGND VPWR VGND sky130_ef_sc_hd__decap_12
Xaccumulator._2212_ accumulator._0165_ accumulator._0166_ accumulator._1121_ VGND
+ VGND VPWR VPWR accumulator._0167_ sky130_fd_sc_hd__mux2_2
Xaccumulator._2143_ accumulator.io_accOut\[5\] accumulator._0392_ accumulator._1094_
+ accumulator._0098_ VGND VGND VPWR VPWR accumulator._0099_ sky130_fd_sc_hd__o2bb2a_1
XTAP_TAPCELL_ROW_37_403 VGND VPWR sky130_fd_sc_hd__tapvpwrvgnd_1
XFILLER_0_57_393 VGND VGND VPWR VPWR sky130_fd_sc_hd__decap_4
Xaccumulator._2074_ accumulator._1170_ VGND VGND VPWR VPWR accumulator._1171_ sky130_fd_sc_hd__buf_8
Xaccumulator._1927_ accumulator._1021_ VGND VGND VPWR VPWR accumulator._1022_ sky130_fd_sc_hd__buf_4
Xaccumulator._1858_ accumulator._0917_ accumulator._0743_ accumulator._0952_ accumulator._0833_
+ VGND VGND VPWR VPWR accumulator._0953_ sky130_fd_sc_hd__a22o_1
Xaccumulator._1789_ accumulator._0538_ accumulator._0577_ accumulator._0883_ VGND
+ VGND VPWR VPWR accumulator._0884_ sky130_fd_sc_hd__and3_1
XFILLER_0_67_113 VPWR VGND VPWR VGND sky130_ef_sc_hd__decap_12
XFILLER_0_63_385 VGND VGND VPWR VPWR sky130_fd_sc_hd__decap_6
XFILLER_0_23_205 VGND VGND VPWR VPWR sky130_fd_sc_hd__decap_6
Xrebuffer9 accumulator._0315_ VGND VGND VPWR VPWR net67 sky130_fd_sc_hd__clkbuf_1
XFILLER_0_64_27 VGND VGND VPWR VPWR sky130_fd_sc_hd__fill_1
XFILLER_0_31_293 VPWR VGND VPWR VGND sky130_ef_sc_hd__decap_12
XTAP_TAPCELL_ROW_59_561 VGND VPWR sky130_fd_sc_hd__tapvpwrvgnd_1
XFILLER_0_46_319 VGND VGND VPWR VPWR sky130_fd_sc_hd__fill_2
XFILLER_0_39_393 VGND VGND VPWR VPWR sky130_fd_sc_hd__decap_4
Xaccumulator._1712_ accumulator.io_accOut\[3\] VGND VGND VPWR VPWR accumulator._0807_
+ sky130_fd_sc_hd__inv_2
Xaccumulator._1643_ accumulator._0733_ accumulator._0736_ accumulator._0737_ accumulator._0513_
+ VGND VGND VPWR VPWR accumulator._0738_ sky130_fd_sc_hd__a31o_1
XFILLER_0_38_83 VGND VGND VPWR VPWR sky130_fd_sc_hd__fill_1
Xaccumulator._1574_ accumulator._0514_ accumulator._0596_ accumulator._0597_ VGND
+ VGND VPWR VPWR accumulator._0669_ sky130_fd_sc_hd__and3_1
Xaccumulator._2126_ accumulator._0060_ accumulator._0081_ VGND VGND VPWR VPWR accumulator._0082_
+ sky130_fd_sc_hd__nor2_1
XFILLER_0_49_113 VGND VGND VPWR VPWR sky130_fd_sc_hd__decap_8
Xaccumulator._2057_ accumulator._1138_ accumulator._1152_ VGND VGND VPWR VPWR accumulator._1153_
+ sky130_fd_sc_hd__nand2_1
XFILLER_0_60_377 VPWR VGND VPWR VGND sky130_ef_sc_hd__decap_12
XFILLER_0_60_333 VPWR VGND VPWR VGND sky130_ef_sc_hd__decap_12
XFILLER_0_60_300 VGND VGND VPWR VPWR sky130_fd_sc_hd__decap_8
XFILLER_0_45_374 VPWR VGND VPWR VGND sky130_ef_sc_hd__decap_12
XFILLER_0_9_298 VGND VGND VPWR VPWR sky130_fd_sc_hd__decap_6
XFILLER_0_59_27 VGND VGND VPWR VPWR sky130_fd_sc_hd__decap_6
XFILLER_0_51_377 VPWR VGND VPWR VGND sky130_ef_sc_hd__decap_12
XTAP_TAPCELL_ROW_62_578 VGND VPWR sky130_fd_sc_hd__tapvpwrvgnd_1
XFILLER_0_46_138 VGND VGND VPWR VPWR sky130_fd_sc_hd__fill_2
Xaccumulator._1290_ accumulator._0386_ VGND VGND VPWR VPWR accumulator._0387_ sky130_fd_sc_hd__clkbuf_4
XTAP_TAPCELL_ROW_19_277 VGND VPWR sky130_fd_sc_hd__tapvpwrvgnd_1
XFILLER_0_54_193 VGND VGND VPWR VPWR sky130_fd_sc_hd__decap_3
XFILLER_0_54_182 VGND VGND VPWR VPWR sky130_fd_sc_hd__decap_4
XFILLER_0_42_377 VPWR VGND VPWR VGND sky130_ef_sc_hd__decap_12
XFILLER_0_42_333 VPWR VGND VPWR VGND sky130_ef_sc_hd__decap_12
XFILLER_0_57_3 VPWR VGND VPWR VGND sky130_ef_sc_hd__decap_12
Xaccumulator._1626_ accumulator._0719_ accumulator._0720_ VGND VGND VPWR VPWR accumulator._0721_
+ sky130_fd_sc_hd__xnor2_2
Xaccumulator._1488_ accumulator._0581_ accumulator._0582_ VGND VGND VPWR VPWR accumulator._0583_
+ sky130_fd_sc_hd__nor2_1
Xoperator._15_ operator._01_ VGND VGND VPWR VPWR operator.io_outExp\[2\] sky130_fd_sc_hd__buf_1
Xaccumulator._1557_ accumulator._0618_ accumulator._0621_ accumulator._0421_ VGND
+ VGND VPWR VPWR accumulator._0652_ sky130_fd_sc_hd__a21o_1
Xaccumulator._2109_ accumulator._0064_ VGND VGND VPWR VPWR accumulator._0003_ sky130_fd_sc_hd__clkbuf_1
XFILLER_0_18_363 VGND VGND VPWR VPWR sky130_fd_sc_hd__fill_1
XFILLER_0_18_374 VPWR VGND VPWR VGND sky130_ef_sc_hd__decap_12
XFILLER_0_60_163 VGND VGND VPWR VPWR sky130_fd_sc_hd__decap_8
XFILLER_0_60_141 VPWR VGND VPWR VGND sky130_ef_sc_hd__decap_12
XFILLER_0_33_388 VGND VGND VPWR VPWR sky130_fd_sc_hd__decap_4
XFILLER_0_61_39 VPWR VGND VPWR VGND sky130_ef_sc_hd__decap_12
XFILLER_0_28_127 VPWR VGND VPWR VGND sky130_ef_sc_hd__decap_12
XFILLER_0_28_105 VGND VGND VPWR VPWR sky130_fd_sc_hd__decap_8
XTAP_TAPCELL_ROW_16_258 VGND VPWR sky130_fd_sc_hd__tapvpwrvgnd_1
XFILLER_0_3_205 VPWR VGND VPWR VGND sky130_ef_sc_hd__decap_12
XscaleAdd._476_ scaleAdd._158_ scaleAdd._161_ scaleAdd._169_ VGND VGND VPWR VPWR scaleAdd._171_
+ sky130_fd_sc_hd__and3_1
XFILLER_0_10_65 VGND VGND VPWR VPWR sky130_fd_sc_hd__decap_3
XTAP_TAPCELL_ROW_67_615 VGND VPWR sky130_fd_sc_hd__tapvpwrvgnd_1
Xaccumulator._1342_ accumulator.io_inMant\[10\] accumulator.io_inMant\[11\] accumulator._0428_
+ VGND VGND VPWR VPWR accumulator._0437_ sky130_fd_sc_hd__mux2_1
Xaccumulator._1411_ accumulator._0447_ accumulator._0450_ net90 VGND VGND VPWR VPWR
+ accumulator._0506_ sky130_fd_sc_hd__mux2_1
Xaccumulator._1273_ net70 accumulator._0333_ accumulator._0337_ accumulator._0338_
+ VGND VGND VPWR VPWR accumulator._0370_ sky130_fd_sc_hd__or4_1
XFILLER_0_51_94 VGND VGND VPWR VPWR sky130_fd_sc_hd__decap_3
XFILLER_0_15_311 VGND VGND VPWR VPWR sky130_fd_sc_hd__fill_1
XFILLER_0_19_105 VGND VGND VPWR VPWR sky130_fd_sc_hd__decap_6
XFILLER_0_42_141 VGND VGND VPWR VPWR sky130_fd_sc_hd__fill_1
XFILLER_0_15_355 VGND VGND VPWR VPWR sky130_fd_sc_hd__decap_4
XFILLER_0_15_399 VGND VGND VPWR VPWR sky130_fd_sc_hd__fill_2
Xaccumulator._1609_ accumulator._0410_ accumulator._0697_ accumulator._0703_ accumulator._0577_
+ accumulator._0679_ VGND VGND VPWR VPWR accumulator._0704_ sky130_fd_sc_hd__a32oi_4
XFILLER_0_65_211 VGND VGND VPWR VPWR sky130_fd_sc_hd__fill_1
XFILLER_0_25_119 VGND VGND VPWR VPWR sky130_fd_sc_hd__decap_8
XTAP_TAPCELL_ROW_21_294 VGND VPWR sky130_fd_sc_hd__tapvpwrvgnd_1
XTAP_TAPCELL_ROW_13_239 VGND VPWR sky130_fd_sc_hd__tapvpwrvgnd_1
XscaleAdd._261_ scaleAdd._202_ scaleAdd._203_ VGND VGND VPWR VPWR scaleAdd._204_ sky130_fd_sc_hd__and2_1
XscaleAdd._330_ scaleAdd._190_ scaleAdd._207_ scaleAdd._003_ scaleAdd._002_ VGND VGND
+ VPWR VPWR scaleAdd._037_ sky130_fd_sc_hd__a31o_1
XTAP_TAPCELL_ROW_29_350 VGND VPWR sky130_fd_sc_hd__tapvpwrvgnd_1
XFILLER_0_56_299 VGND VGND VPWR VPWR sky130_fd_sc_hd__fill_2
Xaccumulator._1891_ accumulator._0918_ accumulator._0984_ accumulator._0985_ VGND
+ VGND VPWR VPWR accumulator._0986_ sky130_fd_sc_hd__o21a_1
Xaccumulator._1960_ accumulator._0886_ accumulator._1054_ accumulator._0897_ accumulator._0535_
+ VGND VGND VPWR VPWR accumulator._1055_ sky130_fd_sc_hd__o211a_1
XFILLER_0_24_141 VPWR VGND VPWR VGND sky130_ef_sc_hd__decap_12
XFILLER_0_24_130 VGND VGND VPWR VPWR sky130_fd_sc_hd__decap_8
XFILLER_0_46_50 VPWR VGND VPWR VGND sky130_ef_sc_hd__decap_12
XscaleAdd._459_ scaleAdd._153_ scaleAdd._154_ scaleAdd._148_ VGND VGND VPWR VPWR scaleAdd._155_
+ sky130_fd_sc_hd__a21oi_1
XFILLER_0_47_222 VGND VGND VPWR VPWR sky130_fd_sc_hd__fill_2
Xaccumulator._2374_ clknet_2_0__leaf_clock accumulator._0019_ VGND VGND VPWR VPWR
+ accumulator.io_accOut\[17\] sky130_fd_sc_hd__dfxtp_1
Xaccumulator._1325_ accumulator._0416_ accumulator._0419_ VGND VGND VPWR VPWR accumulator._0420_
+ sky130_fd_sc_hd__nand2_2
Xaccumulator._1256_ accumulator._0340_ accumulator._0348_ accumulator.io_accOut\[24\]
+ VGND VGND VPWR VPWR accumulator._0353_ sky130_fd_sc_hd__o21a_1
XFILLER_0_62_247 VGND VGND VPWR VPWR sky130_fd_sc_hd__decap_4
XFILLER_0_62_236 VGND VGND VPWR VPWR sky130_fd_sc_hd__decap_8
Xaccumulator._1187_ accumulator._0075_ VGND VGND VPWR VPWR accumulator._0105_ sky130_fd_sc_hd__clkbuf_2
Xhold54 accumulator.state\[0\] VGND VGND VPWR VPWR net112 sky130_fd_sc_hd__dlygate4sd3_1
XFILLER_0_53_214 VGND VGND VPWR VPWR sky130_fd_sc_hd__decap_8
XFILLER_0_42_19 VGND VGND VPWR VPWR sky130_fd_sc_hd__decap_3
XFILLER_0_38_244 VGND VGND VPWR VPWR sky130_fd_sc_hd__decap_8
XFILLER_0_38_222 VPWR VGND VPWR VGND sky130_ef_sc_hd__decap_12
XTAP_TAPCELL_ROW_26_331 VGND VPWR sky130_fd_sc_hd__tapvpwrvgnd_1
XFILLER_0_53_225 VPWR VGND VPWR VGND sky130_ef_sc_hd__decap_12
XFILLER_0_67_27 VGND VGND VPWR VPWR sky130_fd_sc_hd__fill_1
XscaleAdd._313_ scaleAdd._018_ net81 scaleAdd._019_ VGND VGND VPWR VPWR scaleAdd._020_
+ sky130_fd_sc_hd__a21oi_4
XscaleAdd._244_ operator.io_outMant\[1\] VGND VGND VPWR VPWR scaleAdd._190_ sky130_fd_sc_hd__clkbuf_4
Xaccumulator._2090_ accumulator._1170_ VGND VGND VPWR VPWR accumulator._0046_ sky130_fd_sc_hd__buf_8
XTAP_TAPCELL_ROW_49_489 VGND VPWR sky130_fd_sc_hd__tapvpwrvgnd_1
Xrebuffer19 scaleAdd._147_ VGND VGND VPWR VPWR net77 sky130_fd_sc_hd__clkbuf_2
XFILLER_0_44_269 VGND VGND VPWR VPWR sky130_fd_sc_hd__fill_2
XFILLER_0_32_85 VGND VGND VPWR VPWR sky130_fd_sc_hd__decap_6
XTAP_TAPCELL_ROW_32_367 VGND VPWR sky130_fd_sc_hd__tapvpwrvgnd_1
XFILLER_0_32_41 VGND VGND VPWR VPWR sky130_fd_sc_hd__decap_4
XFILLER_0_8_149 VGND VGND VPWR VPWR sky130_fd_sc_hd__decap_3
Xaccumulator._1943_ accumulator._1026_ accumulator._1037_ VGND VGND VPWR VPWR accumulator._1038_
+ sky130_fd_sc_hd__or2_2
Xaccumulator._1874_ accumulator._0841_ accumulator._0964_ VGND VGND VPWR VPWR accumulator._0969_
+ sky130_fd_sc_hd__nand2_1
XFILLER_0_12_122 VGND VGND VPWR VPWR sky130_fd_sc_hd__decap_3
Xaccumulator._2288_ accumulator._0041_ accumulator._0238_ VGND VGND VPWR VPWR accumulator._0239_
+ sky130_fd_sc_hd__or2_1
Xaccumulator._2357_ clknet_2_0__leaf_clock accumulator._0002_ VGND VGND VPWR VPWR
+ accumulator.io_accOut\[0\] sky130_fd_sc_hd__dfxtp_2
Xaccumulator._1308_ accumulator._0396_ accumulator._0402_ VGND VGND VPWR VPWR accumulator._0403_
+ sky130_fd_sc_hd__nor2_1
Xaccumulator._1239_ accumulator.io_inExp\[6\] accumulator._0335_ VGND VGND VPWR VPWR
+ accumulator._0336_ sky130_fd_sc_hd__xnor2_1
XFILLER_0_50_206 VPWR VGND VPWR VGND sky130_ef_sc_hd__decap_12
Xoutput55 net55 VGND VGND VPWR VPWR io_done sky130_fd_sc_hd__buf_2
Xoutput44 net44 VGND VGND VPWR VPWR io_accOut[29] sky130_fd_sc_hd__buf_2
Xoutput33 net33 VGND VGND VPWR VPWR io_accOut[19] sky130_fd_sc_hd__buf_2
XFILLER_0_9_3 VPWR VGND VPWR VGND sky130_ef_sc_hd__decap_12
XFILLER_0_58_306 VGND VGND VPWR VPWR sky130_fd_sc_hd__fill_2
Xaccumulator._2211_ accumulator._0096_ VGND VGND VPWR VPWR accumulator._0166_ sky130_fd_sc_hd__inv_2
XTAP_TAPCELL_ROW_37_404 VGND VPWR sky130_fd_sc_hd__tapvpwrvgnd_1
XFILLER_0_27_41 VGND VGND VPWR VPWR sky130_fd_sc_hd__decap_3
Xaccumulator._1590_ accumulator._0608_ accumulator._0611_ accumulator._0612_ accumulator._0684_
+ VGND VGND VPWR VPWR accumulator._0685_ sky130_fd_sc_hd__a31o_1
XFILLER_0_64_309 VPWR VGND VPWR VGND sky130_ef_sc_hd__decap_12
XFILLER_0_57_361 VPWR VGND VPWR VGND sky130_ef_sc_hd__decap_12
Xaccumulator._2073_ accumulator._1085_ accumulator._1141_ accumulator._1169_ accumulator._1167_
+ VGND VGND VPWR VPWR accumulator._1170_ sky130_fd_sc_hd__a2bb2o_4
XFILLER_0_49_328 VGND VGND VPWR VPWR sky130_fd_sc_hd__decap_8
Xaccumulator._2142_ accumulator._0096_ accumulator._0097_ accumulator._1121_ VGND
+ VGND VPWR VPWR accumulator._0098_ sky130_fd_sc_hd__mux2_4
XFILLER_0_32_206 VGND VGND VPWR VPWR sky130_fd_sc_hd__decap_6
XFILLER_0_4_141 VGND VGND VPWR VPWR sky130_fd_sc_hd__decap_4
XFILLER_0_4_130 VGND VGND VPWR VPWR sky130_fd_sc_hd__fill_1
XFILLER_0_17_225 VGND VGND VPWR VPWR sky130_fd_sc_hd__decap_8
Xaccumulator._1926_ accumulator._0920_ accumulator._0916_ accumulator._0945_ VGND
+ VGND VPWR VPWR accumulator._1021_ sky130_fd_sc_hd__a21o_1
XFILLER_0_40_294 VGND VGND VPWR VPWR sky130_fd_sc_hd__fill_1
XFILLER_0_40_261 VPWR VGND VPWR VGND sky130_ef_sc_hd__decap_12
XFILLER_0_40_250 VGND VGND VPWR VPWR sky130_fd_sc_hd__fill_2
Xaccumulator._1788_ accumulator.io_accOut\[19\] accumulator._0440_ accumulator._0389_
+ VGND VGND VPWR VPWR accumulator._0883_ sky130_fd_sc_hd__mux2_1
Xaccumulator._1857_ accumulator._0834_ accumulator._0730_ accumulator._0533_ VGND
+ VGND VPWR VPWR accumulator._0952_ sky130_fd_sc_hd__o21a_1
XFILLER_0_7_51 VGND VGND VPWR VPWR sky130_fd_sc_hd__decap_4
XFILLER_0_67_125 VPWR VGND VPWR VGND sky130_ef_sc_hd__decap_12
XFILLER_0_67_169 VPWR VGND VPWR VGND sky130_ef_sc_hd__decap_12
XFILLER_0_48_29 VGND VGND VPWR VPWR sky130_fd_sc_hd__decap_4
XTAP_TAPCELL_ROW_59_562 VGND VPWR sky130_fd_sc_hd__tapvpwrvgnd_1
XFILLER_0_54_397 VGND VGND VPWR VPWR sky130_fd_sc_hd__fill_1
XTAP_TAPCELL_ROW_42_440 VGND VPWR sky130_fd_sc_hd__tapvpwrvgnd_1
XFILLER_0_38_62 VGND VGND VPWR VPWR sky130_fd_sc_hd__decap_6
Xaccumulator._1711_ accumulator._0694_ accumulator._0695_ VGND VGND VPWR VPWR accumulator._0806_
+ sky130_fd_sc_hd__and2b_1
XFILLER_0_22_283 VGND VGND VPWR VPWR sky130_fd_sc_hd__fill_1
XFILLER_0_1_111 VGND VGND VPWR VPWR sky130_fd_sc_hd__fill_1
Xaccumulator._1642_ accumulator._0511_ accumulator._0420_ accumulator._0712_ VGND
+ VGND VPWR VPWR accumulator._0737_ sky130_fd_sc_hd__or3_1
XFILLER_0_54_83 VGND VGND VPWR VPWR sky130_fd_sc_hd__fill_1
XFILLER_0_49_103 VGND VGND VPWR VPWR sky130_fd_sc_hd__decap_8
Xaccumulator._1573_ accumulator._0600_ accumulator._0601_ VGND VGND VPWR VPWR accumulator._0668_
+ sky130_fd_sc_hd__nand2_1
XTAP_TAPCELL_ROW_65_598 VGND VPWR sky130_fd_sc_hd__tapvpwrvgnd_1
Xaccumulator._2125_ accumulator._0054_ accumulator._0079_ accumulator._0080_ VGND
+ VGND VPWR VPWR accumulator._0081_ sky130_fd_sc_hd__mux2_1
XFILLER_0_49_169 VPWR VGND VPWR VGND sky130_ef_sc_hd__decap_12
XFILLER_0_49_147 VPWR VGND VPWR VGND sky130_ef_sc_hd__decap_12
Xaccumulator._2056_ accumulator._1150_ accumulator._1151_ VGND VGND VPWR VPWR accumulator._1152_
+ sky130_fd_sc_hd__xnor2_1
XFILLER_0_9_255 VGND VGND VPWR VPWR sky130_fd_sc_hd__fill_2
XFILLER_0_60_389 VPWR VGND VPWR VGND sky130_ef_sc_hd__decap_12
XFILLER_0_60_345 VPWR VGND VPWR VGND sky130_ef_sc_hd__decap_12
Xaccumulator._1909_ accumulator._0997_ accumulator._1000_ accumulator._1003_ VGND
+ VGND VPWR VPWR accumulator._1004_ sky130_fd_sc_hd__and3_1
XFILLER_0_45_386 VGND VGND VPWR VPWR sky130_fd_sc_hd__decap_6
XFILLER_0_20_209 VGND VGND VPWR VPWR sky130_fd_sc_hd__decap_4
XFILLER_0_28_309 VPWR VGND VPWR VGND sky130_ef_sc_hd__decap_12
XFILLER_0_63_172 VGND VGND VPWR VPWR sky130_fd_sc_hd__decap_4
XFILLER_0_36_375 VGND VGND VPWR VPWR sky130_fd_sc_hd__decap_3
XFILLER_0_51_389 VGND VGND VPWR VPWR sky130_fd_sc_hd__decap_3
XTAP_TAPCELL_ROW_62_579 VGND VPWR sky130_fd_sc_hd__tapvpwrvgnd_1
XFILLER_0_39_180 VPWR VGND VPWR VGND sky130_ef_sc_hd__decap_12
XFILLER_0_24_42 VPWR VGND VPWR VGND sky130_ef_sc_hd__decap_12
XTAP_TAPCELL_ROW_19_278 VGND VPWR sky130_fd_sc_hd__tapvpwrvgnd_1
XFILLER_0_42_389 VGND VGND VPWR VPWR sky130_fd_sc_hd__decap_8
XFILLER_0_42_345 VGND VGND VPWR VPWR sky130_fd_sc_hd__fill_2
XFILLER_0_40_85 VPWR VGND VPWR VGND sky130_ef_sc_hd__decap_12
XFILLER_0_40_41 VPWR VGND VPWR VGND sky130_ef_sc_hd__decap_12
Xaccumulator._1556_ accumulator._0649_ accumulator._0650_ VGND VGND VPWR VPWR accumulator._0651_
+ sky130_fd_sc_hd__or2_1
Xaccumulator._1625_ accumulator.io_accOut\[2\] accumulator._0378_ VGND VGND VPWR VPWR
+ accumulator._0720_ sky130_fd_sc_hd__nand2_1
XFILLER_0_4_85 VPWR VGND VPWR VGND sky130_ef_sc_hd__decap_12
XFILLER_0_4_41 VPWR VGND VPWR VGND sky130_ef_sc_hd__decap_12
XFILLER_0_10_253 VPWR VGND VPWR VGND sky130_ef_sc_hd__decap_12
XFILLER_0_10_275 VGND VGND VPWR VPWR sky130_fd_sc_hd__fill_1
Xaccumulator._1487_ accumulator.io_accOut\[11\] accumulator._0548_ accumulator._0387_
+ VGND VGND VPWR VPWR accumulator._0582_ sky130_fd_sc_hd__mux2_1
Xoperator._14_ net2 net3 net7 net6 VGND VGND VPWR VPWR operator._01_ sky130_fd_sc_hd__and4_1
XTAP_TAPCELL_ROW_2_157 VGND VPWR sky130_fd_sc_hd__tapvpwrvgnd_1
Xaccumulator._2039_ accumulator._1131_ accumulator._1133_ accumulator._1021_ VGND
+ VGND VPWR VPWR accumulator._1134_ sky130_fd_sc_hd__mux2_4
Xaccumulator._2108_ accumulator._0380_ accumulator._0063_ VGND VGND VPWR VPWR accumulator._0064_
+ sky130_fd_sc_hd__and2_1
XFILLER_0_45_161 VGND VGND VPWR VPWR sky130_fd_sc_hd__decap_6
XFILLER_0_18_386 VPWR VGND VPWR VGND sky130_ef_sc_hd__decap_12
XFILLER_0_60_197 VPWR VGND VPWR VGND sky130_ef_sc_hd__decap_12
XFILLER_0_60_153 VGND VGND VPWR VPWR sky130_fd_sc_hd__fill_1
XFILLER_0_28_139 VGND VGND VPWR VPWR sky130_fd_sc_hd__fill_1
XTAP_TAPCELL_ROW_16_259 VGND VPWR sky130_fd_sc_hd__tapvpwrvgnd_1
XFILLER_0_24_345 VPWR VGND VPWR VGND sky130_ef_sc_hd__decap_12
XFILLER_0_10_77 VGND VGND VPWR VPWR sky130_fd_sc_hd__decap_6
XTAP_TAPCELL_ROW_67_616 VGND VPWR sky130_fd_sc_hd__tapvpwrvgnd_1
XscaleAdd._475_ scaleAdd._158_ scaleAdd._161_ scaleAdd._169_ VGND VGND VPWR VPWR scaleAdd._170_
+ sky130_fd_sc_hd__a21oi_1
XFILLER_0_19_31 VGND VGND VPWR VPWR sky130_fd_sc_hd__fill_1
Xaccumulator._1410_ accumulator._0425_ VGND VGND VPWR VPWR accumulator._0505_ sky130_fd_sc_hd__buf_6
XFILLER_0_35_74 VPWR VGND VPWR VGND sky130_ef_sc_hd__decap_12
XFILLER_0_35_63 VGND VGND VPWR VPWR sky130_fd_sc_hd__decap_4
XFILLER_0_35_30 VPWR VGND VPWR VGND sky130_ef_sc_hd__decap_12
Xaccumulator._1272_ accumulator._0363_ accumulator._0367_ accumulator._0368_ VGND
+ VGND VPWR VPWR accumulator._0369_ sky130_fd_sc_hd__a21o_1
Xaccumulator._1341_ accumulator.io_inMant\[8\] accumulator.io_inMant\[9\] accumulator._0428_
+ VGND VGND VPWR VPWR accumulator._0436_ sky130_fd_sc_hd__mux2_1
XFILLER_0_27_150 VGND VGND VPWR VPWR sky130_fd_sc_hd__fill_2
XFILLER_0_42_186 VGND VGND VPWR VPWR sky130_fd_sc_hd__fill_1
Xaccumulator._1539_ accumulator._0606_ accumulator._0607_ accumulator._0633_ VGND
+ VGND VPWR VPWR accumulator._0634_ sky130_fd_sc_hd__o21ai_1
Xaccumulator._1608_ accumulator._0608_ accumulator._0639_ accumulator._0642_ accumulator._0702_
+ accumulator._0536_ VGND VGND VPWR VPWR accumulator._0703_ sky130_fd_sc_hd__a311o_1
XTAP_TAPCELL_ROW_21_295 VGND VPWR sky130_fd_sc_hd__tapvpwrvgnd_1
XFILLER_0_0_209 VGND VGND VPWR VPWR sky130_fd_sc_hd__decap_8
XFILLER_0_56_29 VGND VGND VPWR VPWR sky130_fd_sc_hd__decap_3
XscaleAdd._260_ net9 net10 net12 net13 VGND VGND VPWR VPWR scaleAdd._203_ sky130_fd_sc_hd__nand4_1
XTAP_TAPCELL_ROW_29_351 VGND VPWR sky130_fd_sc_hd__tapvpwrvgnd_1
XFILLER_0_8_309 VGND VGND VPWR VPWR sky130_fd_sc_hd__decap_8
Xaccumulator._1890_ accumulator._0756_ accumulator._0980_ accumulator._0632_ accumulator._0534_
+ VGND VGND VPWR VPWR accumulator._0985_ sky130_fd_sc_hd__a211o_1
XFILLER_0_24_197 VGND VGND VPWR VPWR sky130_fd_sc_hd__decap_6
XFILLER_0_24_153 VPWR VGND VPWR VGND sky130_ef_sc_hd__decap_12
XFILLER_0_46_62 VGND VGND VPWR VPWR sky130_fd_sc_hd__decap_4
Xaccumulator._2373_ clknet_2_1__leaf_clock accumulator._0018_ VGND VGND VPWR VPWR
+ accumulator.io_accOut\[16\] sky130_fd_sc_hd__dfxtp_1
XscaleAdd._389_ scaleAdd._029_ scaleAdd._092_ VGND VGND VPWR VPWR scaleAdd._093_ sky130_fd_sc_hd__nand2_1
XscaleAdd._458_ net15 net18 VGND VGND VPWR VPWR scaleAdd._154_ sky130_fd_sc_hd__nand2_1
XFILLER_0_47_256 VGND VGND VPWR VPWR sky130_fd_sc_hd__fill_2
X_29_ accumulator.io_accOut\[29\] VGND VGND VPWR VPWR net44 sky130_fd_sc_hd__clkbuf_1
Xaccumulator._1324_ accumulator._0386_ accumulator._0418_ accumulator._0415_ VGND
+ VGND VPWR VPWR accumulator._0419_ sky130_fd_sc_hd__a21o_1
Xaccumulator._1186_ accumulator.io_inExp\[4\] accumulator._0075_ VGND VGND VPWR VPWR
+ accumulator._0095_ sky130_fd_sc_hd__and2_1
Xaccumulator._1255_ accumulator.io_accOut\[23\] accumulator._0339_ accumulator._0351_
+ VGND VGND VPWR VPWR accumulator._0352_ sky130_fd_sc_hd__or3_4
XFILLER_0_15_197 VPWR VGND VPWR VGND sky130_ef_sc_hd__decap_12
Xhold55 accumulator.io_accOut\[13\] VGND VGND VPWR VPWR net113 sky130_fd_sc_hd__dlygate4sd3_1
XFILLER_0_53_237 VGND VGND VPWR VPWR sky130_fd_sc_hd__decap_4
XFILLER_0_38_234 VGND VGND VPWR VPWR sky130_fd_sc_hd__fill_2
XFILLER_0_61_281 VPWR VGND VPWR VGND sky130_ef_sc_hd__decap_12
XscaleAdd._312_ scaleAdd._226_ scaleAdd._228_ VGND VGND VPWR VPWR scaleAdd._019_ sky130_fd_sc_hd__and2_1
XscaleAdd._243_ scaleAdd._185_ net10 VGND VGND VPWR VPWR scaleAdd._189_ sky130_fd_sc_hd__nor2b_2
Xaccumulator._1942_ accumulator._1031_ accumulator._1036_ VGND VGND VPWR VPWR accumulator._1037_
+ sky130_fd_sc_hd__nand2_1
XTAP_TAPCELL_ROW_32_368 VGND VPWR sky130_fd_sc_hd__tapvpwrvgnd_1
XFILLER_0_29_267 VGND VGND VPWR VPWR sky130_fd_sc_hd__decap_4
Xaccumulator._1873_ accumulator._0963_ accumulator._0959_ accumulator._0955_ accumulator._0967_
+ VGND VGND VPWR VPWR accumulator._0968_ sky130_fd_sc_hd__or4b_4
Xaccumulator._2356_ clknet_2_3__leaf_clock accumulator._0001_ VGND VGND VPWR VPWR
+ accumulator.state\[1\] sky130_fd_sc_hd__dfxtp_1
Xaccumulator._2287_ accumulator.io_accOut\[24\] accumulator._0237_ accumulator._0389_
+ VGND VGND VPWR VPWR accumulator._0238_ sky130_fd_sc_hd__mux2_1
Xaccumulator._1238_ net88 accumulator._0065_ VGND VGND VPWR VPWR accumulator._0335_
+ sky130_fd_sc_hd__nor2_2
Xaccumulator._1307_ accumulator._0398_ accumulator._0401_ VGND VGND VPWR VPWR accumulator._0402_
+ sky130_fd_sc_hd__nand2_1
Xoutput34 net34 VGND VGND VPWR VPWR io_accOut[1] sky130_fd_sc_hd__buf_2
XFILLER_0_50_218 VGND VGND VPWR VPWR sky130_fd_sc_hd__fill_2
Xoutput23 net23 VGND VGND VPWR VPWR io_accOut[0] sky130_fd_sc_hd__buf_2
Xoutput45 net45 VGND VGND VPWR VPWR io_accOut[2] sky130_fd_sc_hd__clkbuf_4
XFILLER_0_1_326 VGND VGND VPWR VPWR sky130_fd_sc_hd__decap_4
Xaccumulator._2210_ accumulator._0131_ accumulator._0163_ accumulator._1128_ VGND
+ VGND VPWR VPWR accumulator._0165_ sky130_fd_sc_hd__mux2_4
XTAP_TAPCELL_ROW_37_405 VGND VPWR sky130_fd_sc_hd__tapvpwrvgnd_1
XFILLER_0_27_75 VGND VGND VPWR VPWR sky130_fd_sc_hd__decap_6
XFILLER_0_57_373 VPWR VGND VPWR VGND sky130_ef_sc_hd__decap_12
Xaccumulator._2072_ accumulator._1081_ accumulator._1083_ accumulator._1168_ VGND
+ VGND VPWR VPWR accumulator._1169_ sky130_fd_sc_hd__o21a_1
Xaccumulator._2141_ accumulator._0060_ accumulator._0059_ VGND VGND VPWR VPWR accumulator._0097_
+ sky130_fd_sc_hd__or2_1
XTAP_TAPCELL_ROW_45_460 VGND VPWR sky130_fd_sc_hd__tapvpwrvgnd_1
XFILLER_0_43_96 VGND VGND VPWR VPWR sky130_fd_sc_hd__decap_3
XFILLER_0_43_41 VGND VGND VPWR VPWR sky130_fd_sc_hd__decap_3
Xaccumulator._1925_ accumulator._1019_ accumulator._0866_ VGND VGND VPWR VPWR accumulator._1020_
+ sky130_fd_sc_hd__xor2_4
XFILLER_0_25_281 VGND VGND VPWR VPWR sky130_fd_sc_hd__decap_3
XFILLER_0_4_197 VGND VGND VPWR VPWR sky130_fd_sc_hd__decap_8
Xaccumulator._1856_ accumulator._0831_ accumulator._0950_ VGND VGND VPWR VPWR accumulator._0951_
+ sky130_fd_sc_hd__or2b_1
XFILLER_0_40_273 VGND VGND VPWR VPWR sky130_fd_sc_hd__decap_4
Xaccumulator._1787_ accumulator._0875_ accumulator._0881_ VGND VGND VPWR VPWR accumulator._0882_
+ sky130_fd_sc_hd__or2_1
XFILLER_0_0_381 VGND VGND VPWR VPWR sky130_fd_sc_hd__decap_8
XFILLER_0_67_137 VGND VGND VPWR VPWR sky130_fd_sc_hd__decap_3
Xaccumulator._2339_ accumulator.io_accOut\[29\] accumulator._0371_ accumulator._0389_
+ VGND VGND VPWR VPWR accumulator._0290_ sky130_fd_sc_hd__mux2_1
XFILLER_0_48_19 VGND VGND VPWR VPWR sky130_fd_sc_hd__decap_8
XFILLER_0_64_29 VPWR VGND VPWR VGND sky130_ef_sc_hd__decap_12
XTAP_TAPCELL_ROW_42_441 VGND VPWR sky130_fd_sc_hd__tapvpwrvgnd_1
XFILLER_0_13_55 VGND VGND VPWR VPWR sky130_fd_sc_hd__fill_1
XFILLER_0_54_365 VPWR VGND VPWR VGND sky130_ef_sc_hd__decap_12
Xaccumulator._1572_ accumulator._0665_ accumulator._0666_ VGND VGND VPWR VPWR accumulator._0667_
+ sky130_fd_sc_hd__xor2_4
XFILLER_0_38_85 VPWR VGND VPWR VGND sky130_ef_sc_hd__decap_12
XFILLER_0_38_52 VGND VGND VPWR VPWR sky130_fd_sc_hd__decap_3
Xaccumulator._1710_ accumulator._0379_ accumulator._0694_ VGND VGND VPWR VPWR accumulator._0805_
+ sky130_fd_sc_hd__nand2_1
XFILLER_0_1_167 VGND VGND VPWR VPWR sky130_fd_sc_hd__fill_1
Xaccumulator._1641_ accumulator._0511_ accumulator._0462_ accumulator._0735_ VGND
+ VGND VPWR VPWR accumulator._0736_ sky130_fd_sc_hd__or3_1
Xaccumulator._2124_ accumulator._0044_ VGND VGND VPWR VPWR accumulator._0080_ sky130_fd_sc_hd__clkbuf_4
XTAP_TAPCELL_ROW_65_599 VGND VPWR sky130_fd_sc_hd__tapvpwrvgnd_1
XFILLER_0_54_51 VGND VGND VPWR VPWR sky130_fd_sc_hd__decap_6
XFILLER_0_49_126 VPWR VGND VPWR VGND sky130_ef_sc_hd__decap_12
Xclkbuf_0_clock clock VGND VGND VPWR VPWR clknet_0_clock sky130_fd_sc_hd__clkbuf_16
XPHY_EDGE_ROW_19_Left_87 VGND VGND VPWR VPWR sky130_fd_sc_hd__decap_3
XFILLER_0_64_118 VGND VGND VPWR VPWR sky130_fd_sc_hd__decap_3
XFILLER_0_64_107 VGND VGND VPWR VPWR sky130_fd_sc_hd__decap_4
XFILLER_0_57_181 VGND VGND VPWR VPWR sky130_fd_sc_hd__decap_4
XFILLER_0_49_159 VGND VGND VPWR VPWR sky130_fd_sc_hd__decap_8
Xaccumulator._2055_ accumulator._0535_ accumulator._1138_ VGND VGND VPWR VPWR accumulator._1151_
+ sky130_fd_sc_hd__nand2_1
XFILLER_0_45_321 VPWR VGND VPWR VGND sky130_ef_sc_hd__decap_12
XFILLER_0_60_357 VGND VGND VPWR VPWR sky130_fd_sc_hd__decap_6
Xaccumulator._1908_ accumulator._0782_ accumulator._1002_ VGND VGND VPWR VPWR accumulator._1003_
+ sky130_fd_sc_hd__xnor2_2
Xaccumulator._1839_ accumulator._0876_ accumulator._0877_ VGND VGND VPWR VPWR accumulator._0934_
+ sky130_fd_sc_hd__and2b_1
XFILLER_0_13_262 VGND VGND VPWR VPWR sky130_fd_sc_hd__fill_1
XFILLER_0_48_170 VGND VGND VPWR VPWR sky130_fd_sc_hd__decap_8
XFILLER_0_63_140 VPWR VGND VPWR VGND sky130_ef_sc_hd__decap_12
XFILLER_0_51_335 VGND VGND VPWR VPWR sky130_fd_sc_hd__fill_1
XFILLER_0_51_313 VGND VGND VPWR VPWR sky130_fd_sc_hd__fill_1
XFILLER_0_36_398 VGND VGND VPWR VPWR sky130_fd_sc_hd__decap_3
XscaleAdd._491_ operator.io_outSign VGND VGND VPWR VPWR accumulator.io_inSign sky130_fd_sc_hd__buf_2
XTAP_TAPCELL_ROW_19_279 VGND VPWR sky130_fd_sc_hd__tapvpwrvgnd_1
XFILLER_0_39_192 VPWR VGND VPWR VGND sky130_ef_sc_hd__decap_12
XFILLER_0_40_53 VGND VGND VPWR VPWR sky130_fd_sc_hd__decap_4
XFILLER_0_24_54 VGND VGND VPWR VPWR sky130_fd_sc_hd__decap_3
XFILLER_0_40_97 VGND VGND VPWR VPWR sky130_fd_sc_hd__decap_8
XFILLER_0_40_64 VGND VGND VPWR VPWR sky130_fd_sc_hd__decap_3
XFILLER_0_10_210 VGND VGND VPWR VPWR sky130_fd_sc_hd__decap_3
XFILLER_0_10_232 VPWR VGND VPWR VGND sky130_ef_sc_hd__decap_12
Xaccumulator._1555_ accumulator.io_accOut\[7\] accumulator._0379_ VGND VGND VPWR VPWR
+ accumulator._0650_ sky130_fd_sc_hd__nand2_1
XFILLER_0_4_97 VPWR VGND VPWR VGND sky130_ef_sc_hd__decap_12
XFILLER_0_4_53 VPWR VGND VPWR VGND sky130_ef_sc_hd__decap_12
XFILLER_0_10_265 VGND VGND VPWR VPWR sky130_fd_sc_hd__decap_4
Xaccumulator._1624_ accumulator._0578_ accumulator._0709_ accumulator._0715_ accumulator._0718_
+ accumulator._0637_ VGND VGND VPWR VPWR accumulator._0719_ sky130_fd_sc_hd__o32ai_4
XTAP_TAPCELL_ROW_53_514 VGND VPWR sky130_fd_sc_hd__tapvpwrvgnd_1
Xaccumulator._2107_ accumulator._0061_ accumulator._0062_ accumulator._1166_ accumulator.io_accOut\[1\]
+ VGND VGND VPWR VPWR accumulator._0063_ sky130_fd_sc_hd__a2bb2o_1
XFILLER_0_37_107 VGND VGND VPWR VPWR sky130_fd_sc_hd__fill_2
Xaccumulator._1486_ accumulator._0538_ accumulator._0562_ accumulator._0577_ accumulator._0580_
+ VGND VGND VPWR VPWR accumulator._0581_ sky130_fd_sc_hd__a22o_1
XTAP_TAPCELL_ROW_2_158 VGND VPWR sky130_fd_sc_hd__tapvpwrvgnd_1
Xoperator._13_ operator._00_ VGND VGND VPWR VPWR operator.io_outMant\[0\] sky130_fd_sc_hd__buf_2
Xaccumulator._2038_ net56 accumulator._1131_ accumulator._1132_ VGND VGND VPWR VPWR
+ accumulator._1133_ sky130_fd_sc_hd__a21oi_1
XFILLER_0_33_335 VGND VGND VPWR VPWR sky130_fd_sc_hd__fill_1
XFILLER_0_5_281 VGND VGND VPWR VPWR sky130_fd_sc_hd__decap_8
XFILLER_0_18_398 VGND VGND VPWR VPWR sky130_fd_sc_hd__decap_3
XFILLER_0_24_379 VGND VGND VPWR VPWR sky130_fd_sc_hd__decap_8
XFILLER_0_24_357 VGND VGND VPWR VPWR sky130_fd_sc_hd__decap_6
XscaleAdd._474_ operator.io_outExp\[2\] scaleAdd._168_ VGND VGND VPWR VPWR scaleAdd._169_
+ sky130_fd_sc_hd__xnor2_1
XTAP_TAPCELL_ROW_67_617 VGND VPWR sky130_fd_sc_hd__tapvpwrvgnd_1
XPHY_EDGE_ROW_32_Left_100 VGND VGND VPWR VPWR sky130_fd_sc_hd__decap_3
Xaccumulator._1340_ accumulator._0433_ accumulator._0434_ accumulator._0431_ VGND
+ VGND VPWR VPWR accumulator._0435_ sky130_fd_sc_hd__mux2_1
XFILLER_0_59_232 VGND VGND VPWR VPWR sky130_fd_sc_hd__decap_8
Xaccumulator._1271_ accumulator.io_accOut\[28\] accumulator._0366_ VGND VGND VPWR
+ VPWR accumulator._0368_ sky130_fd_sc_hd__and2_1
XFILLER_0_35_86 VPWR VGND VPWR VGND sky130_ef_sc_hd__decap_12
XFILLER_0_35_42 VGND VGND VPWR VPWR sky130_fd_sc_hd__decap_8
XFILLER_0_19_118 VPWR VGND VPWR VGND sky130_ef_sc_hd__decap_12
XFILLER_0_62_3 VPWR VGND VPWR VGND sky130_ef_sc_hd__decap_12
XFILLER_0_23_390 VGND VGND VPWR VPWR sky130_fd_sc_hd__fill_2
XFILLER_0_2_251 VGND VGND VPWR VPWR sky130_fd_sc_hd__fill_1
Xaccumulator._1538_ accumulator._0606_ accumulator._0607_ accumulator._0632_ VGND
+ VGND VPWR VPWR accumulator._0633_ sky130_fd_sc_hd__a21o_1
Xaccumulator._1469_ accumulator._0426_ accumulator._0483_ accumulator._0442_ VGND
+ VGND VPWR VPWR accumulator._0564_ sky130_fd_sc_hd__a21o_1
Xaccumulator._1607_ accumulator._0563_ accumulator._0700_ accumulator._0701_ accumulator._0514_
+ VGND VGND VPWR VPWR accumulator._0702_ sky130_fd_sc_hd__o211a_1
XFILLER_0_65_279 VGND VGND VPWR VPWR sky130_fd_sc_hd__fill_1
Xclkload0 clknet_2_1__leaf_clock VGND VGND VPWR VPWR clkload0/Y sky130_fd_sc_hd__clkinvlp_2
XTAP_TAPCELL_ROW_21_296 VGND VPWR sky130_fd_sc_hd__tapvpwrvgnd_1
XFILLER_0_18_195 VGND VGND VPWR VPWR sky130_fd_sc_hd__fill_1
XTAP_TAPCELL_ROW_29_352 VGND VPWR sky130_fd_sc_hd__tapvpwrvgnd_1
XTAP_TAPCELL_ROW_12_230 VGND VPWR sky130_fd_sc_hd__tapvpwrvgnd_1
XFILLER_0_21_55 VGND VGND VPWR VPWR sky130_fd_sc_hd__fill_1
XFILLER_0_24_187 VGND VGND VPWR VPWR sky130_fd_sc_hd__decap_8
XFILLER_0_24_165 VGND VGND VPWR VPWR sky130_fd_sc_hd__fill_1
XscaleAdd._457_ net15 net18 VGND VGND VPWR VPWR scaleAdd._153_ sky130_fd_sc_hd__or2_1
X_28_ accumulator.io_accOut\[28\] VGND VGND VPWR VPWR net43 sky130_fd_sc_hd__clkbuf_1
Xaccumulator._2372_ clknet_2_0__leaf_clock accumulator._0017_ VGND VGND VPWR VPWR
+ accumulator.io_accOut\[15\] sky130_fd_sc_hd__dfxtp_1
XFILLER_0_34_7 VGND VGND VPWR VPWR sky130_fd_sc_hd__decap_6
XscaleAdd._388_ scaleAdd._090_ net80 scaleAdd._011_ scaleAdd._091_ VGND VGND VPWR
+ VPWR scaleAdd._092_ sky130_fd_sc_hd__o211a_4
Xaccumulator._1323_ accumulator._0417_ VGND VGND VPWR VPWR accumulator._0418_ sky130_fd_sc_hd__buf_2
XTAP_TAPCELL_ROW_35_388 VGND VPWR sky130_fd_sc_hd__tapvpwrvgnd_1
XFILLER_0_7_332 VGND VGND VPWR VPWR sky130_fd_sc_hd__decap_4
Xaccumulator._1185_ accumulator.io_inExp\[3\] accumulator._0075_ VGND VGND VPWR VPWR
+ accumulator._0085_ sky130_fd_sc_hd__or2_1
Xaccumulator._1254_ accumulator._0350_ accumulator._0318_ VGND VGND VPWR VPWR accumulator._0351_
+ sky130_fd_sc_hd__or2_1
XFILLER_0_62_216 VGND VGND VPWR VPWR sky130_fd_sc_hd__fill_1
XFILLER_0_7_343 VGND VGND VPWR VPWR sky130_fd_sc_hd__decap_8
XFILLER_0_15_165 VGND VGND VPWR VPWR sky130_fd_sc_hd__decap_3
XFILLER_0_30_157 VGND VGND VPWR VPWR sky130_fd_sc_hd__fill_1
XFILLER_0_11_393 VGND VGND VPWR VPWR sky130_fd_sc_hd__decap_8
XFILLER_0_53_205 VGND VGND VPWR VPWR sky130_fd_sc_hd__fill_1
XPHY_EDGE_ROW_7_Left_75 VGND VGND VPWR VPWR sky130_fd_sc_hd__decap_3
XFILLER_0_67_29 VPWR VGND VPWR VGND sky130_ef_sc_hd__decap_12
XFILLER_0_61_293 VPWR VGND VPWR VGND sky130_ef_sc_hd__decap_12
XscaleAdd._311_ scaleAdd._228_ scaleAdd._226_ VGND VGND VPWR VPWR scaleAdd._018_ sky130_fd_sc_hd__or2_4
XscaleAdd._242_ scaleAdd._181_ scaleAdd._185_ scaleAdd._184_ accumulator.io_inMant\[0\]
+ VGND VGND VPWR VPWR scaleAdd._188_ sky130_fd_sc_hd__a22oi_1
XFILLER_0_16_55 VGND VGND VPWR VPWR sky130_fd_sc_hd__decap_6
Xaccumulator._1941_ accumulator._1033_ accumulator._1035_ VGND VGND VPWR VPWR accumulator._1036_
+ sky130_fd_sc_hd__nor2_1
XFILLER_0_44_249 VGND VGND VPWR VPWR sky130_fd_sc_hd__decap_3
XFILLER_0_44_238 VGND VGND VPWR VPWR sky130_fd_sc_hd__decap_4
Xaccumulator._1872_ accumulator._0841_ accumulator._0966_ VGND VGND VPWR VPWR accumulator._0967_
+ sky130_fd_sc_hd__xnor2_2
XTAP_TAPCELL_ROW_32_369 VGND VPWR sky130_fd_sc_hd__tapvpwrvgnd_1
XFILLER_0_57_73 VGND VGND VPWR VPWR sky130_fd_sc_hd__decap_4
XFILLER_0_57_51 VGND VGND VPWR VPWR sky130_fd_sc_hd__decap_4
XTAP_TAPCELL_ROW_48_480 VGND VPWR sky130_fd_sc_hd__tapvpwrvgnd_1
Xaccumulator._2355_ clknet_2_0__leaf_clock accumulator._0000_ VGND VGND VPWR VPWR
+ accumulator.io_accOut\[31\] sky130_fd_sc_hd__dfxtp_2
Xaccumulator._2286_ accumulator._0340_ accumulator._0348_ VGND VGND VPWR VPWR accumulator._0237_
+ sky130_fd_sc_hd__nor2_1
XFILLER_0_25_3 VGND VGND VPWR VPWR sky130_fd_sc_hd__decap_8
Xaccumulator._1306_ accumulator._0347_ accumulator._0399_ net74 accumulator._0400_
+ VGND VGND VPWR VPWR accumulator._0401_ sky130_fd_sc_hd__and4_1
Xaccumulator._1237_ net67 accumulator._0125_ accumulator._0085_ accumulator._0331_
+ accumulator._0095_ VGND VGND VPWR VPWR accumulator._0334_ sky130_fd_sc_hd__a311o_1
XFILLER_0_43_260 VGND VGND VPWR VPWR sky130_fd_sc_hd__decap_6
Xoutput46 net46 VGND VGND VPWR VPWR io_accOut[30] sky130_fd_sc_hd__buf_2
Xoutput24 net24 VGND VGND VPWR VPWR io_accOut[10] sky130_fd_sc_hd__buf_2
Xoutput35 net35 VGND VGND VPWR VPWR io_accOut[20] sky130_fd_sc_hd__buf_2
XFILLER_0_3_390 VGND VGND VPWR VPWR sky130_fd_sc_hd__fill_2
XFILLER_0_66_363 VGND VGND VPWR VPWR sky130_fd_sc_hd__fill_1
XPHY_EDGE_ROW_19_Right_19 VGND VGND VPWR VPWR sky130_fd_sc_hd__decap_3
XFILLER_0_19_290 VPWR VGND VPWR VGND sky130_ef_sc_hd__decap_12
XPHY_EDGE_ROW_28_Right_28 VGND VGND VPWR VPWR sky130_fd_sc_hd__decap_3
XFILLER_0_27_10 VGND VGND VPWR VPWR sky130_fd_sc_hd__fill_2
Xaccumulator._2140_ accumulator._0056_ accumulator._0094_ net104 VGND VGND VPWR VPWR
+ accumulator._0096_ sky130_fd_sc_hd__mux2_4
XPHY_EDGE_ROW_37_Right_37 VGND VGND VPWR VPWR sky130_fd_sc_hd__decap_3
XTAP_TAPCELL_ROW_37_406 VGND VPWR sky130_fd_sc_hd__tapvpwrvgnd_1
XFILLER_0_57_385 VGND VGND VPWR VPWR sky130_fd_sc_hd__decap_6
Xaccumulator._2071_ accumulator._1089_ accumulator._1086_ VGND VGND VPWR VPWR accumulator._1168_
+ sky130_fd_sc_hd__xnor2_1
XTAP_TAPCELL_ROW_45_461 VGND VPWR sky130_fd_sc_hd__tapvpwrvgnd_1
XFILLER_0_17_205 VGND VGND VPWR VPWR sky130_fd_sc_hd__decap_6
XPHY_EDGE_ROW_46_Right_46 VGND VGND VPWR VPWR sky130_fd_sc_hd__decap_3
Xaccumulator._1924_ accumulator._0932_ accumulator._1018_ accumulator._0535_ VGND
+ VGND VPWR VPWR accumulator._1019_ sky130_fd_sc_hd__mux2_4
Xaccumulator._1855_ accumulator._0949_ accumulator._0832_ VGND VGND VPWR VPWR accumulator._0950_
+ sky130_fd_sc_hd__xnor2_2
XFILLER_0_25_293 VGND VGND VPWR VPWR sky130_fd_sc_hd__decap_3
XPHY_EDGE_ROW_55_Right_55 VGND VGND VPWR VPWR sky130_fd_sc_hd__decap_3
Xaccumulator._1786_ accumulator._0878_ accumulator._0880_ VGND VGND VPWR VPWR accumulator._0881_
+ sky130_fd_sc_hd__nand2_2
XFILLER_0_0_393 VGND VGND VPWR VPWR sky130_fd_sc_hd__decap_8
XFILLER_0_7_97 VGND VGND VPWR VPWR sky130_fd_sc_hd__decap_8
Xaccumulator._2269_ accumulator._0204_ accumulator._0220_ accumulator._0080_ VGND
+ VGND VPWR VPWR accumulator._0221_ sky130_fd_sc_hd__mux2_1
Xaccumulator._2338_ accumulator._0278_ accumulator._0274_ accumulator._0287_ accumulator._0288_
+ VGND VGND VPWR VPWR accumulator._0289_ sky130_fd_sc_hd__a31o_1
XPHY_EDGE_ROW_64_Right_64 VGND VGND VPWR VPWR sky130_fd_sc_hd__decap_3
XFILLER_0_31_252 VPWR VGND VPWR VGND sky130_ef_sc_hd__decap_12
XTAP_TAPCELL_ROW_42_442 VGND VPWR sky130_fd_sc_hd__tapvpwrvgnd_1
XFILLER_0_54_377 VPWR VGND VPWR VGND sky130_ef_sc_hd__decap_12
XFILLER_0_1_113 VPWR VGND VPWR VGND sky130_ef_sc_hd__decap_12
Xaccumulator._1571_ accumulator.io_accOut\[6\] accumulator._0379_ VGND VGND VPWR VPWR
+ accumulator._0666_ sky130_fd_sc_hd__nand2_2
XFILLER_0_38_97 VPWR VGND VPWR VGND sky130_ef_sc_hd__decap_12
XFILLER_0_38_75 VGND VGND VPWR VPWR sky130_fd_sc_hd__decap_8
Xaccumulator._1640_ accumulator.io_accOut\[1\] accumulator._0498_ accumulator._0653_
+ accumulator._0734_ VGND VGND VPWR VPWR accumulator._0735_ sky130_fd_sc_hd__a31o_1
Xaccumulator._2123_ accumulator._1149_ accumulator._0078_ net101 VGND VGND VPWR VPWR
+ accumulator._0079_ sky130_fd_sc_hd__mux2_2
XFILLER_0_49_138 VGND VGND VPWR VPWR sky130_fd_sc_hd__decap_6
XFILLER_0_45_333 VGND VGND VPWR VPWR sky130_fd_sc_hd__decap_3
Xaccumulator._2054_ accumulator._0741_ accumulator._0811_ VGND VGND VPWR VPWR accumulator._1150_
+ sky130_fd_sc_hd__and2_1
Xaccumulator._1838_ accumulator._0866_ accumulator._0875_ VGND VGND VPWR VPWR accumulator._0933_
+ sky130_fd_sc_hd__and2_1
Xaccumulator._1907_ accumulator._0918_ accumulator._0847_ accumulator._1001_ accumulator._0771_
+ VGND VGND VPWR VPWR accumulator._1002_ sky130_fd_sc_hd__o22a_1
Xaccumulator._1769_ accumulator._0862_ accumulator._0863_ VGND VGND VPWR VPWR accumulator._0864_
+ sky130_fd_sc_hd__nor2_2
XTAP_TAPCELL_ROW_5_178 VGND VPWR sky130_fd_sc_hd__tapvpwrvgnd_1
XFILLER_0_48_193 VGND VGND VPWR VPWR sky130_fd_sc_hd__decap_3
XFILLER_0_63_185 VGND VGND VPWR VPWR sky130_fd_sc_hd__decap_6
XFILLER_0_63_163 VGND VGND VPWR VPWR sky130_fd_sc_hd__fill_1
XFILLER_0_63_152 VGND VGND VPWR VPWR sky130_fd_sc_hd__decap_4
XscaleAdd._490_ accumulator.io_inExp\[6\] VGND VGND VPWR VPWR accumulator.io_inExp\[5\]
+ sky130_fd_sc_hd__clkbuf_1
XPHY_EDGE_ROW_20_Left_88 VGND VGND VPWR VPWR sky130_fd_sc_hd__decap_3
XFILLER_0_54_141 VGND VGND VPWR VPWR sky130_fd_sc_hd__decap_4
XFILLER_0_46_119 VGND VGND VPWR VPWR sky130_fd_sc_hd__fill_2
XFILLER_0_40_21 VGND VGND VPWR VPWR sky130_fd_sc_hd__decap_6
XFILLER_0_27_377 VGND VGND VPWR VPWR sky130_fd_sc_hd__decap_4
XFILLER_0_27_333 VGND VGND VPWR VPWR sky130_fd_sc_hd__decap_3
XFILLER_0_6_249 VGND VGND VPWR VPWR sky130_fd_sc_hd__decap_3
XFILLER_0_2_400 VGND VGND VPWR VPWR sky130_fd_sc_hd__fill_1
XFILLER_0_10_244 VGND VGND VPWR VPWR sky130_fd_sc_hd__decap_8
Xaccumulator._1623_ accumulator._0539_ accumulator._0716_ accumulator._0717_ VGND
+ VGND VPWR VPWR accumulator._0718_ sky130_fd_sc_hd__a21oi_2
XFILLER_0_65_84 VGND VGND VPWR VPWR sky130_fd_sc_hd__fill_2
XFILLER_0_65_51 VGND VGND VPWR VPWR sky130_fd_sc_hd__decap_4
XFILLER_0_4_65 VPWR VGND VPWR VGND sky130_ef_sc_hd__decap_12
XTAP_TAPCELL_ROW_2_159 VGND VPWR sky130_fd_sc_hd__tapvpwrvgnd_1
Xoperator._12_ net5 net1 VGND VGND VPWR VPWR operator._00_ sky130_fd_sc_hd__and2_1
Xaccumulator._1554_ accumulator._0635_ accumulator._0637_ accumulator._0648_ accumulator._0578_
+ VGND VGND VPWR VPWR accumulator._0649_ sky130_fd_sc_hd__o22a_1
Xaccumulator._1485_ accumulator._0578_ accumulator._0579_ VGND VGND VPWR VPWR accumulator._0580_
+ sky130_fd_sc_hd__nor2_1
XTAP_TAPCELL_ROW_61_570 VGND VPWR sky130_fd_sc_hd__tapvpwrvgnd_1
Xaccumulator._2106_ accumulator._0383_ accumulator._1092_ VGND VGND VPWR VPWR accumulator._0062_
+ sky130_fd_sc_hd__nand2_2
XTAP_TAPCELL_ROW_53_515 VGND VPWR sky130_fd_sc_hd__tapvpwrvgnd_1
Xaccumulator._2037_ accumulator._0816_ net56 VGND VGND VPWR VPWR accumulator._1132_
+ sky130_fd_sc_hd__nor2_1
XFILLER_0_18_322 VPWR VGND VPWR VGND sky130_ef_sc_hd__decap_12
XFILLER_0_60_133 VGND VGND VPWR VPWR sky130_fd_sc_hd__decap_6
XFILLER_0_33_369 VPWR VGND VPWR VGND sky130_ef_sc_hd__decap_12
XFILLER_0_18_355 VGND VGND VPWR VPWR sky130_fd_sc_hd__decap_8
XFILLER_0_41_391 VGND VGND VPWR VPWR sky130_fd_sc_hd__fill_1
XFILLER_0_36_141 VPWR VGND VPWR VGND sky130_ef_sc_hd__decap_12
XFILLER_0_36_130 VGND VGND VPWR VPWR sky130_fd_sc_hd__decap_8
XFILLER_0_51_188 VPWR VGND VPWR VGND sky130_ef_sc_hd__decap_12
XFILLER_0_51_177 VGND VGND VPWR VPWR sky130_fd_sc_hd__fill_1
XscaleAdd._473_ scaleAdd._155_ scaleAdd._167_ VGND VGND VPWR VPWR scaleAdd._168_ sky130_fd_sc_hd__xnor2_1
XTAP_TAPCELL_ROW_67_618 VGND VPWR sky130_fd_sc_hd__tapvpwrvgnd_1
XFILLER_0_19_55 VGND VGND VPWR VPWR sky130_fd_sc_hd__fill_1
XFILLER_0_59_277 VGND VGND VPWR VPWR sky130_fd_sc_hd__decap_3
XFILLER_0_59_211 VPWR VGND VPWR VGND sky130_ef_sc_hd__decap_12
Xaccumulator._1270_ accumulator.io_accOut\[28\] accumulator._0366_ VGND VGND VPWR
+ VPWR accumulator._0367_ sky130_fd_sc_hd__or2_1
XTAP_TAPCELL_ROW_15_250 VGND VPWR sky130_fd_sc_hd__tapvpwrvgnd_1
XFILLER_0_51_86 VGND VGND VPWR VPWR sky130_fd_sc_hd__decap_8
XFILLER_0_30_328 VGND VGND VPWR VPWR sky130_fd_sc_hd__fill_1
XFILLER_0_15_303 VGND VGND VPWR VPWR sky130_fd_sc_hd__decap_8
XFILLER_0_55_3 VPWR VGND VPWR VGND sky130_ef_sc_hd__decap_12
XFILLER_0_23_380 VGND VGND VPWR VPWR sky130_fd_sc_hd__fill_1
XFILLER_0_2_285 VGND VGND VPWR VPWR sky130_fd_sc_hd__fill_1
Xaccumulator._1606_ accumulator._0671_ accumulator._0672_ accumulator._0500_ VGND
+ VGND VPWR VPWR accumulator._0701_ sky130_fd_sc_hd__a21o_1
Xaccumulator._1537_ accumulator._0630_ accumulator._0631_ VGND VGND VPWR VPWR accumulator._0632_
+ sky130_fd_sc_hd__and2_1
Xaccumulator._1399_ accumulator._0490_ accumulator._0493_ accumulator._0442_ VGND
+ VGND VPWR VPWR accumulator._0494_ sky130_fd_sc_hd__a21o_1
Xaccumulator._1468_ accumulator._0462_ VGND VGND VPWR VPWR accumulator._0563_ sky130_fd_sc_hd__clkbuf_4
Xclkload1 clknet_2_2__leaf_clock VGND VGND VPWR VPWR clkload1/Y sky130_fd_sc_hd__clkinvlp_4
XFILLER_0_21_317 VPWR VGND VPWR VGND sky130_ef_sc_hd__decap_12
XFILLER_0_14_391 VGND VGND VPWR VPWR sky130_fd_sc_hd__decap_8
XTAP_TAPCELL_ROW_12_231 VGND VPWR sky130_fd_sc_hd__tapvpwrvgnd_1
XFILLER_0_12_306 VGND VGND VPWR VPWR sky130_fd_sc_hd__fill_2
XscaleAdd._456_ scaleAdd._152_ VGND VGND VPWR VPWR accumulator.io_inExp\[0\] sky130_fd_sc_hd__buf_1
XscaleAdd._387_ scaleAdd._192_ net13 VGND VGND VPWR VPWR scaleAdd._091_ sky130_fd_sc_hd__or2b_1
XFILLER_0_20_350 VPWR VGND VPWR VGND sky130_ef_sc_hd__decap_12
Xaccumulator._2371_ clknet_2_1__leaf_clock accumulator._0016_ VGND VGND VPWR VPWR
+ accumulator.io_accOut\[14\] sky130_fd_sc_hd__dfxtp_1
X_27_ accumulator.io_accOut\[27\] VGND VGND VPWR VPWR net42 sky130_fd_sc_hd__clkbuf_1
XFILLER_0_1_55 VGND VGND VPWR VPWR sky130_fd_sc_hd__fill_1
Xaccumulator._1253_ accumulator.io_inExp\[0\] accumulator._0311_ VGND VGND VPWR VPWR
+ accumulator._0350_ sky130_fd_sc_hd__nor2_1
Xaccumulator._1322_ net75 accumulator._0400_ VGND VGND VPWR VPWR accumulator._0417_
+ sky130_fd_sc_hd__nand2_1
XFILLER_0_62_96 VPWR VGND VPWR VGND sky130_ef_sc_hd__decap_12
XFILLER_0_62_85 VGND VGND VPWR VPWR sky130_fd_sc_hd__decap_6
XFILLER_0_62_41 VPWR VGND VPWR VGND sky130_ef_sc_hd__decap_12
XFILLER_0_47_225 VPWR VGND VPWR VGND sky130_ef_sc_hd__decap_12
XFILLER_0_47_203 VPWR VGND VPWR VGND sky130_ef_sc_hd__decap_12
XTAP_TAPCELL_ROW_35_389 VGND VPWR sky130_fd_sc_hd__tapvpwrvgnd_1
XPHY_EDGE_ROW_23_Left_91 VGND VGND VPWR VPWR sky130_fd_sc_hd__decap_3
Xaccumulator._1184_ accumulator._0065_ net88 VGND VGND VPWR VPWR accumulator._0075_
+ sky130_fd_sc_hd__or2_4
XFILLER_0_15_111 VGND VGND VPWR VPWR sky130_fd_sc_hd__fill_1
XPHY_EDGE_ROW_51_Left_119 VGND VGND VPWR VPWR sky130_fd_sc_hd__decap_3
XPHY_EDGE_ROW_60_Left_128 VGND VGND VPWR VPWR sky130_fd_sc_hd__decap_3
XFILLER_0_21_169 VGND VGND VPWR VPWR sky130_fd_sc_hd__fill_2
XFILLER_0_21_158 VGND VGND VPWR VPWR sky130_fd_sc_hd__fill_1
XscaleAdd._310_ scaleAdd._016_ scaleAdd._009_ VGND VGND VPWR VPWR scaleAdd._017_ sky130_fd_sc_hd__xnor2_2
XscaleAdd._241_ scaleAdd._181_ scaleAdd._184_ accumulator.io_inMant\[0\] VGND VGND
+ VPWR VPWR scaleAdd._187_ sky130_fd_sc_hd__and3_1
XFILLER_0_29_225 VPWR VGND VPWR VGND sky130_ef_sc_hd__decap_12
XFILLER_0_8_108 VGND VGND VPWR VPWR sky130_fd_sc_hd__fill_2
Xaccumulator._1940_ accumulator._0996_ accumulator._1034_ VGND VGND VPWR VPWR accumulator._1035_
+ sky130_fd_sc_hd__xor2_2
XFILLER_0_52_250 VGND VGND VPWR VPWR sky130_fd_sc_hd__fill_2
Xaccumulator._1871_ accumulator._0534_ accumulator._0964_ accumulator._0965_ VGND
+ VGND VPWR VPWR accumulator._0966_ sky130_fd_sc_hd__a21bo_1
XFILLER_0_12_114 VGND VGND VPWR VPWR sky130_fd_sc_hd__fill_1
XscaleAdd._439_ scaleAdd._136_ scaleAdd._139_ VGND VGND VPWR VPWR scaleAdd._140_ sky130_fd_sc_hd__xnor2_1
XFILLER_0_20_191 VGND VGND VPWR VPWR sky130_fd_sc_hd__fill_1
XFILLER_0_67_309 VPWR VGND VPWR VGND sky130_ef_sc_hd__decap_12
Xaccumulator._2354_ net112 net21 accumulator._0034_ accumulator._0304_ VGND VGND VPWR
+ VPWR accumulator._0033_ sky130_fd_sc_hd__o211a_1
Xaccumulator._2285_ accumulator._0034_ accumulator._0235_ accumulator._0236_ accumulator._0118_
+ VGND VGND VPWR VPWR accumulator._0025_ sky130_fd_sc_hd__o211a_1
XTAP_TAPCELL_ROW_48_481 VGND VPWR sky130_fd_sc_hd__tapvpwrvgnd_1
XTAP_TAPCELL_ROW_23_304 VGND VPWR sky130_fd_sc_hd__tapvpwrvgnd_1
Xaccumulator._1236_ accumulator._0328_ accumulator._0332_ VGND VGND VPWR VPWR accumulator._0333_
+ sky130_fd_sc_hd__xor2_1
XFILLER_0_18_3 VPWR VGND VPWR VGND sky130_ef_sc_hd__decap_12
Xaccumulator._1305_ accumulator._0351_ accumulator._0340_ accumulator.io_accOut\[23\]
+ VGND VGND VPWR VPWR accumulator._0400_ sky130_fd_sc_hd__o21ai_1
XFILLER_0_28_291 VPWR VGND VPWR VGND sky130_ef_sc_hd__decap_12
Xoutput47 net47 VGND VGND VPWR VPWR io_accOut[31] sky130_fd_sc_hd__clkbuf_4
Xoutput25 net25 VGND VGND VPWR VPWR io_accOut[11] sky130_fd_sc_hd__buf_2
Xoutput36 net36 VGND VGND VPWR VPWR io_accOut[21] sky130_fd_sc_hd__buf_2
XFILLER_0_58_309 VPWR VGND VPWR VGND sky130_ef_sc_hd__decap_12
XFILLER_0_27_33 VGND VGND VPWR VPWR sky130_fd_sc_hd__decap_8
XFILLER_0_27_22 VGND VGND VPWR VPWR sky130_fd_sc_hd__decap_3
Xaccumulator._2070_ accumulator._1165_ accumulator._1067_ accumulator._1081_ accumulator._1065_
+ VGND VGND VPWR VPWR accumulator._1167_ sky130_fd_sc_hd__a211o_1
XTAP_TAPCELL_ROW_45_462 VGND VPWR sky130_fd_sc_hd__tapvpwrvgnd_1
XTAP_TAPCELL_ROW_37_407 VGND VPWR sky130_fd_sc_hd__tapvpwrvgnd_1
XFILLER_0_27_55 VGND VGND VPWR VPWR sky130_fd_sc_hd__fill_1
Xaccumulator._1923_ accumulator._0864_ accumulator._1012_ accumulator._0869_ VGND
+ VGND VPWR VPWR accumulator._1018_ sky130_fd_sc_hd__o21ba_1
Xaccumulator._1854_ accumulator._0533_ accumulator._0810_ accumulator._0831_ accumulator._0948_
+ VGND VGND VPWR VPWR accumulator._0949_ sky130_fd_sc_hd__a31o_1
Xaccumulator._1785_ accumulator._0879_ VGND VGND VPWR VPWR accumulator._0880_ sky130_fd_sc_hd__inv_2
XFILLER_0_4_188 VGND VGND VPWR VPWR sky130_fd_sc_hd__decap_8
Xaccumulator._2268_ accumulator._1083_ accumulator._0047_ VGND VGND VPWR VPWR accumulator._0220_
+ sky130_fd_sc_hd__nor2_1
Xaccumulator._2199_ accumulator._0151_ accumulator._0152_ accumulator._0042_ VGND
+ VGND VPWR VPWR accumulator._0153_ sky130_fd_sc_hd__mux2_4
Xaccumulator._2337_ accumulator._0269_ accumulator._0280_ accumulator._0286_ VGND
+ VGND VPWR VPWR accumulator._0288_ sky130_fd_sc_hd__a21oi_1
Xaccumulator._1219_ net66 accumulator._0125_ accumulator._0085_ VGND VGND VPWR VPWR
+ accumulator._0316_ sky130_fd_sc_hd__nand3_2
XFILLER_0_16_261 VGND VGND VPWR VPWR sky130_fd_sc_hd__fill_2
XFILLER_0_31_264 VPWR VGND VPWR VGND sky130_ef_sc_hd__decap_12
XFILLER_0_7_3 VPWR VGND VPWR VGND sky130_ef_sc_hd__decap_12
XFILLER_0_58_139 VGND VGND VPWR VPWR sky130_fd_sc_hd__fill_1
XFILLER_0_66_150 VGND VGND VPWR VPWR sky130_fd_sc_hd__decap_6
XFILLER_0_54_389 VGND VGND VPWR VPWR sky130_fd_sc_hd__decap_8
XFILLER_0_54_356 VGND VGND VPWR VPWR sky130_fd_sc_hd__decap_8
XTAP_TAPCELL_ROW_42_443 VGND VPWR sky130_fd_sc_hd__tapvpwrvgnd_1
XFILLER_0_13_57 VPWR VGND VPWR VGND sky130_ef_sc_hd__decap_12
XFILLER_0_22_253 VGND VGND VPWR VPWR sky130_fd_sc_hd__fill_1
XFILLER_0_1_125 VPWR VGND VPWR VGND sky130_ef_sc_hd__decap_12
XFILLER_0_1_169 VPWR VGND VPWR VGND sky130_ef_sc_hd__decap_12
Xaccumulator._1570_ accumulator._0586_ accumulator._0660_ accumulator._0664_ VGND
+ VGND VPWR VPWR accumulator._0665_ sky130_fd_sc_hd__o21a_2
Xaccumulator._2053_ accumulator._1103_ VGND VGND VPWR VPWR accumulator._1149_ sky130_fd_sc_hd__inv_2
Xaccumulator._2122_ accumulator._1107_ VGND VGND VPWR VPWR accumulator._0078_ sky130_fd_sc_hd__inv_2
XFILLER_0_9_225 VGND VGND VPWR VPWR sky130_fd_sc_hd__decap_6
XFILLER_0_45_345 VGND VGND VPWR VPWR sky130_fd_sc_hd__fill_2
XFILLER_0_13_231 VGND VGND VPWR VPWR sky130_fd_sc_hd__fill_1
Xaccumulator._1906_ accumulator._0772_ accumulator._0583_ accumulator._0767_ accumulator._0918_
+ VGND VGND VPWR VPWR accumulator._1001_ sky130_fd_sc_hd__o31ai_1
Xaccumulator._1837_ accumulator._0926_ accumulator._0927_ accumulator._0928_ accumulator._0931_
+ VGND VGND VPWR VPWR accumulator._0932_ sky130_fd_sc_hd__a211o_1
Xaccumulator._1768_ accumulator._0858_ accumulator._0861_ VGND VGND VPWR VPWR accumulator._0863_
+ sky130_fd_sc_hd__and2_1
XFILLER_0_13_275 VGND VGND VPWR VPWR sky130_fd_sc_hd__fill_2
XTAP_TAPCELL_ROW_56_535 VGND VPWR sky130_fd_sc_hd__tapvpwrvgnd_1
Xaccumulator._1699_ accumulator._0769_ accumulator._0770_ VGND VGND VPWR VPWR accumulator._0794_
+ sky130_fd_sc_hd__or2b_1
XTAP_TAPCELL_ROW_5_179 VGND VPWR sky130_fd_sc_hd__tapvpwrvgnd_1
XFILLER_0_54_197 VPWR VGND VPWR VGND sky130_ef_sc_hd__decap_12
XFILLER_0_27_345 VGND VGND VPWR VPWR sky130_fd_sc_hd__fill_1
XFILLER_0_49_64 VGND VGND VPWR VPWR sky130_fd_sc_hd__decap_3
Xaccumulator._1622_ accumulator._0576_ accumulator._0421_ accumulator._0525_ VGND
+ VGND VPWR VPWR accumulator._0717_ sky130_fd_sc_hd__and3_1
Xoperator._11_ net8 net4 VGND VGND VPWR VPWR operator.io_outSign sky130_fd_sc_hd__xor2_1
XFILLER_0_4_77 VGND VGND VPWR VPWR sky130_fd_sc_hd__decap_6
Xaccumulator._1484_ accumulator._0412_ VGND VGND VPWR VPWR accumulator._0579_ sky130_fd_sc_hd__clkbuf_4
Xaccumulator._1553_ accumulator._0644_ accumulator._0647_ VGND VGND VPWR VPWR accumulator._0648_
+ sky130_fd_sc_hd__nand2_1
XTAP_TAPCELL_ROW_61_571 VGND VPWR sky130_fd_sc_hd__tapvpwrvgnd_1
Xaccumulator._2105_ accumulator._0056_ accumulator._0059_ accumulator._0060_ VGND
+ VGND VPWR VPWR accumulator._0061_ sky130_fd_sc_hd__mux2_1
XTAP_TAPCELL_ROW_53_516 VGND VPWR sky130_fd_sc_hd__tapvpwrvgnd_1
Xaccumulator._2036_ accumulator._1130_ VGND VGND VPWR VPWR accumulator._1131_ sky130_fd_sc_hd__inv_2
XTAP_TAPCELL_ROW_18_270 VGND VPWR sky130_fd_sc_hd__tapvpwrvgnd_1
XFILLER_0_18_334 VGND VGND VPWR VPWR sky130_fd_sc_hd__decap_4
XFILLER_0_18_345 VGND VGND VPWR VPWR sky130_fd_sc_hd__decap_4
XFILLER_0_5_261 VPWR VGND VPWR VGND sky130_ef_sc_hd__decap_12
XFILLER_0_36_197 VPWR VGND VPWR VGND sky130_ef_sc_hd__decap_12
XFILLER_0_36_153 VPWR VGND VPWR VGND sky130_ef_sc_hd__decap_12
XFILLER_0_24_304 VGND VGND VPWR VPWR sky130_fd_sc_hd__decap_4
XscaleAdd._472_ scaleAdd._153_ scaleAdd._166_ VGND VGND VPWR VPWR scaleAdd._167_ sky130_fd_sc_hd__xor2_1
XTAP_TAPCELL_ROW_67_619 VGND VPWR sky130_fd_sc_hd__tapvpwrvgnd_1
XFILLER_0_35_11 VGND VGND VPWR VPWR sky130_fd_sc_hd__fill_1
XFILLER_0_19_67 VGND VGND VPWR VPWR sky130_fd_sc_hd__fill_1
XFILLER_0_19_78 VGND VGND VPWR VPWR sky130_fd_sc_hd__decap_6
XFILLER_0_59_289 VGND VGND VPWR VPWR sky130_fd_sc_hd__decap_3
XFILLER_0_59_256 VGND VGND VPWR VPWR sky130_fd_sc_hd__decap_3
XFILLER_0_59_223 VGND VGND VPWR VPWR sky130_fd_sc_hd__fill_1
XFILLER_0_51_43 VPWR VGND VPWR VGND sky130_ef_sc_hd__decap_12
XTAP_TAPCELL_ROW_15_251 VGND VPWR sky130_fd_sc_hd__tapvpwrvgnd_1
XFILLER_0_42_134 VGND VGND VPWR VPWR sky130_fd_sc_hd__decap_6
XFILLER_0_2_253 VGND VGND VPWR VPWR sky130_fd_sc_hd__decap_6
XFILLER_0_15_359 VGND VGND VPWR VPWR sky130_fd_sc_hd__fill_1
XFILLER_0_48_3 VGND VGND VPWR VPWR sky130_fd_sc_hd__decap_8
Xaccumulator._1536_ accumulator.io_accOut\[8\] accumulator._0619_ accumulator._0387_
+ VGND VGND VPWR VPWR accumulator._0631_ sky130_fd_sc_hd__mux2_1
Xaccumulator._1605_ accumulator._0442_ accumulator._0698_ accumulator._0699_ VGND
+ VGND VPWR VPWR accumulator._0700_ sky130_fd_sc_hd__a21o_1
Xaccumulator._1398_ accumulator.io_accOut\[17\] accumulator._0492_ net59 VGND VGND
+ VPWR VPWR accumulator._0493_ sky130_fd_sc_hd__mux2_4
Xaccumulator._1467_ accumulator._0539_ accumulator._0553_ accumulator._0561_ VGND
+ VGND VPWR VPWR accumulator._0562_ sky130_fd_sc_hd__a21o_1
XFILLER_0_65_237 VPWR VGND VPWR VGND sky130_ef_sc_hd__decap_12
Xclkload2 clknet_2_3__leaf_clock VGND VGND VPWR VPWR clkload2/Y sky130_fd_sc_hd__clkinv_1
Xaccumulator._2019_ accumulator._1105_ accumulator._1104_ accumulator._0946_ VGND
+ VGND VPWR VPWR accumulator._1114_ sky130_fd_sc_hd__a21o_1
XFILLER_0_33_123 VPWR VGND VPWR VGND sky130_ef_sc_hd__decap_12
XFILLER_0_18_197 VPWR VGND VPWR VGND sky130_ef_sc_hd__decap_12
XFILLER_0_33_156 VPWR VGND VPWR VGND sky130_ef_sc_hd__decap_12
XFILLER_0_21_329 VGND VGND VPWR VPWR sky130_fd_sc_hd__decap_6
XFILLER_0_56_215 VGND VGND VPWR VPWR sky130_fd_sc_hd__fill_2
XFILLER_0_24_101 VGND VGND VPWR VPWR sky130_fd_sc_hd__fill_1
XTAP_TAPCELL_ROW_12_232 VGND VPWR sky130_fd_sc_hd__tapvpwrvgnd_1
XscaleAdd._455_ scaleAdd._150_ scaleAdd._151_ VGND VGND VPWR VPWR scaleAdd._152_ sky130_fd_sc_hd__and2_1
XscaleAdd._386_ scaleAdd._192_ scaleAdd._070_ scaleAdd._071_ VGND VGND VPWR VPWR scaleAdd._090_
+ sky130_fd_sc_hd__nand3_1
XFILLER_0_20_362 VGND VGND VPWR VPWR sky130_fd_sc_hd__fill_2
XFILLER_0_62_53 VGND VGND VPWR VPWR sky130_fd_sc_hd__decap_4
Xaccumulator._2370_ clknet_2_1__leaf_clock accumulator._0015_ VGND VGND VPWR VPWR
+ accumulator.io_accOut\[13\] sky130_fd_sc_hd__dfxtp_1
X_26_ accumulator.io_accOut\[26\] VGND VGND VPWR VPWR net41 sky130_fd_sc_hd__clkbuf_1
Xaccumulator._1183_ accumulator.io_inMant\[9\] accumulator.io_inMant\[8\] accumulator.io_inMant\[10\]
+ accumulator.io_inMant\[11\] VGND VGND VPWR VPWR accumulator._0065_ sky130_fd_sc_hd__or4_2
Xaccumulator._1321_ net69 accumulator._0414_ accumulator._0415_ VGND VGND VPWR VPWR
+ accumulator._0416_ sky130_fd_sc_hd__or3b_4
Xaccumulator._1252_ accumulator.io_accOut\[24\] accumulator._0348_ accumulator._0339_
+ VGND VGND VPWR VPWR accumulator._0349_ sky130_fd_sc_hd__or3_4
XFILLER_0_55_270 VGND VGND VPWR VPWR sky130_fd_sc_hd__fill_1
XFILLER_0_47_248 VGND VGND VPWR VPWR sky130_fd_sc_hd__decap_8
XFILLER_0_47_215 VGND VGND VPWR VPWR sky130_fd_sc_hd__decap_3
XFILLER_0_15_189 VGND VGND VPWR VPWR sky130_fd_sc_hd__decap_3
Xhold47 accumulator.io_accOut\[12\] VGND VGND VPWR VPWR net105 sky130_fd_sc_hd__dlygate4sd3_1
Xaccumulator._1519_ accumulator._0608_ accumulator._0610_ accumulator._0613_ VGND
+ VGND VPWR VPWR accumulator._0614_ sky130_fd_sc_hd__a21o_1
XFILLER_0_46_292 VPWR VGND VPWR VGND sky130_ef_sc_hd__decap_12
XscaleAdd._240_ scaleAdd._186_ VGND VGND VPWR VPWR accumulator.io_inMant\[0\] sky130_fd_sc_hd__buf_1
XFILLER_0_29_204 VPWR VGND VPWR VGND sky130_ef_sc_hd__decap_12
XFILLER_0_32_78 VGND VGND VPWR VPWR sky130_fd_sc_hd__decap_6
XFILLER_0_32_45 VGND VGND VPWR VPWR sky130_fd_sc_hd__fill_1
XFILLER_0_29_248 VPWR VGND VPWR VGND sky130_ef_sc_hd__decap_12
XFILLER_0_29_237 VGND VGND VPWR VPWR sky130_fd_sc_hd__decap_4
XFILLER_0_4_315 VGND VGND VPWR VPWR sky130_fd_sc_hd__fill_1
XFILLER_0_52_273 VGND VGND VPWR VPWR sky130_fd_sc_hd__fill_1
Xaccumulator._1870_ accumulator._0696_ accumulator._0706_ accumulator._0746_ accumulator._0747_
+ accumulator._0533_ VGND VGND VPWR VPWR accumulator._0965_ sky130_fd_sc_hd__a311o_1
Xaccumulator._2353_ net22 net55 VGND VGND VPWR VPWR accumulator._0304_ sky130_fd_sc_hd__nor2_1
XscaleAdd._438_ scaleAdd._124_ scaleAdd._137_ scaleAdd._138_ VGND VGND VPWR VPWR scaleAdd._139_
+ sky130_fd_sc_hd__o21a_1
XscaleAdd._369_ scaleAdd._073_ scaleAdd._072_ VGND VGND VPWR VPWR scaleAdd._074_ sky130_fd_sc_hd__xnor2_4
XFILLER_0_20_181 VGND VGND VPWR VPWR sky130_fd_sc_hd__fill_1
XTAP_TAPCELL_ROW_48_482 VGND VPWR sky130_fd_sc_hd__tapvpwrvgnd_1
Xaccumulator._2284_ accumulator.io_accOut\[23\] accumulator._0384_ VGND VGND VPWR
+ VPWR accumulator._0236_ sky130_fd_sc_hd__or2_1
X_09_ accumulator.io_accOut\[9\] VGND VGND VPWR VPWR net54 sky130_fd_sc_hd__buf_1
XTAP_TAPCELL_ROW_23_305 VGND VPWR sky130_fd_sc_hd__tapvpwrvgnd_1
Xaccumulator._1235_ accumulator._0330_ accumulator._0331_ VGND VGND VPWR VPWR accumulator._0332_
+ sky130_fd_sc_hd__nor2_1
Xaccumulator._1304_ accumulator._0353_ accumulator._0349_ VGND VGND VPWR VPWR accumulator._0399_
+ sky130_fd_sc_hd__and2b_2
XFILLER_0_35_229 VGND VGND VPWR VPWR sky130_fd_sc_hd__decap_4
XTAP_TAPCELL_ROW_31_360 VGND VPWR sky130_fd_sc_hd__tapvpwrvgnd_1
Xaccumulator._1999_ accumulator._1166_ accumulator._1093_ VGND VGND VPWR VPWR accumulator._1094_
+ sky130_fd_sc_hd__or2_1
Xoutput37 net37 VGND VGND VPWR VPWR io_accOut[22] sky130_fd_sc_hd__buf_2
Xoutput26 net26 VGND VGND VPWR VPWR io_accOut[12] sky130_fd_sc_hd__buf_2
XPHY_EDGE_ROW_1_Right_1 VGND VGND VPWR VPWR sky130_fd_sc_hd__decap_3
Xoutput48 net48 VGND VGND VPWR VPWR io_accOut[3] sky130_fd_sc_hd__buf_2
XFILLER_0_11_181 VPWR VGND VPWR VGND sky130_ef_sc_hd__decap_12
XFILLER_0_66_365 VPWR VGND VPWR VGND sky130_ef_sc_hd__decap_12
XFILLER_0_66_321 VPWR VGND VPWR VGND sky130_ef_sc_hd__decap_12
XFILLER_0_34_251 VGND VGND VPWR VPWR sky130_fd_sc_hd__fill_1
XTAP_TAPCELL_ROW_45_463 VGND VPWR sky130_fd_sc_hd__tapvpwrvgnd_1
XTAP_TAPCELL_ROW_37_408 VGND VPWR sky130_fd_sc_hd__tapvpwrvgnd_1
Xaccumulator._1922_ accumulator._1011_ accumulator._1016_ VGND VGND VPWR VPWR accumulator._1017_
+ sky130_fd_sc_hd__xor2_2
XFILLER_0_25_251 VGND VGND VPWR VPWR sky130_fd_sc_hd__fill_1
XFILLER_0_40_221 VPWR VGND VPWR VGND sky130_ef_sc_hd__decap_12
Xaccumulator._1853_ accumulator._0533_ accumulator._0741_ VGND VGND VPWR VPWR accumulator._0948_
+ sky130_fd_sc_hd__nor2_1
Xaccumulator._1784_ accumulator._0876_ accumulator._0877_ VGND VGND VPWR VPWR accumulator._0879_
+ sky130_fd_sc_hd__and2_1
XFILLER_0_7_55 VGND VGND VPWR VPWR sky130_fd_sc_hd__fill_1
Xaccumulator._2336_ accumulator._0268_ accumulator._0286_ VGND VGND VPWR VPWR accumulator._0287_
+ sky130_fd_sc_hd__nand2_1
XFILLER_0_30_3 VGND VGND VPWR VPWR sky130_fd_sc_hd__decap_6
Xaccumulator._2198_ accumulator._1033_ accumulator._1008_ net101 VGND VGND VPWR VPWR
+ accumulator._0152_ sky130_fd_sc_hd__mux2_2
XFILLER_0_63_335 VGND VGND VPWR VPWR sky130_fd_sc_hd__fill_1
Xaccumulator._2267_ accumulator._0098_ accumulator._0218_ VGND VGND VPWR VPWR accumulator._0219_
+ sky130_fd_sc_hd__nor2_1
XFILLER_0_48_365 VPWR VGND VPWR VGND sky130_ef_sc_hd__decap_12
XFILLER_0_48_321 VGND VGND VPWR VPWR sky130_fd_sc_hd__decap_8
Xaccumulator._1218_ accumulator._0281_ accumulator._0212_ accumulator._0313_ accumulator._0314_
+ accumulator._0251_ VGND VGND VPWR VPWR accumulator._0315_ sky130_fd_sc_hd__a311o_1
XFILLER_0_31_276 VGND VGND VPWR VPWR sky130_fd_sc_hd__decap_4
XFILLER_0_16_273 VGND VGND VPWR VPWR sky130_fd_sc_hd__fill_2
XTAP_TAPCELL_ROW_8_199 VGND VPWR sky130_fd_sc_hd__tapvpwrvgnd_1
XFILLER_0_39_321 VGND VGND VPWR VPWR sky130_fd_sc_hd__decap_8
XFILLER_0_54_313 VPWR VGND VPWR VGND sky130_ef_sc_hd__decap_12
XFILLER_0_39_365 VGND VGND VPWR VPWR sky130_fd_sc_hd__fill_1
XFILLER_0_13_69 VPWR VGND VPWR VGND sky130_ef_sc_hd__decap_12
XFILLER_0_38_44 VGND VGND VPWR VPWR sky130_fd_sc_hd__decap_8
XFILLER_0_1_137 VPWR VGND VPWR VGND sky130_ef_sc_hd__decap_12
Xaccumulator._2052_ accumulator._1115_ VGND VGND VPWR VPWR accumulator._1148_ sky130_fd_sc_hd__inv_2
Xaccumulator._2121_ accumulator._0058_ accumulator._0076_ accumulator._0044_ VGND
+ VGND VPWR VPWR accumulator._0077_ sky130_fd_sc_hd__mux2_2
Xaccumulator._1905_ accumulator._0773_ accumulator._0999_ VGND VGND VPWR VPWR accumulator._1000_
+ sky130_fd_sc_hd__xnor2_2
XFILLER_0_13_243 VGND VGND VPWR VPWR sky130_fd_sc_hd__fill_1
Xaccumulator._1698_ accumulator._0773_ accumulator._0792_ VGND VGND VPWR VPWR accumulator._0793_
+ sky130_fd_sc_hd__or2_1
Xaccumulator._1836_ accumulator._0929_ accumulator._0930_ accumulator._0862_ VGND
+ VGND VPWR VPWR accumulator._0931_ sky130_fd_sc_hd__a21o_1
Xaccumulator._1767_ accumulator._0858_ accumulator._0861_ VGND VGND VPWR VPWR accumulator._0862_
+ sky130_fd_sc_hd__nor2_1
XFILLER_0_0_181 VGND VGND VPWR VPWR sky130_fd_sc_hd__decap_8
XFILLER_0_13_287 VPWR VGND VPWR VGND sky130_ef_sc_hd__decap_12
XTAP_TAPCELL_ROW_56_536 VGND VPWR sky130_fd_sc_hd__tapvpwrvgnd_1
Xaccumulator._2319_ accumulator._1093_ accumulator._0268_ VGND VGND VPWR VPWR accumulator._0270_
+ sky130_fd_sc_hd__nand2_1
XTAP_TAPCELL_ROW_64_591 VGND VPWR sky130_fd_sc_hd__tapvpwrvgnd_1
XFILLER_0_39_151 VGND VGND VPWR VPWR sky130_fd_sc_hd__decap_4
XFILLER_0_6_229 VPWR VGND VPWR VGND sky130_ef_sc_hd__decap_12
XFILLER_0_49_54 VGND VGND VPWR VPWR sky130_fd_sc_hd__fill_2
Xaccumulator._1552_ accumulator._0645_ accumulator._0646_ accumulator._0579_ VGND
+ VGND VPWR VPWR accumulator._0647_ sky130_fd_sc_hd__a21o_1
Xaccumulator._1621_ accumulator._0421_ accumulator._0443_ accumulator._0458_ accumulator._0485_
+ VGND VGND VPWR VPWR accumulator._0716_ sky130_fd_sc_hd__a31o_1
Xaccumulator._2104_ accumulator._1127_ VGND VGND VPWR VPWR accumulator._0060_ sky130_fd_sc_hd__inv_2
XTAP_TAPCELL_ROW_53_517 VGND VPWR sky130_fd_sc_hd__tapvpwrvgnd_1
Xaccumulator._1483_ accumulator._0409_ VGND VGND VPWR VPWR accumulator._0578_ sky130_fd_sc_hd__clkbuf_4
XTAP_TAPCELL_ROW_61_572 VGND VPWR sky130_fd_sc_hd__tapvpwrvgnd_1
Xaccumulator._2035_ accumulator._0816_ accumulator._1129_ VGND VGND VPWR VPWR accumulator._1130_
+ sky130_fd_sc_hd__xor2_1
XTAP_TAPCELL_ROW_18_271 VGND VPWR sky130_fd_sc_hd__tapvpwrvgnd_1
XFILLER_0_60_124 VGND VGND VPWR VPWR sky130_fd_sc_hd__decap_6
XFILLER_0_41_393 VGND VGND VPWR VPWR sky130_fd_sc_hd__decap_4
XFILLER_0_41_371 VPWR VGND VPWR VGND sky130_ef_sc_hd__decap_12
Xaccumulator._1819_ accumulator._0340_ accumulator._0517_ accumulator._0379_ VGND
+ VGND VPWR VPWR accumulator._0914_ sky130_fd_sc_hd__mux2_1
XFILLER_0_5_273 VGND VGND VPWR VPWR sky130_fd_sc_hd__fill_1
XTAP_TAPCELL_ROW_1_150 VGND VPWR sky130_fd_sc_hd__tapvpwrvgnd_1
XFILLER_0_36_165 VGND VGND VPWR VPWR sky130_fd_sc_hd__decap_4
XFILLER_0_32_360 VGND VGND VPWR VPWR sky130_fd_sc_hd__decap_4
XFILLER_0_10_15 VPWR VGND VPWR VGND sky130_ef_sc_hd__decap_12
XFILLER_0_17_390 VGND VGND VPWR VPWR sky130_fd_sc_hd__fill_2
XscaleAdd._471_ scaleAdd._164_ scaleAdd._165_ VGND VGND VPWR VPWR scaleAdd._166_ sky130_fd_sc_hd__nand2_1
XFILLER_0_19_57 VGND VGND VPWR VPWR sky130_fd_sc_hd__fill_1
XFILLER_0_59_268 VGND VGND VPWR VPWR sky130_fd_sc_hd__fill_1
XFILLER_0_51_66 VPWR VGND VPWR VGND sky130_ef_sc_hd__decap_12
XFILLER_0_51_55 VGND VGND VPWR VPWR sky130_fd_sc_hd__fill_1
XFILLER_0_42_113 VGND VGND VPWR VPWR sky130_fd_sc_hd__fill_1
XFILLER_0_27_165 VGND VGND VPWR VPWR sky130_fd_sc_hd__decap_3
XFILLER_0_27_143 VGND VGND VPWR VPWR sky130_fd_sc_hd__fill_2
XTAP_TAPCELL_ROW_15_252 VGND VPWR sky130_fd_sc_hd__tapvpwrvgnd_1
XFILLER_0_42_157 VPWR VGND VPWR VGND sky130_ef_sc_hd__decap_12
Xaccumulator._1535_ accumulator._0605_ accumulator._0614_ accumulator._0537_ accumulator._0629_
+ VGND VGND VPWR VPWR accumulator._0630_ sky130_fd_sc_hd__a2bb2o_1
Xaccumulator._1604_ accumulator.io_accOut\[4\] net107 accumulator._0418_ accumulator._0571_
+ VGND VGND VPWR VPWR accumulator._0699_ sky130_fd_sc_hd__and4_1
Xaccumulator._1397_ accumulator._0431_ accumulator._0427_ accumulator._0335_ accumulator._0429_
+ accumulator._0491_ VGND VGND VPWR VPWR accumulator._0492_ sky130_fd_sc_hd__a41o_1
Xaccumulator._1466_ accumulator._0554_ accumulator._0557_ accumulator._0560_ VGND
+ VGND VPWR VPWR accumulator._0561_ sky130_fd_sc_hd__and3_1
XFILLER_0_65_249 VPWR VGND VPWR VGND sky130_ef_sc_hd__decap_12
Xaccumulator._2018_ accumulator._0977_ accumulator._1112_ VGND VGND VPWR VPWR accumulator._1113_
+ sky130_fd_sc_hd__xor2_2
XFILLER_0_33_135 VPWR VGND VPWR VGND sky130_ef_sc_hd__decap_12
XFILLER_0_33_113 VGND VGND VPWR VPWR sky130_fd_sc_hd__fill_2
XFILLER_0_14_382 VGND VGND VPWR VPWR sky130_fd_sc_hd__fill_1
XTAP_TAPCELL_ROW_12_233 VGND VPWR sky130_fd_sc_hd__tapvpwrvgnd_1
XscaleAdd._454_ scaleAdd._148_ scaleAdd._149_ operator.io_outExp\[0\] VGND VGND VPWR
+ VPWR scaleAdd._151_ sky130_fd_sc_hd__a21o_1
XFILLER_0_46_66 VGND VGND VPWR VPWR sky130_fd_sc_hd__fill_1
XscaleAdd._385_ scaleAdd._190_ scaleAdd._074_ VGND VGND VPWR VPWR scaleAdd._089_ sky130_fd_sc_hd__nand2_1
Xaccumulator._1320_ accumulator._0399_ net74 VGND VGND VPWR VPWR accumulator._0415_
+ sky130_fd_sc_hd__xor2_2
XFILLER_0_62_76 VGND VGND VPWR VPWR sky130_fd_sc_hd__fill_1
X_25_ accumulator.io_accOut\[25\] VGND VGND VPWR VPWR net40 sky130_fd_sc_hd__buf_1
Xaccumulator._1182_ accumulator._0045_ VGND VGND VPWR VPWR accumulator._0055_ sky130_fd_sc_hd__buf_8
XFILLER_0_1_57 VPWR VGND VPWR VGND sky130_ef_sc_hd__decap_12
Xaccumulator._1251_ accumulator._0319_ accumulator._0318_ VGND VGND VPWR VPWR accumulator._0348_
+ sky130_fd_sc_hd__xnor2_2
XFILLER_0_7_368 VPWR VGND VPWR VGND sky130_ef_sc_hd__decap_12
XFILLER_0_15_157 VGND VGND VPWR VPWR sky130_fd_sc_hd__decap_8
XFILLER_0_60_3 VPWR VGND VPWR VGND sky130_ef_sc_hd__decap_12
XFILLER_0_30_127 VPWR VGND VPWR VGND sky130_ef_sc_hd__decap_12
Xhold48 accumulator.io_accOut\[17\] VGND VGND VPWR VPWR net106 sky130_fd_sc_hd__dlygate4sd3_1
Xaccumulator._1449_ accumulator._0540_ accumulator._0543_ accumulator._0500_ VGND
+ VGND VPWR VPWR accumulator._0544_ sky130_fd_sc_hd__a21o_1
Xaccumulator._1518_ accumulator._0611_ accumulator._0612_ accumulator._0554_ VGND
+ VGND VPWR VPWR accumulator._0613_ sky130_fd_sc_hd__a21oi_1
XTAP_TAPCELL_ROW_26_325 VGND VPWR sky130_fd_sc_hd__tapvpwrvgnd_1
XFILLER_0_32_13 VGND VGND VPWR VPWR sky130_fd_sc_hd__fill_1
XFILLER_0_29_216 VGND VGND VPWR VPWR sky130_fd_sc_hd__decap_8
XFILLER_0_4_305 VGND VGND VPWR VPWR sky130_fd_sc_hd__decap_3
XscaleAdd._437_ scaleAdd._181_ scaleAdd._092_ scaleAdd._106_ scaleAdd._191_ VGND VGND
+ VPWR VPWR scaleAdd._138_ sky130_fd_sc_hd__a22o_1
XFILLER_0_20_160 VGND VGND VPWR VPWR sky130_fd_sc_hd__fill_1
XFILLER_0_57_65 VGND VGND VPWR VPWR sky130_fd_sc_hd__fill_1
Xaccumulator._2283_ accumulator._0047_ accumulator._0234_ VGND VGND VPWR VPWR accumulator._0235_
+ sky130_fd_sc_hd__xor2_1
X_08_ accumulator.io_accOut\[8\] VGND VGND VPWR VPWR net53 sky130_fd_sc_hd__clkbuf_1
Xaccumulator._2352_ accumulator._0034_ accumulator._0300_ accumulator._0302_ accumulator._0303_
+ VGND VGND VPWR VPWR accumulator._0032_ sky130_fd_sc_hd__o31a_1
Xaccumulator._1303_ accumulator._0356_ accumulator._0397_ VGND VGND VPWR VPWR accumulator._0398_
+ sky130_fd_sc_hd__xnor2_4
XFILLER_0_32_7 VGND VGND VPWR VPWR sky130_fd_sc_hd__decap_6
XscaleAdd._368_ scaleAdd._054_ scaleAdd._051_ scaleAdd._049_ VGND VGND VPWR VPWR scaleAdd._073_
+ sky130_fd_sc_hd__a21oi_4
XscaleAdd._299_ scaleAdd._214_ scaleAdd._215_ scaleAdd._212_ VGND VGND VPWR VPWR scaleAdd._007_
+ sky130_fd_sc_hd__a21oi_2
XTAP_TAPCELL_ROW_48_483 VGND VPWR sky130_fd_sc_hd__tapvpwrvgnd_1
XTAP_TAPCELL_ROW_23_306 VGND VPWR sky130_fd_sc_hd__tapvpwrvgnd_1
Xaccumulator._1234_ accumulator.io_inExp\[5\] accumulator._0105_ VGND VGND VPWR VPWR
+ accumulator._0331_ sky130_fd_sc_hd__and2_1
Xaccumulator._1998_ accumulator._1038_ accumulator._1092_ VGND VGND VPWR VPWR accumulator._1093_
+ sky130_fd_sc_hd__nor2_4
XTAP_TAPCELL_ROW_31_361 VGND VPWR sky130_fd_sc_hd__tapvpwrvgnd_1
Xoutput38 net38 VGND VGND VPWR VPWR io_accOut[23] sky130_fd_sc_hd__buf_2
Xoutput49 net49 VGND VGND VPWR VPWR io_accOut[4] sky130_fd_sc_hd__buf_2
Xoutput27 net27 VGND VGND VPWR VPWR io_accOut[13] sky130_fd_sc_hd__buf_2
XFILLER_0_3_393 VGND VGND VPWR VPWR sky130_fd_sc_hd__decap_8
XFILLER_0_3_382 VGND VGND VPWR VPWR sky130_fd_sc_hd__decap_8
XFILLER_0_11_193 VGND VGND VPWR VPWR sky130_fd_sc_hd__decap_8
XFILLER_0_66_377 VPWR VGND VPWR VGND sky130_ef_sc_hd__decap_12
XFILLER_0_66_333 VPWR VGND VPWR VGND sky130_ef_sc_hd__decap_12
XFILLER_0_27_57 VPWR VGND VPWR VGND sky130_ef_sc_hd__decap_12
XTAP_TAPCELL_ROW_45_464 VGND VPWR sky130_fd_sc_hd__tapvpwrvgnd_1
XFILLER_0_43_78 VGND VGND VPWR VPWR sky130_fd_sc_hd__fill_1
Xaccumulator._1852_ accumulator._0946_ VGND VGND VPWR VPWR accumulator._0947_ sky130_fd_sc_hd__clkbuf_4
Xaccumulator._1921_ accumulator._0864_ accumulator._1015_ VGND VGND VPWR VPWR accumulator._1016_
+ sky130_fd_sc_hd__xor2_2
XFILLER_0_4_157 VGND VGND VPWR VPWR sky130_fd_sc_hd__decap_6
XFILLER_0_40_277 VGND VGND VPWR VPWR sky130_fd_sc_hd__fill_1
Xaccumulator._1783_ accumulator._0876_ accumulator._0877_ VGND VGND VPWR VPWR accumulator._0878_
+ sky130_fd_sc_hd__or2_1
XPHY_EDGE_ROW_15_Right_15 VGND VGND VPWR VPWR sky130_fd_sc_hd__decap_3
Xaccumulator._2266_ accumulator._0383_ accumulator._1093_ VGND VGND VPWR VPWR accumulator._0218_
+ sky130_fd_sc_hd__nand2_1
Xaccumulator._2335_ accumulator._1093_ accumulator._0280_ VGND VGND VPWR VPWR accumulator._0286_
+ sky130_fd_sc_hd__nor2_1
XPHY_EDGE_ROW_24_Right_24 VGND VGND VPWR VPWR sky130_fd_sc_hd__decap_3
XFILLER_0_23_3 VGND VGND VPWR VPWR sky130_fd_sc_hd__decap_8
Xaccumulator._2197_ accumulator._1030_ accumulator._1035_ accumulator._0046_ VGND
+ VGND VPWR VPWR accumulator._0151_ sky130_fd_sc_hd__mux2_2
XFILLER_0_48_377 VPWR VGND VPWR VGND sky130_ef_sc_hd__decap_12
Xaccumulator._1217_ accumulator.io_inExp\[3\] accumulator._0075_ VGND VGND VPWR VPWR
+ accumulator._0314_ sky130_fd_sc_hd__and2_4
XPHY_EDGE_ROW_39_Left_107 VGND VGND VPWR VPWR sky130_fd_sc_hd__decap_3
XPHY_EDGE_ROW_33_Right_33 VGND VGND VPWR VPWR sky130_fd_sc_hd__decap_3
XFILLER_0_31_200 VPWR VGND VPWR VGND sky130_ef_sc_hd__decap_12
XTAP_TAPCELL_ROW_59_556 VGND VPWR sky130_fd_sc_hd__tapvpwrvgnd_1
XPHY_EDGE_ROW_48_Left_116 VGND VGND VPWR VPWR sky130_fd_sc_hd__decap_3
XPHY_EDGE_ROW_42_Right_42 VGND VGND VPWR VPWR sky130_fd_sc_hd__decap_3
XFILLER_0_13_15 VPWR VGND VPWR VGND sky130_ef_sc_hd__decap_12
XPHY_EDGE_ROW_57_Left_125 VGND VGND VPWR VPWR sky130_fd_sc_hd__decap_3
XPHY_EDGE_ROW_51_Right_51 VGND VGND VPWR VPWR sky130_fd_sc_hd__decap_3
XFILLER_0_1_105 VGND VGND VPWR VPWR sky130_fd_sc_hd__decap_6
XFILLER_0_1_149 VPWR VGND VPWR VGND sky130_ef_sc_hd__decap_12
XPHY_EDGE_ROW_66_Left_134 VGND VGND VPWR VPWR sky130_fd_sc_hd__decap_3
XPHY_EDGE_ROW_60_Right_60 VGND VGND VPWR VPWR sky130_fd_sc_hd__decap_3
Xaccumulator._2120_ accumulator._0053_ VGND VGND VPWR VPWR accumulator._0076_ sky130_fd_sc_hd__inv_2
Xaccumulator._2051_ accumulator._1113_ VGND VGND VPWR VPWR accumulator._1147_ sky130_fd_sc_hd__inv_2
XFILLER_0_9_216 VGND VGND VPWR VPWR sky130_fd_sc_hd__decap_8
XFILLER_0_9_249 VGND VGND VPWR VPWR sky130_fd_sc_hd__fill_2
XFILLER_0_53_391 VGND VGND VPWR VPWR sky130_fd_sc_hd__fill_1
Xaccumulator._1904_ accumulator._0919_ accumulator._0926_ accumulator._0998_ VGND
+ VGND VPWR VPWR accumulator._0999_ sky130_fd_sc_hd__a21o_1
Xaccumulator._1835_ accumulator._0410_ accumulator._0527_ accumulator._0529_ VGND
+ VGND VPWR VPWR accumulator._0930_ sky130_fd_sc_hd__and3_1
XFILLER_0_13_200 VGND VGND VPWR VPWR sky130_fd_sc_hd__fill_2
Xaccumulator._1697_ accumulator._0583_ accumulator._0584_ VGND VGND VPWR VPWR accumulator._0792_
+ sky130_fd_sc_hd__nor2_2
Xaccumulator._1766_ accumulator._0859_ accumulator._0388_ accumulator._0860_ VGND
+ VGND VPWR VPWR accumulator._0861_ sky130_fd_sc_hd__o21a_1
XTAP_TAPCELL_ROW_64_592 VGND VPWR sky130_fd_sc_hd__tapvpwrvgnd_1
XTAP_TAPCELL_ROW_56_537 VGND VPWR sky130_fd_sc_hd__tapvpwrvgnd_1
Xaccumulator._2249_ accumulator._0392_ accumulator._0196_ accumulator._0201_ accumulator._0200_
+ VGND VGND VPWR VPWR accumulator._0202_ sky130_fd_sc_hd__or4_4
Xaccumulator._2318_ accumulator._1093_ accumulator._0268_ VGND VGND VPWR VPWR accumulator._0269_
+ sky130_fd_sc_hd__or2_1
XFILLER_0_48_185 VGND VGND VPWR VPWR sky130_fd_sc_hd__decap_8
XFILLER_0_36_314 VGND VGND VPWR VPWR sky130_fd_sc_hd__decap_6
XFILLER_0_8_271 VGND VGND VPWR VPWR sky130_fd_sc_hd__fill_1
XFILLER_0_24_25 VGND VGND VPWR VPWR sky130_fd_sc_hd__decap_3
XFILLER_0_50_361 VGND VGND VPWR VPWR sky130_fd_sc_hd__decap_3
XFILLER_0_49_11 VGND VGND VPWR VPWR sky130_fd_sc_hd__fill_2
XFILLER_0_42_317 VGND VGND VPWR VPWR sky130_fd_sc_hd__fill_1
XFILLER_0_42_306 VGND VGND VPWR VPWR sky130_fd_sc_hd__fill_2
XFILLER_0_40_57 VGND VGND VPWR VPWR sky130_fd_sc_hd__fill_1
XFILLER_0_35_380 VGND VGND VPWR VPWR sky130_fd_sc_hd__fill_2
Xaccumulator._1620_ accumulator._0539_ accumulator._0713_ accumulator._0714_ VGND
+ VGND VPWR VPWR accumulator._0715_ sky130_fd_sc_hd__a21oi_1
XFILLER_0_10_269 VGND VGND VPWR VPWR sky130_fd_sc_hd__fill_1
Xaccumulator._1551_ accumulator._0557_ accumulator._0560_ accumulator._0576_ VGND
+ VGND VPWR VPWR accumulator._0646_ sky130_fd_sc_hd__a21o_1
Xaccumulator._1482_ accumulator._0570_ accumulator._0575_ accumulator._0576_ VGND
+ VGND VPWR VPWR accumulator._0577_ sky130_fd_sc_hd__mux2_2
XTAP_TAPCELL_ROW_53_518 VGND VPWR sky130_fd_sc_hd__tapvpwrvgnd_1
Xaccumulator._2103_ accumulator._0044_ accumulator._0058_ VGND VGND VPWR VPWR accumulator._0059_
+ sky130_fd_sc_hd__nand2_1
XTAP_TAPCELL_ROW_18_272 VGND VPWR sky130_fd_sc_hd__tapvpwrvgnd_1
XTAP_TAPCELL_ROW_61_573 VGND VPWR sky130_fd_sc_hd__tapvpwrvgnd_1
XFILLER_0_45_111 VGND VGND VPWR VPWR sky130_fd_sc_hd__fill_1
Xaccumulator._2034_ accumulator._0534_ net56 VGND VGND VPWR VPWR accumulator._1129_
+ sky130_fd_sc_hd__nand2_1
XFILLER_0_33_317 VPWR VGND VPWR VGND sky130_ef_sc_hd__decap_12
XFILLER_0_14_80 VGND VGND VPWR VPWR sky130_fd_sc_hd__fill_1
XFILLER_0_41_383 VGND VGND VPWR VPWR sky130_fd_sc_hd__decap_8
Xaccumulator._1818_ accumulator._0787_ accumulator._0635_ VGND VGND VPWR VPWR accumulator._0913_
+ sky130_fd_sc_hd__nor2_1
Xaccumulator._1749_ accumulator._0763_ accumulator._0765_ VGND VGND VPWR VPWR accumulator._0844_
+ sky130_fd_sc_hd__and2_1
XTAP_TAPCELL_ROW_1_151 VGND VPWR sky130_fd_sc_hd__tapvpwrvgnd_1
XFILLER_0_36_100 VPWR VGND VPWR VGND sky130_ef_sc_hd__decap_12
XFILLER_0_51_169 VGND VGND VPWR VPWR sky130_fd_sc_hd__decap_8
XFILLER_0_36_177 VGND VGND VPWR VPWR sky130_fd_sc_hd__decap_3
XscaleAdd._470_ net16 net19 VGND VGND VPWR VPWR scaleAdd._165_ sky130_fd_sc_hd__or2_1
XFILLER_0_10_27 VGND VGND VPWR VPWR sky130_fd_sc_hd__fill_1
XFILLER_0_51_78 VGND VGND VPWR VPWR sky130_fd_sc_hd__decap_3
XTAP_TAPCELL_ROW_15_253 VGND VPWR sky130_fd_sc_hd__tapvpwrvgnd_1
XFILLER_0_42_169 VGND VGND VPWR VPWR sky130_fd_sc_hd__fill_1
XTAP_TAPCELL_ROW_66_610 VGND VPWR sky130_fd_sc_hd__tapvpwrvgnd_1
Xaccumulator._1465_ accumulator._0558_ accumulator._0559_ accumulator._0462_ VGND
+ VGND VPWR VPWR accumulator._0560_ sky130_fd_sc_hd__a21o_1
Xaccumulator._1534_ accumulator._0623_ accumulator._0628_ VGND VGND VPWR VPWR accumulator._0629_
+ sky130_fd_sc_hd__or2_1
Xaccumulator._1603_ accumulator.io_accOut\[3\] accumulator._0406_ accumulator._0424_
+ VGND VGND VPWR VPWR accumulator._0698_ sky130_fd_sc_hd__and3_1
Xaccumulator._2017_ accumulator._0968_ accumulator._0972_ accumulator._1022_ VGND
+ VGND VPWR VPWR accumulator._1112_ sky130_fd_sc_hd__o21ai_1
Xaccumulator._1396_ net61 accumulator._0465_ accumulator._0464_ accumulator._0055_
+ VGND VGND VPWR VPWR accumulator._0491_ sky130_fd_sc_hd__a22o_1
XFILLER_0_33_169 VPWR VGND VPWR VGND sky130_ef_sc_hd__decap_12
XFILLER_0_33_147 VGND VGND VPWR VPWR sky130_fd_sc_hd__fill_1
XFILLER_0_21_15 VPWR VGND VPWR VGND sky130_ef_sc_hd__decap_12
XscaleAdd._384_ scaleAdd._087_ net76 VGND VGND VPWR VPWR accumulator.io_inMant\[9\]
+ sky130_fd_sc_hd__xnor2_2
XscaleAdd._453_ operator.io_outExp\[0\] scaleAdd._148_ scaleAdd._149_ VGND VGND VPWR
+ VPWR scaleAdd._150_ sky130_fd_sc_hd__nand3_1
XFILLER_0_12_309 VPWR VGND VPWR VGND sky130_ef_sc_hd__decap_12
XFILLER_0_46_34 VGND VGND VPWR VPWR sky130_fd_sc_hd__decap_6
X_24_ accumulator.io_accOut\[24\] VGND VGND VPWR VPWR net39 sky130_fd_sc_hd__clkbuf_1
Xaccumulator._1250_ accumulator.io_accOut\[25\] accumulator._0346_ VGND VGND VPWR
+ VPWR accumulator._0347_ sky130_fd_sc_hd__xor2_4
Xaccumulator._1181_ accumulator.io_inMant\[14\] accumulator.io_inMant\[12\] accumulator.io_inMant\[13\]
+ accumulator.io_inMant\[15\] VGND VGND VPWR VPWR accumulator._0045_ sky130_fd_sc_hd__or4_4
XFILLER_0_1_69 VPWR VGND VPWR VGND sky130_ef_sc_hd__decap_12
XFILLER_0_30_117 VGND VGND VPWR VPWR sky130_fd_sc_hd__decap_3
XFILLER_0_15_103 VGND VGND VPWR VPWR sky130_fd_sc_hd__decap_8
XFILLER_0_15_169 VGND VGND VPWR VPWR sky130_fd_sc_hd__decap_4
XFILLER_0_53_3 VPWR VGND VPWR VGND sky130_ef_sc_hd__decap_12
XFILLER_0_30_139 VGND VGND VPWR VPWR sky130_fd_sc_hd__fill_1
XTAP_TAPCELL_ROW_26_326 VGND VPWR sky130_fd_sc_hd__tapvpwrvgnd_1
Xaccumulator._1448_ net96 accumulator._0542_ accumulator._0498_ VGND VGND VPWR VPWR
+ accumulator._0543_ sky130_fd_sc_hd__a21o_1
Xaccumulator._1517_ accumulator._0494_ accumulator._0499_ accumulator._0551_ VGND
+ VGND VPWR VPWR accumulator._0612_ sky130_fd_sc_hd__a21o_1
Xaccumulator._1379_ accumulator._0425_ accumulator._0472_ accumulator._0473_ VGND
+ VGND VPWR VPWR accumulator._0474_ sky130_fd_sc_hd__a21o_1
XFILLER_0_46_261 VGND VGND VPWR VPWR sky130_fd_sc_hd__fill_1
XTAP_TAPCELL_ROW_34_381 VGND VPWR sky130_fd_sc_hd__tapvpwrvgnd_1
XFILLER_0_61_253 VGND VGND VPWR VPWR sky130_fd_sc_hd__fill_2
Xclkbuf_2_2__f_clock clknet_0_clock VGND VGND VPWR VPWR clknet_2_2__leaf_clock sky130_fd_sc_hd__clkbuf_16
XFILLER_0_21_106 VGND VGND VPWR VPWR sky130_fd_sc_hd__decap_6
XFILLER_0_21_139 VPWR VGND VPWR VGND sky130_ef_sc_hd__decap_12
XFILLER_0_16_15 VPWR VGND VPWR VGND sky130_ef_sc_hd__decap_12
XFILLER_0_52_253 VGND VGND VPWR VPWR sky130_fd_sc_hd__decap_4
XFILLER_0_52_242 VGND VGND VPWR VPWR sky130_fd_sc_hd__decap_8
XFILLER_0_37_272 VGND VGND VPWR VPWR sky130_fd_sc_hd__fill_2
XFILLER_0_57_55 VGND VGND VPWR VPWR sky130_fd_sc_hd__fill_1
XscaleAdd._436_ scaleAdd._181_ scaleAdd._106_ VGND VGND VPWR VPWR scaleAdd._137_ sky130_fd_sc_hd__nand2_1
XPHY_EDGE_ROW_27_Left_95 VGND VGND VPWR VPWR sky130_fd_sc_hd__decap_3
XscaleAdd._367_ scaleAdd._192_ scaleAdd._070_ scaleAdd._071_ scaleAdd._046_ VGND VGND
+ VPWR VPWR scaleAdd._072_ sky130_fd_sc_hd__a31o_2
XTAP_TAPCELL_ROW_48_484 VGND VPWR sky130_fd_sc_hd__tapvpwrvgnd_1
Xaccumulator._2351_ accumulator._0385_ accumulator._0034_ accumulator._0074_ VGND
+ VGND VPWR VPWR accumulator._0303_ sky130_fd_sc_hd__a21oi_1
Xaccumulator._2282_ accumulator.io_accOut\[23\] accumulator._0233_ accumulator._0389_
+ VGND VGND VPWR VPWR accumulator._0234_ sky130_fd_sc_hd__mux2_2
Xaccumulator._1302_ accumulator._0360_ accumulator._0359_ VGND VGND VPWR VPWR accumulator._0397_
+ sky130_fd_sc_hd__and2b_1
X_07_ accumulator.io_accOut\[7\] VGND VGND VPWR VPWR net52 sky130_fd_sc_hd__clkbuf_1
XPHY_EDGE_ROW_11_Left_79 VGND VGND VPWR VPWR sky130_fd_sc_hd__decap_3
Xaccumulator._1233_ accumulator._0329_ VGND VGND VPWR VPWR accumulator._0330_ sky130_fd_sc_hd__inv_2
XscaleAdd._298_ scaleAdd._004_ scaleAdd._005_ VGND VGND VPWR VPWR scaleAdd._006_ sky130_fd_sc_hd__xnor2_2
XFILLER_0_28_283 VGND VGND VPWR VPWR sky130_fd_sc_hd__decap_3
XFILLER_0_28_250 VGND VGND VPWR VPWR sky130_fd_sc_hd__fill_2
XTAP_TAPCELL_ROW_23_307 VGND VPWR sky130_fd_sc_hd__tapvpwrvgnd_1
XFILLER_0_7_111 VGND VGND VPWR VPWR sky130_fd_sc_hd__fill_1
XFILLER_0_7_166 VGND VGND VPWR VPWR sky130_fd_sc_hd__fill_2
Xaccumulator._1997_ accumulator._1069_ accumulator._1091_ VGND VGND VPWR VPWR accumulator._1092_
+ sky130_fd_sc_hd__or2_4
XFILLER_0_43_242 VGND VGND VPWR VPWR sky130_fd_sc_hd__fill_1
XFILLER_0_43_220 VGND VGND VPWR VPWR sky130_fd_sc_hd__decap_4
Xoutput39 net39 VGND VGND VPWR VPWR io_accOut[24] sky130_fd_sc_hd__buf_2
XTAP_TAPCELL_ROW_31_362 VGND VPWR sky130_fd_sc_hd__tapvpwrvgnd_1
Xoutput28 net28 VGND VGND VPWR VPWR io_accOut[14] sky130_fd_sc_hd__buf_2
XFILLER_0_66_345 VPWR VGND VPWR VGND sky130_ef_sc_hd__decap_12
XFILLER_0_66_301 VGND VGND VPWR VPWR sky130_fd_sc_hd__decap_6
XFILLER_0_66_389 VPWR VGND VPWR VGND sky130_ef_sc_hd__decap_12
XFILLER_0_34_253 VGND VGND VPWR VPWR sky130_fd_sc_hd__fill_1
XFILLER_0_34_220 VPWR VGND VPWR VGND sky130_ef_sc_hd__decap_12
XFILLER_0_26_209 VGND VGND VPWR VPWR sky130_fd_sc_hd__fill_1
XFILLER_0_27_69 VGND VGND VPWR VPWR sky130_fd_sc_hd__fill_1
XFILLER_0_43_35 VGND VGND VPWR VPWR sky130_fd_sc_hd__decap_3
Xaccumulator._1851_ accumulator._0916_ accumulator._0920_ accumulator._0945_ VGND
+ VGND VPWR VPWR accumulator._0946_ sky130_fd_sc_hd__a21oi_2
Xaccumulator._1920_ accumulator._1012_ accumulator._1014_ accumulator._0919_ VGND
+ VGND VPWR VPWR accumulator._1015_ sky130_fd_sc_hd__mux2_1
XFILLER_0_40_212 VGND VGND VPWR VPWR sky130_fd_sc_hd__decap_3
XFILLER_0_25_264 VPWR VGND VPWR VGND sky130_ef_sc_hd__decap_12
XFILLER_0_25_231 VGND VGND VPWR VPWR sky130_fd_sc_hd__fill_1
XFILLER_0_4_169 VPWR VGND VPWR VGND sky130_ef_sc_hd__decap_12
XFILLER_0_7_57 VPWR VGND VPWR VGND sky130_ef_sc_hd__decap_12
XscaleAdd._419_ scaleAdd._190_ scaleAdd._106_ VGND VGND VPWR VPWR scaleAdd._121_ sky130_fd_sc_hd__nand2_1
Xaccumulator._1782_ accumulator.io_accOut\[18\] accumulator._0455_ accumulator._0388_
+ VGND VGND VPWR VPWR accumulator._0877_ sky130_fd_sc_hd__mux2_1
XFILLER_0_67_109 VGND VGND VPWR VPWR sky130_fd_sc_hd__decap_3
Xaccumulator._2196_ accumulator._0148_ accumulator._0149_ accumulator._0044_ VGND
+ VGND VPWR VPWR accumulator._0150_ sky130_fd_sc_hd__mux2_4
Xaccumulator._2334_ accumulator._0283_ accumulator._0284_ accumulator._0285_ accumulator._0118_
+ VGND VGND VPWR VPWR accumulator._0030_ sky130_fd_sc_hd__o211a_1
XFILLER_0_48_334 VPWR VGND VPWR VGND sky130_ef_sc_hd__decap_12
Xaccumulator._2265_ net109 accumulator._0147_ accumulator._0209_ accumulator._0217_
+ accumulator._0381_ VGND VGND VPWR VPWR accumulator._0022_ sky130_fd_sc_hd__o221a_1
Xaccumulator._1216_ accumulator.io_inExp\[0\] accumulator._0311_ accumulator._0312_
+ VGND VGND VPWR VPWR accumulator._0313_ sky130_fd_sc_hd__or3b_1
XFILLER_0_16_3 VPWR VGND VPWR VGND sky130_ef_sc_hd__decap_12
XFILLER_0_63_337 VPWR VGND VPWR VGND sky130_ef_sc_hd__decap_12
XFILLER_0_48_389 VPWR VGND VPWR VGND sky130_ef_sc_hd__decap_12
XFILLER_0_16_253 VGND VGND VPWR VPWR sky130_fd_sc_hd__decap_8
XFILLER_0_31_234 VGND VGND VPWR VPWR sky130_fd_sc_hd__fill_1
XFILLER_0_31_223 VGND VGND VPWR VPWR sky130_fd_sc_hd__fill_1
XFILLER_0_31_212 VGND VGND VPWR VPWR sky130_fd_sc_hd__fill_2
XTAP_TAPCELL_ROW_59_557 VGND VPWR sky130_fd_sc_hd__tapvpwrvgnd_1
XFILLER_0_54_337 VGND VGND VPWR VPWR sky130_fd_sc_hd__decap_3
XFILLER_0_39_389 VGND VGND VPWR VPWR sky130_fd_sc_hd__decap_3
XFILLER_0_39_334 VGND VGND VPWR VPWR sky130_fd_sc_hd__fill_2
XFILLER_0_39_301 VGND VGND VPWR VPWR sky130_fd_sc_hd__decap_4
XFILLER_0_13_27 VPWR VGND VPWR VGND sky130_ef_sc_hd__decap_12
XFILLER_0_38_68 VGND VGND VPWR VPWR sky130_fd_sc_hd__fill_1
Xaccumulator._2050_ accumulator._1028_ VGND VGND VPWR VPWR accumulator._1146_ sky130_fd_sc_hd__inv_2
XFILLER_0_57_131 VPWR VGND VPWR VGND sky130_ef_sc_hd__decap_12
XFILLER_0_45_337 VGND VGND VPWR VPWR sky130_fd_sc_hd__decap_8
Xaccumulator._1903_ accumulator._0792_ accumulator._0993_ accumulator._0534_ accumulator._0786_
+ VGND VGND VPWR VPWR accumulator._0998_ sky130_fd_sc_hd__o211a_1
Xaccumulator._1834_ accumulator._0863_ VGND VGND VPWR VPWR accumulator._0929_ sky130_fd_sc_hd__inv_2
Xaccumulator._1765_ accumulator._0388_ accumulator._0502_ VGND VGND VPWR VPWR accumulator._0860_
+ sky130_fd_sc_hd__nand2_1
XTAP_TAPCELL_ROW_56_538 VGND VPWR sky130_fd_sc_hd__tapvpwrvgnd_1
Xaccumulator._1696_ accumulator._0788_ accumulator._0762_ accumulator._0790_ VGND
+ VGND VPWR VPWR accumulator._0791_ sky130_fd_sc_hd__a21oi_1
XTAP_TAPCELL_ROW_64_593 VGND VPWR sky130_fd_sc_hd__tapvpwrvgnd_1
Xaccumulator._2248_ accumulator._0070_ accumulator._0158_ VGND VGND VPWR VPWR accumulator._0201_
+ sky130_fd_sc_hd__nor2_1
XFILLER_0_48_120 VPWR VGND VPWR VGND sky130_ef_sc_hd__decap_12
Xaccumulator._2179_ accumulator._0127_ accumulator._0133_ accumulator._0118_ VGND
+ VGND VPWR VPWR accumulator._0011_ sky130_fd_sc_hd__o21a_1
Xaccumulator._2317_ accumulator.io_accOut\[27\] accumulator._0267_ accumulator._0389_
+ VGND VGND VPWR VPWR accumulator._0268_ sky130_fd_sc_hd__mux2_1
XFILLER_0_36_304 VGND VGND VPWR VPWR sky130_fd_sc_hd__decap_4
XPHY_EDGE_ROW_14_Left_82 VGND VGND VPWR VPWR sky130_fd_sc_hd__decap_3
XFILLER_0_63_167 VGND VGND VPWR VPWR sky130_fd_sc_hd__fill_1
XFILLER_0_63_156 VGND VGND VPWR VPWR sky130_fd_sc_hd__fill_1
XFILLER_0_5_3 VPWR VGND VPWR VGND sky130_ef_sc_hd__decap_12
XTAP_TAPCELL_ROW_4_171 VGND VPWR sky130_fd_sc_hd__tapvpwrvgnd_1
XFILLER_0_54_145 VGND VGND VPWR VPWR sky130_fd_sc_hd__fill_1
XFILLER_0_27_337 VGND VGND VPWR VPWR sky130_fd_sc_hd__decap_8
XFILLER_0_6_209 VGND VGND VPWR VPWR sky130_fd_sc_hd__fill_1
XFILLER_0_65_99 VGND VGND VPWR VPWR sky130_fd_sc_hd__fill_1
XFILLER_0_65_77 VGND VGND VPWR VPWR sky130_fd_sc_hd__fill_1
XFILLER_0_65_55 VGND VGND VPWR VPWR sky130_fd_sc_hd__fill_1
Xaccumulator._1481_ accumulator._0511_ VGND VGND VPWR VPWR accumulator._0576_ sky130_fd_sc_hd__clkbuf_4
Xaccumulator._1550_ accumulator._0563_ accumulator._0566_ accumulator._0569_ accumulator._0576_
+ VGND VGND VPWR VPWR accumulator._0645_ sky130_fd_sc_hd__o211ai_2
Xaccumulator._2033_ accumulator._1127_ VGND VGND VPWR VPWR accumulator._1128_ sky130_fd_sc_hd__buf_2
XTAP_TAPCELL_ROW_53_519 VGND VPWR sky130_fd_sc_hd__tapvpwrvgnd_1
Xaccumulator._2102_ net56 accumulator._1134_ net103 VGND VGND VPWR VPWR accumulator._0058_
+ sky130_fd_sc_hd__mux2_1
XTAP_TAPCELL_ROW_18_273 VGND VPWR sky130_fd_sc_hd__tapvpwrvgnd_1
XTAP_TAPCELL_ROW_61_574 VGND VPWR sky130_fd_sc_hd__tapvpwrvgnd_1
XFILLER_0_45_167 VGND VGND VPWR VPWR sky130_fd_sc_hd__fill_1
XFILLER_0_33_329 VGND VGND VPWR VPWR sky130_fd_sc_hd__decap_6
XFILLER_0_30_80 VGND VGND VPWR VPWR sky130_fd_sc_hd__decap_4
XFILLER_0_26_370 VGND VGND VPWR VPWR sky130_fd_sc_hd__decap_6
XFILLER_0_14_92 VGND VGND VPWR VPWR sky130_fd_sc_hd__decap_8
Xaccumulator._1817_ accumulator._0910_ accumulator._0907_ accumulator._0911_ VGND
+ VGND VPWR VPWR accumulator._0912_ sky130_fd_sc_hd__a21oi_1
Xaccumulator._1748_ accumulator._0839_ accumulator._0809_ accumulator._0800_ accumulator._0756_
+ accumulator._0842_ VGND VGND VPWR VPWR accumulator._0843_ sky130_fd_sc_hd__a2111o_1
XTAP_TAPCELL_ROW_1_152 VGND VPWR sky130_fd_sc_hd__tapvpwrvgnd_1
Xaccumulator._1679_ accumulator._0579_ accumulator._0678_ VGND VGND VPWR VPWR accumulator._0774_
+ sky130_fd_sc_hd__nor2_1
XFILLER_0_36_112 VGND VGND VPWR VPWR sky130_fd_sc_hd__decap_4
XFILLER_0_32_373 VPWR VGND VPWR VGND sky130_ef_sc_hd__decap_12
XFILLER_0_19_15 VPWR VGND VPWR VGND sky130_ef_sc_hd__decap_12
XFILLER_0_59_248 VGND VGND VPWR VPWR sky130_fd_sc_hd__decap_8
XFILLER_0_67_281 VGND VGND VPWR VPWR sky130_fd_sc_hd__fill_2
XFILLER_0_51_57 VGND VGND VPWR VPWR sky130_fd_sc_hd__decap_3
XFILLER_0_27_123 VPWR VGND VPWR VGND sky130_ef_sc_hd__decap_12
XFILLER_0_15_318 VPWR VGND VPWR VGND sky130_ef_sc_hd__decap_12
XTAP_TAPCELL_ROW_15_254 VGND VPWR sky130_fd_sc_hd__tapvpwrvgnd_1
XFILLER_0_2_267 VPWR VGND VPWR VGND sky130_ef_sc_hd__decap_12
Xaccumulator._1602_ accumulator._0539_ accumulator._0553_ accumulator._0561_ accumulator._0579_
+ VGND VGND VPWR VPWR accumulator._0697_ sky130_fd_sc_hd__a211o_1
XTAP_TAPCELL_ROW_66_611 VGND VPWR sky130_fd_sc_hd__tapvpwrvgnd_1
Xaccumulator._1464_ net96 accumulator._0503_ accumulator._0498_ VGND VGND VPWR VPWR
+ accumulator._0559_ sky130_fd_sc_hd__a21o_1
Xaccumulator._1533_ accumulator._0624_ accumulator._0511_ accumulator._0627_ VGND
+ VGND VPWR VPWR accumulator._0628_ sky130_fd_sc_hd__and3_1
Xaccumulator._1395_ accumulator._0425_ VGND VGND VPWR VPWR accumulator._0490_ sky130_fd_sc_hd__buf_6
Xaccumulator._2016_ accumulator._0983_ accumulator._1110_ VGND VGND VPWR VPWR accumulator._1111_
+ sky130_fd_sc_hd__xor2_2
XFILLER_0_41_181 VGND VGND VPWR VPWR sky130_fd_sc_hd__fill_1
XFILLER_0_33_104 VGND VGND VPWR VPWR sky130_fd_sc_hd__decap_8
XFILLER_0_14_351 VGND VGND VPWR VPWR sky130_fd_sc_hd__fill_2
XFILLER_0_18_178 VGND VGND VPWR VPWR sky130_fd_sc_hd__fill_1
XTAP_TAPCELL_ROW_29_346 VGND VPWR sky130_fd_sc_hd__tapvpwrvgnd_1
XFILLER_0_64_251 VGND VGND VPWR VPWR sky130_fd_sc_hd__fill_1
XFILLER_0_49_281 VPWR VGND VPWR VGND sky130_ef_sc_hd__decap_12
XFILLER_0_21_27 VPWR VGND VPWR VGND sky130_ef_sc_hd__decap_12
XscaleAdd._383_ scaleAdd._067_ scaleAdd._065_ scaleAdd._064_ VGND VGND VPWR VPWR scaleAdd._088_
+ sky130_fd_sc_hd__a21o_1
XscaleAdd._452_ net14 net17 VGND VGND VPWR VPWR scaleAdd._149_ sky130_fd_sc_hd__or2_1
XFILLER_0_20_321 VGND VGND VPWR VPWR sky130_fd_sc_hd__decap_4
XFILLER_0_20_365 VGND VGND VPWR VPWR sky130_fd_sc_hd__fill_1
X_23_ accumulator.io_accOut\[23\] VGND VGND VPWR VPWR net38 sky130_fd_sc_hd__clkbuf_1
XFILLER_0_1_15 VPWR VGND VPWR VGND sky130_ef_sc_hd__decap_12
Xaccumulator._1180_ accumulator._1166_ VGND VGND VPWR VPWR accumulator._0034_ sky130_fd_sc_hd__clkbuf_4
XFILLER_0_7_337 VGND VGND VPWR VPWR sky130_fd_sc_hd__fill_1
XFILLER_0_15_137 VPWR VGND VPWR VGND sky130_ef_sc_hd__decap_12
XFILLER_0_46_3 VPWR VGND VPWR VGND sky130_ef_sc_hd__decap_12
Xaccumulator._1516_ accumulator._0443_ accumulator._0458_ accumulator._0500_ VGND
+ VGND VPWR VPWR accumulator._0611_ sky130_fd_sc_hd__a21o_1
XTAP_TAPCELL_ROW_26_327 VGND VPWR sky130_fd_sc_hd__tapvpwrvgnd_1
Xaccumulator._1447_ accumulator.io_accOut\[13\] accumulator._0541_ net69 VGND VGND
+ VPWR VPWR accumulator._0542_ sky130_fd_sc_hd__mux2_1
Xaccumulator._1378_ accumulator._0414_ VGND VGND VPWR VPWR accumulator._0473_ sky130_fd_sc_hd__buf_2
XFILLER_0_61_210 VGND VGND VPWR VPWR sky130_fd_sc_hd__decap_4
XFILLER_0_46_251 VGND VGND VPWR VPWR sky130_fd_sc_hd__fill_1
XTAP_TAPCELL_ROW_34_382 VGND VPWR sky130_fd_sc_hd__tapvpwrvgnd_1
XFILLER_0_16_27 VGND VGND VPWR VPWR sky130_fd_sc_hd__fill_1
XFILLER_0_4_329 VPWR VGND VPWR VGND sky130_ef_sc_hd__decap_12
XPHY_EDGE_ROW_2_Left_70 VGND VGND VPWR VPWR sky130_fd_sc_hd__decap_3
XscaleAdd._435_ scaleAdd._108_ scaleAdd._124_ VGND VGND VPWR VPWR scaleAdd._136_ sky130_fd_sc_hd__nor2_1
XscaleAdd._366_ net13 scaleAdd._011_ VGND VGND VPWR VPWR scaleAdd._071_ sky130_fd_sc_hd__or2_1
XscaleAdd._297_ operator.io_outMant\[1\] scaleAdd._207_ VGND VGND VPWR VPWR scaleAdd._005_
+ sky130_fd_sc_hd__nand2_1
XFILLER_0_20_173 VGND VGND VPWR VPWR sky130_fd_sc_hd__decap_8
XFILLER_0_20_195 VGND VGND VPWR VPWR sky130_fd_sc_hd__fill_1
XTAP_TAPCELL_ROW_48_485 VGND VPWR sky130_fd_sc_hd__tapvpwrvgnd_1
Xaccumulator._2350_ accumulator._0295_ accumulator._0296_ accumulator._0299_ VGND
+ VGND VPWR VPWR accumulator._0302_ sky130_fd_sc_hd__a21oi_1
Xaccumulator._2281_ accumulator._0351_ accumulator._0340_ VGND VGND VPWR VPWR accumulator._0233_
+ sky130_fd_sc_hd__nor2_1
Xaccumulator._1301_ accumulator._0395_ net82 VGND VGND VPWR VPWR accumulator._0396_
+ sky130_fd_sc_hd__xnor2_2
Xaccumulator._1232_ accumulator.io_inExp\[5\] accumulator._0105_ VGND VGND VPWR VPWR
+ accumulator._0329_ sky130_fd_sc_hd__or2_1
X_06_ accumulator.io_accOut\[6\] VGND VGND VPWR VPWR net51 sky130_fd_sc_hd__clkbuf_1
XTAP_TAPCELL_ROW_31_363 VGND VPWR sky130_fd_sc_hd__tapvpwrvgnd_1
XTAP_TAPCELL_ROW_23_308 VGND VPWR sky130_fd_sc_hd__tapvpwrvgnd_1
XFILLER_0_22_92 VPWR VGND VPWR VGND sky130_ef_sc_hd__decap_12
Xaccumulator._1996_ accumulator._1081_ accumulator._1084_ accumulator._1090_ VGND
+ VGND VPWR VPWR accumulator._1091_ sky130_fd_sc_hd__or3_4
Xoutput29 net29 VGND VGND VPWR VPWR io_accOut[15] sky130_fd_sc_hd__buf_2
XFILLER_0_11_140 VGND VGND VPWR VPWR sky130_fd_sc_hd__fill_1
XFILLER_0_66_357 VGND VGND VPWR VPWR sky130_fd_sc_hd__decap_6
XFILLER_0_34_287 VGND VGND VPWR VPWR sky130_fd_sc_hd__decap_3
XFILLER_0_34_232 VGND VGND VPWR VPWR sky130_fd_sc_hd__decap_4
XFILLER_0_43_14 VGND VGND VPWR VPWR sky130_fd_sc_hd__fill_2
XFILLER_0_57_335 VGND VGND VPWR VPWR sky130_fd_sc_hd__fill_1
XFILLER_0_25_221 VGND VGND VPWR VPWR sky130_fd_sc_hd__decap_3
Xaccumulator._1850_ accumulator._0919_ accumulator._0925_ accumulator._0932_ accumulator._0933_
+ accumulator._0944_ VGND VGND VPWR VPWR accumulator._0945_ sky130_fd_sc_hd__a41o_1
XFILLER_0_25_276 VGND VGND VPWR VPWR sky130_fd_sc_hd__decap_4
Xaccumulator._1781_ accumulator._0787_ accumulator._0718_ VGND VGND VPWR VPWR accumulator._0876_
+ sky130_fd_sc_hd__or2_1
XFILLER_0_4_137 VGND VGND VPWR VPWR sky130_fd_sc_hd__decap_3
XFILLER_0_0_321 VGND VGND VPWR VPWR sky130_fd_sc_hd__decap_4
XFILLER_0_7_69 VPWR VGND VPWR VGND sky130_ef_sc_hd__decap_12
Xaccumulator._2333_ accumulator.io_accOut\[28\] accumulator._0383_ VGND VGND VPWR
+ VPWR accumulator._0285_ sky130_fd_sc_hd__or2_1
XscaleAdd._418_ scaleAdd._118_ net73 VGND VGND VPWR VPWR accumulator.io_inMant\[11\]
+ sky130_fd_sc_hd__xor2_2
XFILLER_0_0_365 VGND VGND VPWR VPWR sky130_fd_sc_hd__decap_3
XscaleAdd._349_ scaleAdd._054_ scaleAdd._051_ VGND VGND VPWR VPWR scaleAdd._055_ sky130_fd_sc_hd__xor2_4
Xaccumulator._2195_ accumulator._1111_ accumulator._1028_ accumulator._0046_ VGND
+ VGND VPWR VPWR accumulator._0149_ sky130_fd_sc_hd__mux2_2
XFILLER_0_48_346 VPWR VGND VPWR VGND sky130_ef_sc_hd__decap_12
Xaccumulator._2264_ accumulator._0392_ accumulator._0216_ VGND VGND VPWR VPWR accumulator._0217_
+ sky130_fd_sc_hd__or2_4
XTAP_TAPCELL_ROW_36_400 VGND VPWR sky130_fd_sc_hd__tapvpwrvgnd_1
XPHY_EDGE_ROW_5_Right_5 VGND VGND VPWR VPWR sky130_fd_sc_hd__decap_3
Xaccumulator._1215_ accumulator.io_inExp\[1\] accumulator._0203_ VGND VGND VPWR VPWR
+ accumulator._0312_ sky130_fd_sc_hd__nand2_1
XFILLER_0_63_349 VPWR VGND VPWR VGND sky130_ef_sc_hd__decap_12
XFILLER_0_63_305 VPWR VGND VPWR VGND sky130_ef_sc_hd__decap_12
Xaccumulator._1979_ accumulator._0907_ accumulator._1073_ VGND VGND VPWR VPWR accumulator._1074_
+ sky130_fd_sc_hd__xnor2_4
XFILLER_0_3_181 VPWR VGND VPWR VGND sky130_ef_sc_hd__decap_12
XTAP_TAPCELL_ROW_59_558 VGND VPWR sky130_fd_sc_hd__tapvpwrvgnd_1
XFILLER_0_54_305 VGND VGND VPWR VPWR sky130_fd_sc_hd__decap_3
XFILLER_0_39_379 VGND VGND VPWR VPWR sky130_fd_sc_hd__decap_4
XFILLER_0_13_39 VPWR VGND VPWR VGND sky130_ef_sc_hd__decap_12
XFILLER_0_22_213 VPWR VGND VPWR VGND sky130_ef_sc_hd__decap_12
XFILLER_0_57_143 VPWR VGND VPWR VGND sky130_ef_sc_hd__decap_12
XFILLER_0_54_79 VGND VGND VPWR VPWR sky130_fd_sc_hd__decap_4
Xaccumulator._1902_ accumulator._0996_ accumulator._0992_ accumulator._0988_ VGND
+ VGND VPWR VPWR accumulator._0997_ sky130_fd_sc_hd__and3_1
XFILLER_0_53_393 VGND VGND VPWR VPWR sky130_fd_sc_hd__decap_8
Xaccumulator._1833_ accumulator._0784_ accumulator._0864_ accumulator._0532_ VGND
+ VGND VPWR VPWR accumulator._0928_ sky130_fd_sc_hd__and3b_1
Xaccumulator._1764_ accumulator.io_accOut\[15\] VGND VGND VPWR VPWR accumulator._0859_
+ sky130_fd_sc_hd__inv_2
Xaccumulator._1695_ accumulator._0788_ accumulator._0762_ accumulator._0789_ VGND
+ VGND VPWR VPWR accumulator._0790_ sky130_fd_sc_hd__o21ba_1
XFILLER_0_13_235 VGND VGND VPWR VPWR sky130_fd_sc_hd__decap_3
XTAP_TAPCELL_ROW_56_539 VGND VPWR sky130_fd_sc_hd__tapvpwrvgnd_1
Xaccumulator._2316_ accumulator._0341_ VGND VGND VPWR VPWR accumulator._0267_ sky130_fd_sc_hd__inv_2
XFILLER_0_28_80 VGND VGND VPWR VPWR sky130_fd_sc_hd__decap_4
XTAP_TAPCELL_ROW_64_594 VGND VPWR sky130_fd_sc_hd__tapvpwrvgnd_1
Xaccumulator._2247_ accumulator._0170_ accumulator._0199_ accumulator._1128_ VGND
+ VGND VPWR VPWR accumulator._0200_ sky130_fd_sc_hd__mux2_4
XFILLER_0_63_113 VGND VGND VPWR VPWR sky130_fd_sc_hd__fill_1
XFILLER_0_48_132 VGND VGND VPWR VPWR sky130_fd_sc_hd__decap_8
Xaccumulator._2178_ accumulator.io_accOut\[9\] accumulator._0392_ accumulator._1122_
+ accumulator._0132_ VGND VGND VPWR VPWR accumulator._0133_ sky130_fd_sc_hd__a22o_1
XFILLER_0_36_349 VPWR VGND VPWR VGND sky130_ef_sc_hd__decap_12
XFILLER_0_8_240 VGND VGND VPWR VPWR sky130_fd_sc_hd__decap_4
XFILLER_0_8_284 VPWR VGND VPWR VGND sky130_ef_sc_hd__decap_12
XFILLER_0_39_110 VGND VGND VPWR VPWR sky130_fd_sc_hd__fill_2
XTAP_TAPCELL_ROW_4_172 VGND VPWR sky130_fd_sc_hd__tapvpwrvgnd_1
XFILLER_0_54_102 VGND VGND VPWR VPWR sky130_fd_sc_hd__fill_1
XFILLER_0_35_393 VGND VGND VPWR VPWR sky130_fd_sc_hd__fill_1
XFILLER_0_49_79 VPWR VGND VPWR VGND sky130_ef_sc_hd__decap_12
XFILLER_0_49_35 VPWR VGND VPWR VGND sky130_ef_sc_hd__decap_12
XFILLER_0_4_15 VPWR VGND VPWR VGND sky130_ef_sc_hd__decap_12
Xaccumulator._1480_ accumulator._0574_ VGND VGND VPWR VPWR accumulator._0575_ sky130_fd_sc_hd__inv_2
XTAP_TAPCELL_ROW_61_575 VGND VPWR sky130_fd_sc_hd__tapvpwrvgnd_1
Xaccumulator._2032_ accumulator._1126_ VGND VGND VPWR VPWR accumulator._1127_ sky130_fd_sc_hd__buf_8
Xaccumulator._2101_ accumulator._1171_ VGND VGND VPWR VPWR accumulator._0057_ sky130_fd_sc_hd__buf_8
XFILLER_0_45_113 VPWR VGND VPWR VGND sky130_ef_sc_hd__decap_12
XTAP_TAPCELL_ROW_18_274 VGND VPWR sky130_fd_sc_hd__tapvpwrvgnd_1
XFILLER_0_18_338 VGND VGND VPWR VPWR sky130_fd_sc_hd__fill_1
XFILLER_0_5_298 VPWR VGND VPWR VGND sky130_ef_sc_hd__decap_12
Xaccumulator._1747_ accumulator._0667_ accumulator._0841_ VGND VGND VPWR VPWR accumulator._0842_
+ sky130_fd_sc_hd__or2b_1
Xaccumulator._1678_ accumulator._0771_ accumulator._0772_ VGND VGND VPWR VPWR accumulator._0773_
+ sky130_fd_sc_hd__nor2_2
Xaccumulator._1816_ accumulator._0663_ accumulator._0787_ accumulator._0903_ VGND
+ VGND VPWR VPWR accumulator._0911_ sky130_fd_sc_hd__o21a_1
XTAP_TAPCELL_ROW_1_153 VGND VPWR sky130_fd_sc_hd__tapvpwrvgnd_1
XFILLER_0_17_382 VGND VGND VPWR VPWR sky130_fd_sc_hd__decap_8
XFILLER_0_32_385 VGND VGND VPWR VPWR sky130_fd_sc_hd__fill_1
XFILLER_0_32_330 VGND VGND VPWR VPWR sky130_fd_sc_hd__decap_6
XFILLER_0_10_29 VPWR VGND VPWR VGND sky130_ef_sc_hd__decap_12
XFILLER_0_17_393 VGND VGND VPWR VPWR sky130_fd_sc_hd__decap_8
XFILLER_0_19_27 VGND VGND VPWR VPWR sky130_fd_sc_hd__decap_4
XFILLER_0_27_135 VGND VGND VPWR VPWR sky130_fd_sc_hd__decap_8
XFILLER_0_27_113 VGND VGND VPWR VPWR sky130_fd_sc_hd__decap_6
XFILLER_0_50_160 VGND VGND VPWR VPWR sky130_fd_sc_hd__fill_1
XFILLER_0_35_190 VGND VGND VPWR VPWR sky130_fd_sc_hd__decap_4
XFILLER_0_27_157 VGND VGND VPWR VPWR sky130_fd_sc_hd__decap_8
XFILLER_0_23_352 VGND VGND VPWR VPWR sky130_fd_sc_hd__fill_2
XFILLER_0_2_235 VPWR VGND VPWR VGND sky130_ef_sc_hd__decap_12
Xaccumulator._1601_ accumulator._0694_ accumulator._0695_ VGND VGND VPWR VPWR accumulator._0696_
+ sky130_fd_sc_hd__xor2_2
XFILLER_0_23_396 VGND VGND VPWR VPWR sky130_fd_sc_hd__decap_4
Xaccumulator._1532_ accumulator._0626_ accumulator._0625_ accumulator._0462_ VGND
+ VGND VPWR VPWR accumulator._0627_ sky130_fd_sc_hd__a21o_1
XFILLER_0_2_279 VGND VGND VPWR VPWR sky130_fd_sc_hd__decap_6
Xaccumulator._1463_ accumulator._0490_ accumulator._0497_ accumulator._0473_ VGND
+ VGND VPWR VPWR accumulator._0558_ sky130_fd_sc_hd__a21o_1
Xaccumulator._1394_ accumulator._0421_ accumulator._0443_ accumulator._0458_ accumulator._0485_
+ accumulator._0488_ VGND VGND VPWR VPWR accumulator._0489_ sky130_fd_sc_hd__a311o_1
XFILLER_0_58_293 VGND VGND VPWR VPWR sky130_fd_sc_hd__decap_8
XFILLER_0_58_282 VGND VGND VPWR VPWR sky130_fd_sc_hd__decap_4
Xaccumulator._2015_ accumulator._0946_ accumulator._0978_ VGND VGND VPWR VPWR accumulator._1110_
+ sky130_fd_sc_hd__or2_1
XFILLER_0_18_124 VGND VGND VPWR VPWR sky130_fd_sc_hd__decap_4
XFILLER_0_18_135 VGND VGND VPWR VPWR sky130_fd_sc_hd__decap_4
XFILLER_0_18_146 VPWR VGND VPWR VGND sky130_ef_sc_hd__decap_12
XFILLER_0_1_290 VGND VGND VPWR VPWR sky130_fd_sc_hd__fill_1
XFILLER_0_49_271 VGND VGND VPWR VPWR sky130_fd_sc_hd__decap_8
XTAP_TAPCELL_ROW_29_347 VGND VPWR sky130_fd_sc_hd__tapvpwrvgnd_1
XFILLER_0_24_138 VGND VGND VPWR VPWR sky130_fd_sc_hd__fill_2
XFILLER_0_21_39 VPWR VGND VPWR VGND sky130_ef_sc_hd__decap_12
XFILLER_0_32_182 VPWR VGND VPWR VGND sky130_ef_sc_hd__decap_12
XscaleAdd._382_ scaleAdd._085_ scaleAdd._086_ VGND VGND VPWR VPWR scaleAdd._087_ sky130_fd_sc_hd__or2b_1
XscaleAdd._451_ net14 net17 VGND VGND VPWR VPWR scaleAdd._148_ sky130_fd_sc_hd__nand2_1
X_22_ accumulator.io_accOut\[22\] VGND VGND VPWR VPWR net37 sky130_fd_sc_hd__buf_1
XFILLER_0_1_27 VPWR VGND VPWR VGND sky130_ef_sc_hd__decap_12
XFILLER_0_62_68 VGND VGND VPWR VPWR sky130_fd_sc_hd__decap_8
XFILLER_0_15_127 VGND VGND VPWR VPWR sky130_fd_sc_hd__decap_6
XFILLER_0_23_160 VGND VGND VPWR VPWR sky130_fd_sc_hd__decap_8
XFILLER_0_11_83 VGND VGND VPWR VPWR sky130_fd_sc_hd__decap_3
XFILLER_0_11_94 VGND VGND VPWR VPWR sky130_fd_sc_hd__fill_1
XFILLER_0_15_149 VGND VGND VPWR VPWR sky130_fd_sc_hd__fill_2
XFILLER_0_39_3 VGND VGND VPWR VPWR sky130_fd_sc_hd__decap_8
Xaccumulator._1515_ accumulator._0563_ accumulator._0525_ accumulator._0609_ VGND
+ VGND VPWR VPWR accumulator._0610_ sky130_fd_sc_hd__a21oi_2
XTAP_TAPCELL_ROW_26_328 VGND VPWR sky130_fd_sc_hd__tapvpwrvgnd_1
Xaccumulator._1377_ accumulator.io_accOut\[21\] accumulator._0471_ accumulator._0376_
+ VGND VGND VPWR VPWR accumulator._0472_ sky130_fd_sc_hd__mux2_4
Xaccumulator._1446_ accumulator._0335_ accumulator._0467_ VGND VGND VPWR VPWR accumulator._0541_
+ sky130_fd_sc_hd__nor2_1
XFILLER_0_46_285 VGND VGND VPWR VPWR sky130_fd_sc_hd__decap_3
XTAP_TAPCELL_ROW_34_383 VGND VPWR sky130_fd_sc_hd__tapvpwrvgnd_1
XFILLER_0_32_27 VGND VGND VPWR VPWR sky130_fd_sc_hd__fill_1
XFILLER_0_52_233 VGND VGND VPWR VPWR sky130_fd_sc_hd__decap_4
XscaleAdd._434_ scaleAdd._190_ scaleAdd._106_ scaleAdd._128_ VGND VGND VPWR VPWR scaleAdd._135_
+ sky130_fd_sc_hd__and3_1
XFILLER_0_20_141 VGND VGND VPWR VPWR sky130_fd_sc_hd__decap_4
XFILLER_0_57_57 VGND VGND VPWR VPWR sky130_fd_sc_hd__decap_8
XFILLER_0_57_35 VGND VGND VPWR VPWR sky130_fd_sc_hd__fill_2
Xaccumulator._1300_ accumulator._0362_ accumulator._0342_ VGND VGND VPWR VPWR accumulator._0395_
+ sky130_fd_sc_hd__or2b_1
XscaleAdd._365_ net13 scaleAdd._011_ VGND VGND VPWR VPWR scaleAdd._070_ sky130_fd_sc_hd__nand2_1
XscaleAdd._296_ scaleAdd._002_ scaleAdd._003_ VGND VGND VPWR VPWR scaleAdd._004_ sky130_fd_sc_hd__and2b_1
Xaccumulator._2280_ accumulator._0226_ accumulator._0231_ accumulator._0074_ VGND
+ VGND VPWR VPWR accumulator._0024_ sky130_fd_sc_hd__a21oi_1
X_05_ accumulator.io_accOut\[5\] VGND VGND VPWR VPWR net50 sky130_fd_sc_hd__buf_1
XTAP_TAPCELL_ROW_23_309 VGND VPWR sky130_fd_sc_hd__tapvpwrvgnd_1
Xaccumulator._1231_ accumulator._0085_ accumulator._0125_ accumulator._0315_ accumulator._0095_
+ VGND VGND VPWR VPWR accumulator._0328_ sky130_fd_sc_hd__a31o_1
XTAP_TAPCELL_ROW_31_364 VGND VPWR sky130_fd_sc_hd__tapvpwrvgnd_1
Xaccumulator._1995_ accumulator._1086_ accumulator._0945_ accumulator._1089_ VGND
+ VGND VPWR VPWR accumulator._1090_ sky130_fd_sc_hd__mux2_2
XFILLER_0_11_163 VGND VGND VPWR VPWR sky130_fd_sc_hd__decap_4
XTAP_TAPCELL_ROW_39_420 VGND VPWR sky130_fd_sc_hd__tapvpwrvgnd_1
Xaccumulator._1429_ accumulator._0473_ accumulator._0505_ accumulator._0523_ VGND
+ VGND VPWR VPWR accumulator._0524_ sky130_fd_sc_hd__and3_1
XFILLER_0_34_266 VGND VGND VPWR VPWR sky130_fd_sc_hd__decap_4
XFILLER_0_34_244 VGND VGND VPWR VPWR sky130_fd_sc_hd__fill_1
XFILLER_0_65_391 VGND VGND VPWR VPWR sky130_fd_sc_hd__fill_1
XFILLER_0_25_255 VGND VGND VPWR VPWR sky130_fd_sc_hd__fill_2
Xaccumulator._1780_ accumulator._0873_ accumulator._0874_ VGND VGND VPWR VPWR accumulator._0875_
+ sky130_fd_sc_hd__xor2_2
XscaleAdd._417_ scaleAdd._103_ scaleAdd._102_ scaleAdd._119_ VGND VGND VPWR VPWR scaleAdd._120_
+ sky130_fd_sc_hd__a21bo_1
XFILLER_0_0_300 VGND VGND VPWR VPWR sky130_fd_sc_hd__decap_4
XFILLER_0_7_15 VPWR VGND VPWR VGND sky130_ef_sc_hd__decap_12
Xaccumulator._2263_ accumulator._1121_ accumulator._0210_ accumulator._0215_ accumulator._1092_
+ accumulator._0155_ VGND VGND VPWR VPWR accumulator._0216_ sky130_fd_sc_hd__o32a_1
Xaccumulator._2332_ accumulator._0278_ accumulator._0274_ accumulator._0282_ accumulator._0392_
+ VGND VGND VPWR VPWR accumulator._0284_ sky130_fd_sc_hd__a31o_1
XTAP_TAPCELL_ROW_36_401 VGND VPWR sky130_fd_sc_hd__tapvpwrvgnd_1
XscaleAdd._348_ scaleAdd._021_ scaleAdd._052_ scaleAdd._053_ VGND VGND VPWR VPWR scaleAdd._054_
+ sky130_fd_sc_hd__a21o_4
XscaleAdd._279_ net12 net11 net13 net10 VGND VGND VPWR VPWR scaleAdd._221_ sky130_fd_sc_hd__a22o_1
XFILLER_0_63_317 VPWR VGND VPWR VGND sky130_ef_sc_hd__decap_12
Xaccumulator._2194_ accumulator._1117_ accumulator._1113_ accumulator._0046_ VGND
+ VGND VPWR VPWR accumulator._0148_ sky130_fd_sc_hd__mux2_2
XFILLER_0_48_358 VGND VGND VPWR VPWR sky130_fd_sc_hd__decap_6
Xaccumulator._1214_ accumulator.io_inMant\[15\] accumulator._0291_ accumulator._0309_
+ accumulator._0310_ VGND VGND VPWR VPWR accumulator._0311_ sky130_fd_sc_hd__o22a_4
Xaccumulator._1978_ accumulator._0919_ accumulator._1070_ accumulator._1072_ accumulator._0910_
+ VGND VGND VPWR VPWR accumulator._1073_ sky130_fd_sc_hd__o2bb2a_2
XFILLER_0_3_193 VPWR VGND VPWR VGND sky130_ef_sc_hd__decap_12
XTAP_TAPCELL_ROW_59_559 VGND VPWR sky130_fd_sc_hd__tapvpwrvgnd_1
XFILLER_0_66_188 VGND VGND VPWR VPWR sky130_fd_sc_hd__decap_8
XFILLER_0_66_177 VGND VGND VPWR VPWR sky130_fd_sc_hd__fill_2
XFILLER_0_54_328 VGND VGND VPWR VPWR sky130_fd_sc_hd__decap_3
XTAP_TAPCELL_ROW_42_437 VGND VPWR sky130_fd_sc_hd__tapvpwrvgnd_1
XFILLER_0_39_347 VPWR VGND VPWR VGND sky130_ef_sc_hd__decap_12
XPHY_EDGE_ROW_11_Right_11 VGND VGND VPWR VPWR sky130_fd_sc_hd__decap_3
XFILLER_0_38_15 VPWR VGND VPWR VGND sky130_ef_sc_hd__decap_12
XFILLER_0_22_225 VPWR VGND VPWR VGND sky130_ef_sc_hd__decap_12
XFILLER_0_22_203 VGND VGND VPWR VPWR sky130_fd_sc_hd__decap_6
XPHY_EDGE_ROW_20_Right_20 VGND VGND VPWR VPWR sky130_fd_sc_hd__decap_3
XTAP_TAPCELL_ROW_7_192 VGND VPWR sky130_fd_sc_hd__tapvpwrvgnd_1
XFILLER_0_57_155 VGND VGND VPWR VPWR sky130_fd_sc_hd__decap_3
XPHY_EDGE_ROW_35_Left_103 VGND VGND VPWR VPWR sky130_fd_sc_hd__decap_3
XFILLER_0_60_309 VPWR VGND VPWR VGND sky130_ef_sc_hd__decap_12
XFILLER_0_57_188 VPWR VGND VPWR VGND sky130_ef_sc_hd__decap_12
XFILLER_0_53_361 VPWR VGND VPWR VGND sky130_ef_sc_hd__decap_12
XPHY_EDGE_ROW_44_Left_112 VGND VGND VPWR VPWR sky130_fd_sc_hd__decap_3
Xaccumulator._1901_ accumulator._0995_ accumulator._0792_ VGND VGND VPWR VPWR accumulator._0996_
+ sky130_fd_sc_hd__xor2_2
XFILLER_0_38_380 VGND VGND VPWR VPWR sky130_fd_sc_hd__fill_1
Xaccumulator._1832_ accumulator._0532_ accumulator._0773_ accumulator._0782_ accumulator._0864_
+ VGND VGND VPWR VPWR accumulator._0927_ sky130_fd_sc_hd__and4_1
XFILLER_0_13_225 VGND VGND VPWR VPWR sky130_fd_sc_hd__decap_6
Xaccumulator._1694_ accumulator._0606_ accumulator._0607_ VGND VGND VPWR VPWR accumulator._0789_
+ sky130_fd_sc_hd__or2b_1
Xaccumulator._1763_ accumulator._0578_ accumulator._0829_ VGND VGND VPWR VPWR accumulator._0858_
+ sky130_fd_sc_hd__or2_1
XFILLER_0_0_141 VGND VGND VPWR VPWR sky130_fd_sc_hd__decap_8
Xaccumulator._2246_ accumulator._0197_ accumulator._0198_ accumulator._0044_ VGND
+ VGND VPWR VPWR accumulator._0199_ sky130_fd_sc_hd__mux2_4
Xaccumulator._2315_ accumulator._1120_ accumulator._0255_ VGND VGND VPWR VPWR accumulator._0266_
+ sky130_fd_sc_hd__or2b_1
XPHY_EDGE_ROW_53_Left_121 VGND VGND VPWR VPWR sky130_fd_sc_hd__decap_3
XFILLER_0_21_3 VPWR VGND VPWR VGND sky130_ef_sc_hd__decap_12
XTAP_TAPCELL_ROW_64_595 VGND VPWR sky130_fd_sc_hd__tapvpwrvgnd_1
XPHY_EDGE_ROW_62_Left_130 VGND VGND VPWR VPWR sky130_fd_sc_hd__decap_3
Xaccumulator._2177_ accumulator._0129_ accumulator._0131_ accumulator._1128_ VGND
+ VGND VPWR VPWR accumulator._0132_ sky130_fd_sc_hd__mux2_4
XFILLER_0_48_144 VGND VGND VPWR VPWR sky130_fd_sc_hd__fill_1
XFILLER_0_8_296 VGND VGND VPWR VPWR sky130_fd_sc_hd__fill_2
XTAP_TAPCELL_ROW_4_173 VGND VPWR sky130_fd_sc_hd__tapvpwrvgnd_1
XFILLER_0_39_155 VGND VGND VPWR VPWR sky130_fd_sc_hd__fill_1
XFILLER_0_24_17 VGND VGND VPWR VPWR sky130_fd_sc_hd__decap_8
XFILLER_0_42_309 VGND VGND VPWR VPWR sky130_fd_sc_hd__decap_8
XFILLER_0_40_27 VGND VGND VPWR VPWR sky130_fd_sc_hd__fill_1
XFILLER_0_49_47 VGND VGND VPWR VPWR sky130_fd_sc_hd__fill_1
XFILLER_0_4_27 VGND VGND VPWR VPWR sky130_fd_sc_hd__fill_1
XFILLER_0_10_217 VGND VGND VPWR VPWR sky130_fd_sc_hd__fill_1
XFILLER_0_65_57 VPWR VGND VPWR VGND sky130_ef_sc_hd__decap_12
Xaccumulator._2100_ accumulator._0053_ accumulator._0054_ accumulator._0042_ VGND
+ VGND VPWR VPWR accumulator._0056_ sky130_fd_sc_hd__mux2_4
Xaccumulator._2031_ accumulator._1125_ accumulator._1091_ VGND VGND VPWR VPWR accumulator._1126_
+ sky130_fd_sc_hd__or2_4
XTAP_TAPCELL_ROW_61_576 VGND VPWR sky130_fd_sc_hd__tapvpwrvgnd_1
XFILLER_0_45_125 VPWR VGND VPWR VGND sky130_ef_sc_hd__decap_12
XFILLER_0_5_211 VGND VGND VPWR VPWR sky130_fd_sc_hd__decap_4
XTAP_TAPCELL_ROW_18_275 VGND VPWR sky130_fd_sc_hd__tapvpwrvgnd_1
XFILLER_0_60_139 VGND VGND VPWR VPWR sky130_fd_sc_hd__fill_1
XFILLER_0_60_117 VGND VGND VPWR VPWR sky130_fd_sc_hd__decap_4
Xaccumulator._1815_ accumulator._0608_ accumulator._0677_ accumulator._0787_ accumulator._0899_
+ VGND VGND VPWR VPWR accumulator._0910_ sky130_fd_sc_hd__o31a_1
XFILLER_0_5_277 VGND VGND VPWR VPWR sky130_fd_sc_hd__decap_3
Xaccumulator._1746_ accumulator._0683_ accumulator._0840_ VGND VGND VPWR VPWR accumulator._0841_
+ sky130_fd_sc_hd__nand2_1
Xaccumulator._1677_ accumulator._0769_ accumulator._0770_ VGND VGND VPWR VPWR accumulator._0772_
+ sky130_fd_sc_hd__nor2_1
Xaccumulator._2229_ accumulator._1162_ accumulator._1143_ net101 VGND VGND VPWR VPWR
+ accumulator._0182_ sky130_fd_sc_hd__mux2_1
XTAP_TAPCELL_ROW_52_510 VGND VPWR sky130_fd_sc_hd__tapvpwrvgnd_1
XTAP_TAPCELL_ROW_1_154 VGND VPWR sky130_fd_sc_hd__tapvpwrvgnd_1
XFILLER_0_44_191 VGND VGND VPWR VPWR sky130_fd_sc_hd__decap_4
XFILLER_0_36_169 VGND VGND VPWR VPWR sky130_fd_sc_hd__fill_1
XFILLER_0_24_309 VPWR VGND VPWR VGND sky130_ef_sc_hd__decap_12
XTAP_TAPCELL_ROW_9_210 VGND VPWR sky130_fd_sc_hd__tapvpwrvgnd_1
XFILLER_0_51_15 VPWR VGND VPWR VGND sky130_ef_sc_hd__decap_12
XFILLER_0_27_169 VGND VGND VPWR VPWR sky130_fd_sc_hd__decap_3
XFILLER_0_2_247 VGND VGND VPWR VPWR sky130_fd_sc_hd__decap_4
Xaccumulator._1600_ accumulator.io_accOut\[4\] accumulator._0378_ VGND VGND VPWR VPWR
+ accumulator._0695_ sky130_fd_sc_hd__nand2_1
Xaccumulator._1531_ accumulator._0505_ accumulator._0546_ accumulator._0418_ VGND
+ VGND VPWR VPWR accumulator._0626_ sky130_fd_sc_hd__a21o_1
Xaccumulator._1462_ accumulator._0555_ accumulator._0556_ accumulator._0500_ VGND
+ VGND VPWR VPWR accumulator._0557_ sky130_fd_sc_hd__a21o_1
Xaccumulator._1393_ accumulator._0486_ accumulator._0487_ VGND VGND VPWR VPWR accumulator._0488_
+ sky130_fd_sc_hd__xnor2_2
Xaccumulator._2014_ accumulator._1101_ accumulator._1108_ VGND VGND VPWR VPWR accumulator._1109_
+ sky130_fd_sc_hd__nand2_1
XFILLER_0_14_320 VGND VGND VPWR VPWR sky130_fd_sc_hd__fill_1
XFILLER_0_18_158 VPWR VGND VPWR VGND sky130_ef_sc_hd__decap_12
XFILLER_0_41_161 VGND VGND VPWR VPWR sky130_fd_sc_hd__decap_6
XTAP_TAPCELL_ROW_29_348 VGND VPWR sky130_fd_sc_hd__tapvpwrvgnd_1
XFILLER_0_5_81 VPWR VGND VPWR VGND sky130_ef_sc_hd__decap_12
Xaccumulator._1729_ accumulator._0563_ accumulator._0700_ accumulator._0701_ accumulator._0554_
+ VGND VGND VPWR VPWR accumulator._0824_ sky130_fd_sc_hd__o211a_1
XFILLER_0_64_253 VPWR VGND VPWR VGND sky130_ef_sc_hd__decap_12
XscaleAdd._450_ scaleAdd._185_ scaleAdd._191_ scaleAdd._189_ scaleAdd._029_ VGND VGND
+ VPWR VPWR accumulator.io_inMant\[2\] sky130_fd_sc_hd__a22o_1
XFILLER_0_46_26 VGND VGND VPWR VPWR sky130_fd_sc_hd__fill_2
X_21_ accumulator.io_accOut\[21\] VGND VGND VPWR VPWR net36 sky130_fd_sc_hd__buf_1
XFILLER_0_32_194 VGND VGND VPWR VPWR sky130_fd_sc_hd__fill_2
XscaleAdd._381_ scaleAdd._083_ scaleAdd._084_ scaleAdd._068_ VGND VGND VPWR VPWR scaleAdd._086_
+ sky130_fd_sc_hd__a21o_1
XFILLER_0_20_378 VGND VGND VPWR VPWR sky130_fd_sc_hd__decap_8
XFILLER_0_1_39 VPWR VGND VPWR VGND sky130_ef_sc_hd__decap_12
XFILLER_0_7_306 VGND VGND VPWR VPWR sky130_fd_sc_hd__decap_8
XFILLER_0_11_51 VGND VGND VPWR VPWR sky130_fd_sc_hd__decap_4
XPHY_EDGE_ROW_49_Right_49 VGND VGND VPWR VPWR sky130_fd_sc_hd__decap_3
XFILLER_0_30_109 VGND VGND VPWR VPWR sky130_fd_sc_hd__decap_8
XFILLER_0_23_183 VPWR VGND VPWR VGND sky130_ef_sc_hd__decap_12
XFILLER_0_11_356 VGND VGND VPWR VPWR sky130_fd_sc_hd__decap_3
XPHY_EDGE_ROW_58_Right_58 VGND VGND VPWR VPWR sky130_fd_sc_hd__decap_3
Xaccumulator._1445_ accumulator._0490_ accumulator._0508_ accumulator._0473_ VGND
+ VGND VPWR VPWR accumulator._0540_ sky130_fd_sc_hd__a21o_1
Xaccumulator._1514_ accumulator._0500_ accumulator._0474_ accumulator._0484_ VGND
+ VGND VPWR VPWR accumulator._0609_ sky130_fd_sc_hd__and3_1
XFILLER_0_38_209 VGND VGND VPWR VPWR sky130_fd_sc_hd__fill_2
XTAP_TAPCELL_ROW_34_384 VGND VPWR sky130_fd_sc_hd__tapvpwrvgnd_1
XTAP_TAPCELL_ROW_26_329 VGND VPWR sky130_fd_sc_hd__tapvpwrvgnd_1
Xaccumulator._1376_ accumulator._0463_ accumulator._0464_ accumulator._0468_ accumulator._0470_
+ VGND VGND VPWR VPWR accumulator._0471_ sky130_fd_sc_hd__a211o_1
XPHY_EDGE_ROW_67_Right_67 VGND VGND VPWR VPWR sky130_fd_sc_hd__decap_3
XFILLER_0_46_253 VGND VGND VPWR VPWR sky130_fd_sc_hd__decap_8
XFILLER_0_16_29 VPWR VGND VPWR VGND sky130_ef_sc_hd__decap_12
XFILLER_0_4_309 VGND VGND VPWR VPWR sky130_fd_sc_hd__decap_6
XscaleAdd._433_ scaleAdd._132_ net72 VGND VGND VPWR VPWR accumulator.io_inMant\[12\]
+ sky130_fd_sc_hd__xor2_2
XFILLER_0_12_109 VGND VGND VPWR VPWR sky130_fd_sc_hd__fill_1
X_04_ accumulator.io_accOut\[4\] VGND VGND VPWR VPWR net49 sky130_fd_sc_hd__buf_1
XscaleAdd._364_ scaleAdd._190_ scaleAdd._055_ VGND VGND VPWR VPWR scaleAdd._069_ sky130_fd_sc_hd__nand2_1
XscaleAdd._295_ scaleAdd._000_ scaleAdd._001_ scaleAdd._209_ VGND VGND VPWR VPWR scaleAdd._003_
+ sky130_fd_sc_hd__a21o_1
XFILLER_0_28_242 VGND VGND VPWR VPWR sky130_fd_sc_hd__decap_8
Xaccumulator._1230_ accumulator._0326_ accumulator._0316_ accumulator._0317_ VGND
+ VGND VPWR VPWR accumulator._0327_ sky130_fd_sc_hd__nand3b_1
Xaccumulator._1994_ accumulator._0916_ accumulator._0920_ accumulator._1088_ accumulator._0535_
+ VGND VGND VPWR VPWR accumulator._1089_ sky130_fd_sc_hd__o2bb2a_1
XTAP_TAPCELL_ROW_31_365 VGND VPWR sky130_fd_sc_hd__tapvpwrvgnd_1
XFILLER_0_28_253 VGND VGND VPWR VPWR sky130_fd_sc_hd__decap_6
XFILLER_0_22_83 VGND VGND VPWR VPWR sky130_fd_sc_hd__fill_1
XFILLER_0_7_158 VGND VGND VPWR VPWR sky130_fd_sc_hd__decap_8
XFILLER_0_7_169 VPWR VGND VPWR VGND sky130_ef_sc_hd__decap_12
XFILLER_0_51_3 VPWR VGND VPWR VGND sky130_ef_sc_hd__decap_12
XFILLER_0_11_153 VGND VGND VPWR VPWR sky130_fd_sc_hd__decap_4
XFILLER_0_47_80 VGND VGND VPWR VPWR sky130_fd_sc_hd__decap_6
XTAP_TAPCELL_ROW_39_421 VGND VPWR sky130_fd_sc_hd__tapvpwrvgnd_1
Xaccumulator._1428_ accumulator.io_accOut\[22\] accumulator._0522_ net69 VGND VGND
+ VPWR VPWR accumulator._0523_ sky130_fd_sc_hd__mux2_1
Xaccumulator._1359_ net94 accumulator._0450_ accumulator._0453_ net92 VGND VGND VPWR
+ VPWR accumulator._0454_ sky130_fd_sc_hd__a22o_1
XFILLER_0_57_337 VPWR VGND VPWR VGND sky130_ef_sc_hd__decap_12
XFILLER_0_43_27 VGND VGND VPWR VPWR sky130_fd_sc_hd__decap_8
XFILLER_0_40_204 VGND VGND VPWR VPWR sky130_fd_sc_hd__decap_8
XFILLER_0_7_27 VPWR VGND VPWR VGND sky130_ef_sc_hd__decap_12
XscaleAdd._416_ scaleAdd._100_ scaleAdd._101_ VGND VGND VPWR VPWR scaleAdd._119_ sky130_fd_sc_hd__nand2_1
XscaleAdd._347_ scaleAdd._020_ scaleAdd._017_ VGND VGND VPWR VPWR scaleAdd._053_ sky130_fd_sc_hd__and2b_1
XFILLER_0_0_389 VGND VGND VPWR VPWR sky130_fd_sc_hd__decap_3
Xaccumulator._2262_ accumulator._0080_ accumulator._0198_ accumulator._0214_ VGND
+ VGND VPWR VPWR accumulator._0215_ sky130_fd_sc_hd__o21a_1
Xaccumulator._2331_ accumulator._0278_ accumulator._0274_ accumulator._0282_ VGND
+ VGND VPWR VPWR accumulator._0283_ sky130_fd_sc_hd__a21oi_1
Xaccumulator._1213_ accumulator.io_inMant\[15\] accumulator.io_inMant\[13\] VGND VGND
+ VPWR VPWR accumulator._0310_ sky130_fd_sc_hd__or2_1
XscaleAdd._278_ scaleAdd._217_ scaleAdd._219_ VGND VGND VPWR VPWR scaleAdd._220_ sky130_fd_sc_hd__nor2_1
XFILLER_0_63_329 VGND VGND VPWR VPWR sky130_fd_sc_hd__decap_6
Xaccumulator._2193_ accumulator._0383_ VGND VGND VPWR VPWR accumulator._0147_ sky130_fd_sc_hd__clkbuf_4
XFILLER_0_48_304 VGND VGND VPWR VPWR sky130_fd_sc_hd__decap_4
XFILLER_0_33_82 VGND VGND VPWR VPWR sky130_fd_sc_hd__fill_1
XFILLER_0_16_212 VGND VGND VPWR VPWR sky130_fd_sc_hd__fill_2
Xaccumulator._1977_ accumulator._1071_ accumulator._0902_ accumulator._0535_ VGND
+ VGND VPWR VPWR accumulator._1072_ sky130_fd_sc_hd__o21ai_1
XFILLER_0_3_161 VGND VGND VPWR VPWR sky130_fd_sc_hd__decap_6
XFILLER_0_39_359 VGND VGND VPWR VPWR sky130_fd_sc_hd__decap_6
XFILLER_0_39_337 VGND VGND VPWR VPWR sky130_fd_sc_hd__decap_3
XTAP_TAPCELL_ROW_50_493 VGND VPWR sky130_fd_sc_hd__tapvpwrvgnd_1
XTAP_TAPCELL_ROW_42_438 VGND VPWR sky130_fd_sc_hd__tapvpwrvgnd_1
XFILLER_0_38_27 VGND VGND VPWR VPWR sky130_fd_sc_hd__fill_1
XFILLER_0_22_237 VGND VGND VPWR VPWR sky130_fd_sc_hd__decap_3
XFILLER_0_54_15 VPWR VGND VPWR VGND sky130_ef_sc_hd__decap_12
XTAP_TAPCELL_ROW_7_193 VGND VPWR sky130_fd_sc_hd__tapvpwrvgnd_1
XFILLER_0_57_167 VGND VGND VPWR VPWR sky130_fd_sc_hd__fill_1
XFILLER_0_57_101 VGND VGND VPWR VPWR sky130_fd_sc_hd__decap_8
XFILLER_0_53_373 VPWR VGND VPWR VGND sky130_ef_sc_hd__decap_12
Xaccumulator._1900_ accumulator._0918_ accumulator._0993_ accumulator._0994_ accumulator._0763_
+ VGND VGND VPWR VPWR accumulator._0995_ sky130_fd_sc_hd__a2bb2o_1
Xaccumulator._1831_ accumulator._0583_ accumulator._0767_ VGND VGND VPWR VPWR accumulator._0926_
+ sky130_fd_sc_hd__nor2_1
Xaccumulator._1762_ accumulator._0853_ accumulator._0856_ VGND VGND VPWR VPWR accumulator._0857_
+ sky130_fd_sc_hd__or2_1
Xaccumulator._1693_ accumulator._0787_ accumulator._0760_ accumulator._0718_ accumulator._0605_
+ VGND VGND VPWR VPWR accumulator._0788_ sky130_fd_sc_hd__o22a_1
XFILLER_0_21_281 VGND VGND VPWR VPWR sky130_fd_sc_hd__decap_8
XFILLER_0_0_197 VPWR VGND VPWR VGND sky130_ef_sc_hd__decap_12
Xaccumulator._2245_ accumulator._1050_ accumulator._1068_ accumulator._0057_ VGND
+ VGND VPWR VPWR accumulator._0198_ sky130_fd_sc_hd__mux2_4
Xaccumulator._2314_ accumulator._0253_ accumulator._0256_ VGND VGND VPWR VPWR accumulator._0265_
+ sky130_fd_sc_hd__or2_1
Xaccumulator._2176_ accumulator._0109_ accumulator._0130_ accumulator._0044_ VGND
+ VGND VPWR VPWR accumulator._0131_ sky130_fd_sc_hd__mux2_4
XFILLER_0_44_70 VGND VGND VPWR VPWR sky130_fd_sc_hd__decap_4
XFILLER_0_14_3 VPWR VGND VPWR VGND sky130_ef_sc_hd__decap_12
XTAP_TAPCELL_ROW_64_596 VGND VPWR sky130_fd_sc_hd__tapvpwrvgnd_1
XFILLER_0_48_178 VGND VGND VPWR VPWR sky130_fd_sc_hd__fill_2
XFILLER_0_8_220 VPWR VGND VPWR VGND sky130_ef_sc_hd__decap_12
XTAP_TAPCELL_ROW_4_174 VGND VPWR sky130_fd_sc_hd__tapvpwrvgnd_1
XTAP_TAPCELL_ROW_55_530 VGND VPWR sky130_fd_sc_hd__tapvpwrvgnd_1
XFILLER_0_39_167 VGND VGND VPWR VPWR sky130_fd_sc_hd__fill_1
XFILLER_0_24_29 VGND VGND VPWR VPWR sky130_fd_sc_hd__decap_8
XFILLER_0_50_365 VPWR VGND VPWR VGND sky130_ef_sc_hd__decap_12
XFILLER_0_65_69 VGND VGND VPWR VPWR sky130_fd_sc_hd__decap_8
Xaccumulator._2030_ accumulator._1026_ accumulator._1124_ accumulator._1069_ VGND
+ VGND VPWR VPWR accumulator._1125_ sky130_fd_sc_hd__o21ba_1
XFILLER_0_45_137 VPWR VGND VPWR VGND sky130_ef_sc_hd__decap_12
XFILLER_0_30_50 VPWR VGND VPWR VGND sky130_ef_sc_hd__decap_12
XFILLER_0_26_362 VGND VGND VPWR VPWR sky130_fd_sc_hd__fill_2
XFILLER_0_14_62 VPWR VGND VPWR VGND sky130_ef_sc_hd__decap_12
XFILLER_0_53_192 VGND VGND VPWR VPWR sky130_fd_sc_hd__fill_2
Xaccumulator._1814_ accumulator._0898_ accumulator._0893_ accumulator._0908_ VGND
+ VGND VPWR VPWR accumulator._0909_ sky130_fd_sc_hd__a21o_1
XFILLER_0_41_343 VGND VGND VPWR VPWR sky130_fd_sc_hd__fill_1
Xaccumulator._1745_ accumulator._0681_ accumulator._0682_ VGND VGND VPWR VPWR accumulator._0840_
+ sky130_fd_sc_hd__or2_1
XFILLER_0_26_395 VGND VGND VPWR VPWR sky130_fd_sc_hd__fill_2
XFILLER_0_5_289 VGND VGND VPWR VPWR sky130_fd_sc_hd__decap_3
XPHY_EDGE_ROW_18_Left_86 VGND VGND VPWR VPWR sky130_fd_sc_hd__decap_3
Xaccumulator._1676_ accumulator._0769_ accumulator._0770_ VGND VGND VPWR VPWR accumulator._0771_
+ sky130_fd_sc_hd__and2_1
Xaccumulator._2159_ accumulator._1166_ accumulator._1095_ accumulator._1092_ VGND
+ VGND VPWR VPWR accumulator._0114_ sky130_fd_sc_hd__or3_4
XTAP_TAPCELL_ROW_52_511 VGND VPWR sky130_fd_sc_hd__tapvpwrvgnd_1
Xaccumulator._2228_ accumulator._0179_ accumulator._0181_ accumulator._0074_ VGND
+ VGND VPWR VPWR accumulator._0017_ sky130_fd_sc_hd__a21oi_1
XTAP_TAPCELL_ROW_1_155 VGND VPWR sky130_fd_sc_hd__tapvpwrvgnd_1
XFILLER_0_32_321 VGND VGND VPWR VPWR sky130_fd_sc_hd__fill_2
XFILLER_0_3_3 VPWR VGND VPWR VGND sky130_ef_sc_hd__decap_12
XTAP_TAPCELL_ROW_9_211 VGND VPWR sky130_fd_sc_hd__tapvpwrvgnd_1
XFILLER_0_67_251 VGND VGND VPWR VPWR sky130_fd_sc_hd__fill_1
XFILLER_0_51_27 VPWR VGND VPWR VGND sky130_ef_sc_hd__decap_12
XFILLER_0_50_184 VPWR VGND VPWR VGND sky130_ef_sc_hd__decap_12
XFILLER_0_23_321 VPWR VGND VPWR VGND sky130_ef_sc_hd__decap_12
XFILLER_0_2_215 VGND VGND VPWR VPWR sky130_fd_sc_hd__fill_1
Xaccumulator._1530_ accumulator._0542_ accumulator._0505_ accumulator._0473_ VGND
+ VGND VPWR VPWR accumulator._0625_ sky130_fd_sc_hd__a21o_1
Xaccumulator._1461_ accumulator._0490_ accumulator._0493_ accumulator._0498_ VGND
+ VGND VPWR VPWR accumulator._0556_ sky130_fd_sc_hd__a21o_1
Xaccumulator._1392_ accumulator._0399_ accumulator._0414_ net59 VGND VGND VPWR VPWR
+ accumulator._0487_ sky130_fd_sc_hd__a21oi_4
XFILLER_0_58_262 VGND VGND VPWR VPWR sky130_fd_sc_hd__decap_8
Xaccumulator._2013_ accumulator._1103_ accumulator._1107_ VGND VGND VPWR VPWR accumulator._1108_
+ sky130_fd_sc_hd__nor2_1
XFILLER_0_26_181 VGND VGND VPWR VPWR sky130_fd_sc_hd__decap_4
Xaccumulator._1728_ accumulator._0643_ accumulator._0638_ accumulator._0579_ VGND
+ VGND VPWR VPWR accumulator._0823_ sky130_fd_sc_hd__a21oi_2
Xaccumulator._1659_ accumulator._0753_ accumulator._0631_ VGND VGND VPWR VPWR accumulator._0754_
+ sky130_fd_sc_hd__nor2_1
XTAP_TAPCELL_ROW_29_349 VGND VPWR sky130_fd_sc_hd__tapvpwrvgnd_1
XFILLER_0_64_265 VPWR VGND VPWR VGND sky130_ef_sc_hd__decap_12
XFILLER_0_64_221 VGND VGND VPWR VPWR sky130_fd_sc_hd__fill_1
XFILLER_0_24_118 VPWR VGND VPWR VGND sky130_ef_sc_hd__decap_12
XTAP_TAPCELL_ROW_12_227 VGND VPWR sky130_fd_sc_hd__tapvpwrvgnd_1
XFILLER_0_32_173 VGND VGND VPWR VPWR sky130_fd_sc_hd__fill_2
XscaleAdd._380_ scaleAdd._083_ scaleAdd._068_ scaleAdd._084_ VGND VGND VPWR VPWR scaleAdd._085_
+ sky130_fd_sc_hd__and3_1
X_20_ accumulator.io_accOut\[20\] VGND VGND VPWR VPWR net35 sky130_fd_sc_hd__buf_1
XFILLER_0_62_15 VPWR VGND VPWR VGND sky130_ef_sc_hd__decap_12
XFILLER_0_55_287 VGND VGND VPWR VPWR sky130_fd_sc_hd__fill_2
XFILLER_0_23_140 VGND VGND VPWR VPWR sky130_fd_sc_hd__decap_4
XFILLER_0_15_118 VGND VGND VPWR VPWR sky130_fd_sc_hd__decap_3
XFILLER_0_23_195 VGND VGND VPWR VPWR sky130_fd_sc_hd__fill_1
XFILLER_0_23_173 VGND VGND VPWR VPWR sky130_fd_sc_hd__fill_1
XFILLER_0_11_335 VGND VGND VPWR VPWR sky130_fd_sc_hd__fill_1
XFILLER_0_11_368 VGND VGND VPWR VPWR sky130_fd_sc_hd__fill_2
Xaccumulator._1375_ accumulator._0437_ accumulator._0469_ accumulator._0431_ VGND
+ VGND VPWR VPWR accumulator._0470_ sky130_fd_sc_hd__mux2_1
Xinput1 io_inA[0] VGND VGND VPWR VPWR net1 sky130_fd_sc_hd__buf_1
Xaccumulator._1444_ accumulator._0514_ VGND VGND VPWR VPWR accumulator._0539_ sky130_fd_sc_hd__buf_2
Xaccumulator._1513_ accumulator._0554_ VGND VGND VPWR VPWR accumulator._0608_ sky130_fd_sc_hd__buf_2
XFILLER_0_46_243 VGND VGND VPWR VPWR sky130_fd_sc_hd__decap_8
XTAP_TAPCELL_ROW_34_385 VGND VPWR sky130_fd_sc_hd__tapvpwrvgnd_1
XFILLER_0_6_395 VGND VGND VPWR VPWR sky130_fd_sc_hd__decap_6
XFILLER_0_14_195 VGND VGND VPWR VPWR sky130_fd_sc_hd__fill_1
XFILLER_0_32_29 VPWR VGND VPWR VGND sky130_ef_sc_hd__decap_12
XFILLER_0_57_15 VPWR VGND VPWR VGND sky130_ef_sc_hd__decap_12
XscaleAdd._432_ scaleAdd._120_ scaleAdd._118_ scaleAdd._133_ VGND VGND VPWR VPWR scaleAdd._134_
+ sky130_fd_sc_hd__a21o_1
XscaleAdd._363_ scaleAdd._059_ scaleAdd._061_ VGND VGND VPWR VPWR scaleAdd._068_ sky130_fd_sc_hd__or2b_1
X_03_ accumulator.io_accOut\[3\] VGND VGND VPWR VPWR net48 sky130_fd_sc_hd__buf_1
XscaleAdd._294_ scaleAdd._209_ scaleAdd._000_ scaleAdd._001_ VGND VGND VPWR VPWR scaleAdd._002_
+ sky130_fd_sc_hd__and3_1
Xaccumulator._1993_ accumulator._0921_ accumulator._1087_ VGND VGND VPWR VPWR accumulator._1088_
+ sky130_fd_sc_hd__xnor2_1
XFILLER_0_43_279 VGND VGND VPWR VPWR sky130_fd_sc_hd__fill_1
XTAP_TAPCELL_ROW_31_366 VGND VPWR sky130_fd_sc_hd__tapvpwrvgnd_1
XFILLER_0_11_132 VGND VGND VPWR VPWR sky130_fd_sc_hd__decap_8
XFILLER_0_44_3 VGND VGND VPWR VPWR sky130_fd_sc_hd__fill_2
XTAP_TAPCELL_ROW_39_422 VGND VPWR sky130_fd_sc_hd__tapvpwrvgnd_1
Xaccumulator._1358_ accumulator._0451_ accumulator._0452_ accumulator._0203_ VGND
+ VGND VPWR VPWR accumulator._0453_ sky130_fd_sc_hd__mux2_1
Xaccumulator._1427_ accumulator._0335_ accumulator._0506_ accumulator._0520_ accumulator._0521_
+ VGND VGND VPWR VPWR accumulator._0522_ sky130_fd_sc_hd__a22o_1
XFILLER_0_2_83 VGND VGND VPWR VPWR sky130_fd_sc_hd__fill_1
Xaccumulator._1289_ accumulator._0385_ net79 VGND VGND VPWR VPWR accumulator._0386_
+ sky130_fd_sc_hd__xnor2_4
XTAP_TAPCELL_ROW_22_300 VGND VPWR sky130_fd_sc_hd__tapvpwrvgnd_1
XFILLER_0_19_232 VGND VGND VPWR VPWR sky130_fd_sc_hd__fill_1
XPHY_EDGE_ROW_6_Left_74 VGND VGND VPWR VPWR sky130_fd_sc_hd__decap_3
XFILLER_0_57_349 VPWR VGND VPWR VGND sky130_ef_sc_hd__decap_12
XFILLER_0_57_305 VPWR VGND VPWR VGND sky130_ef_sc_hd__decap_12
XTAP_TAPCELL_ROW_45_458 VGND VPWR sky130_fd_sc_hd__tapvpwrvgnd_1
XFILLER_0_65_393 VGND VGND VPWR VPWR sky130_fd_sc_hd__decap_8
XFILLER_0_4_118 VPWR VGND VPWR VGND sky130_ef_sc_hd__decap_12
XFILLER_0_7_39 VPWR VGND VPWR VGND sky130_ef_sc_hd__decap_12
XscaleAdd._415_ scaleAdd._115_ scaleAdd._117_ VGND VGND VPWR VPWR scaleAdd._118_ sky130_fd_sc_hd__xnor2_2
XscaleAdd._346_ scaleAdd._231_ scaleAdd._230_ scaleAdd._013_ VGND VGND VPWR VPWR scaleAdd._052_
+ sky130_fd_sc_hd__a21o_1
XscaleAdd._277_ scaleAdd._216_ scaleAdd._218_ VGND VGND VPWR VPWR scaleAdd._219_ sky130_fd_sc_hd__and2b_1
Xaccumulator._2261_ accumulator._0080_ accumulator._0213_ VGND VGND VPWR VPWR accumulator._0214_
+ sky130_fd_sc_hd__nand2_1
Xaccumulator._2330_ accumulator._0269_ accumulator._0280_ VGND VGND VPWR VPWR accumulator._0282_
+ sky130_fd_sc_hd__xnor2_1
Xaccumulator._2192_ accumulator._0145_ accumulator._0146_ accumulator._0118_ VGND
+ VGND VPWR VPWR accumulator._0013_ sky130_fd_sc_hd__o21a_1
Xaccumulator._1212_ accumulator.io_inMant\[11\] accumulator._0308_ accumulator.io_inMant\[12\]
+ VGND VGND VPWR VPWR accumulator._0309_ sky130_fd_sc_hd__o21ba_1
XFILLER_0_17_51 VGND VGND VPWR VPWR sky130_fd_sc_hd__decap_4
XFILLER_0_16_246 VGND VGND VPWR VPWR sky130_fd_sc_hd__decap_6
Xaccumulator._1976_ accumulator._0893_ accumulator._0898_ VGND VGND VPWR VPWR accumulator._1071_
+ sky130_fd_sc_hd__and2_1
XFILLER_0_58_91 VGND VGND VPWR VPWR sky130_fd_sc_hd__fill_1
XTAP_TAPCELL_ROW_42_439 VGND VPWR sky130_fd_sc_hd__tapvpwrvgnd_1
XFILLER_0_39_305 VGND VGND VPWR VPWR sky130_fd_sc_hd__fill_1
XFILLER_0_62_363 VGND VGND VPWR VPWR sky130_fd_sc_hd__fill_1
XTAP_TAPCELL_ROW_50_494 VGND VPWR sky130_fd_sc_hd__tapvpwrvgnd_1
XFILLER_0_47_393 VGND VGND VPWR VPWR sky130_fd_sc_hd__decap_4
XTAP_TAPCELL_ROW_58_550 VGND VPWR sky130_fd_sc_hd__tapvpwrvgnd_1
XFILLER_0_54_27 VGND VGND VPWR VPWR sky130_fd_sc_hd__fill_1
XTAP_TAPCELL_ROW_7_194 VGND VPWR sky130_fd_sc_hd__tapvpwrvgnd_1
XFILLER_0_53_385 VGND VGND VPWR VPWR sky130_fd_sc_hd__decap_6
Xaccumulator._1830_ accumulator._0923_ accumulator._0924_ VGND VGND VPWR VPWR accumulator._0925_
+ sky130_fd_sc_hd__nor2_1
Xaccumulator._1761_ accumulator._0854_ accumulator._0388_ accumulator._0855_ VGND
+ VGND VPWR VPWR accumulator._0856_ sky130_fd_sc_hd__o21a_1
XFILLER_0_0_154 VPWR VGND VPWR VGND sky130_ef_sc_hd__decap_12
XPHY_EDGE_ROW_9_Right_9 VGND VGND VPWR VPWR sky130_fd_sc_hd__decap_3
Xaccumulator._2313_ accumulator._0034_ accumulator._0263_ accumulator._0264_ accumulator._0118_
+ VGND VGND VPWR VPWR accumulator._0028_ sky130_fd_sc_hd__o211a_1
Xaccumulator._1692_ accumulator._0586_ VGND VGND VPWR VPWR accumulator._0787_ sky130_fd_sc_hd__buf_2
XscaleAdd._329_ scaleAdd._032_ scaleAdd._033_ scaleAdd._034_ VGND VGND VPWR VPWR scaleAdd._036_
+ sky130_fd_sc_hd__o21ai_1
Xaccumulator._2244_ accumulator._1025_ accumulator._1052_ accumulator._0057_ VGND
+ VGND VPWR VPWR accumulator._0197_ sky130_fd_sc_hd__mux2_4
XTAP_TAPCELL_ROW_64_597 VGND VPWR sky130_fd_sc_hd__tapvpwrvgnd_1
Xaccumulator._2175_ accumulator._1028_ accumulator._1030_ accumulator._0047_ VGND
+ VGND VPWR VPWR accumulator._0130_ sky130_fd_sc_hd__mux2_2
XFILLER_0_44_363 VGND VGND VPWR VPWR sky130_fd_sc_hd__fill_1
XFILLER_0_29_371 VGND VGND VPWR VPWR sky130_fd_sc_hd__decap_4
XFILLER_0_29_360 VGND VGND VPWR VPWR sky130_fd_sc_hd__decap_4
XFILLER_0_8_232 VGND VGND VPWR VPWR sky130_fd_sc_hd__fill_1
Xaccumulator._1959_ accumulator._1040_ accumulator._0882_ accumulator._0895_ VGND
+ VGND VPWR VPWR accumulator._1054_ sky130_fd_sc_hd__o21a_1
XFILLER_0_12_260 VGND VGND VPWR VPWR sky130_fd_sc_hd__decap_8
XFILLER_0_12_282 VPWR VGND VPWR VGND sky130_ef_sc_hd__decap_12
XTAP_TAPCELL_ROW_55_531 VGND VPWR sky130_fd_sc_hd__tapvpwrvgnd_1
XTAP_TAPCELL_ROW_4_175 VGND VPWR sky130_fd_sc_hd__tapvpwrvgnd_1
XFILLER_0_54_127 VGND VGND VPWR VPWR sky130_fd_sc_hd__decap_3
XFILLER_0_54_116 VGND VGND VPWR VPWR sky130_fd_sc_hd__fill_2
XFILLER_0_39_102 VGND VGND VPWR VPWR sky130_fd_sc_hd__decap_8
XFILLER_0_40_29 VPWR VGND VPWR VGND sky130_ef_sc_hd__decap_12
XFILLER_0_50_377 VPWR VGND VPWR VGND sky130_ef_sc_hd__decap_12
XFILLER_0_65_15 VPWR VGND VPWR VGND sky130_ef_sc_hd__decap_12
XFILLER_0_4_29 VPWR VGND VPWR VGND sky130_ef_sc_hd__decap_12
XFILLER_0_45_149 VPWR VGND VPWR VGND sky130_ef_sc_hd__decap_12
XFILLER_0_41_333 VGND VGND VPWR VPWR sky130_fd_sc_hd__decap_3
XFILLER_0_30_73 VGND VGND VPWR VPWR sky130_fd_sc_hd__fill_1
XFILLER_0_30_62 VGND VGND VPWR VPWR sky130_fd_sc_hd__decap_8
XFILLER_0_26_341 VGND VGND VPWR VPWR sky130_fd_sc_hd__decap_8
XFILLER_0_14_74 VGND VGND VPWR VPWR sky130_fd_sc_hd__decap_6
Xaccumulator._1813_ accumulator._0902_ accumulator._0907_ VGND VGND VPWR VPWR accumulator._0908_
+ sky130_fd_sc_hd__or2b_1
Xaccumulator._1744_ accumulator._0833_ accumulator._0835_ accumulator._0696_ accumulator._0837_
+ accumulator._0838_ VGND VGND VPWR VPWR accumulator._0839_ sky130_fd_sc_hd__a2111o_1
Xaccumulator._1675_ accumulator.io_accOut\[12\] accumulator._0545_ accumulator._0387_
+ VGND VGND VPWR VPWR accumulator._0770_ sky130_fd_sc_hd__mux2_1
XTAP_TAPCELL_ROW_1_156 VGND VPWR sky130_fd_sc_hd__tapvpwrvgnd_1
Xaccumulator._2089_ accumulator._0041_ VGND VGND VPWR VPWR accumulator._0044_ sky130_fd_sc_hd__clkbuf_4
XTAP_TAPCELL_ROW_52_512 VGND VPWR sky130_fd_sc_hd__tapvpwrvgnd_1
Xaccumulator._2158_ accumulator._0062_ accumulator._0112_ VGND VGND VPWR VPWR accumulator._0113_
+ sky130_fd_sc_hd__nor2_1
Xaccumulator._2227_ accumulator._0859_ accumulator._0383_ accumulator._0112_ accumulator._0114_
+ accumulator._0180_ VGND VGND VPWR VPWR accumulator._0181_ sky130_fd_sc_hd__o221a_1
XFILLER_0_36_138 VGND VGND VPWR VPWR sky130_fd_sc_hd__fill_2
XFILLER_0_36_116 VGND VGND VPWR VPWR sky130_fd_sc_hd__fill_1
XFILLER_0_32_399 VGND VGND VPWR VPWR sky130_fd_sc_hd__fill_2
XTAP_TAPCELL_ROW_9_212 VGND VPWR sky130_fd_sc_hd__tapvpwrvgnd_1
XFILLER_0_35_18 VPWR VGND VPWR VGND sky130_ef_sc_hd__decap_12
XFILLER_0_67_296 VPWR VGND VPWR VGND sky130_ef_sc_hd__decap_12
XFILLER_0_51_39 VGND VGND VPWR VPWR sky130_fd_sc_hd__fill_1
XFILLER_0_23_333 VGND VGND VPWR VPWR sky130_fd_sc_hd__decap_3
XFILLER_0_50_152 VGND VGND VPWR VPWR sky130_fd_sc_hd__decap_8
XFILLER_0_50_141 VGND VGND VPWR VPWR sky130_fd_sc_hd__decap_8
Xaccumulator._1460_ accumulator._0490_ accumulator._0456_ accumulator._0442_ VGND
+ VGND VPWR VPWR accumulator._0555_ sky130_fd_sc_hd__a21o_1
Xaccumulator._1391_ accumulator._0347_ net84 VGND VGND VPWR VPWR accumulator._0486_
+ sky130_fd_sc_hd__xor2_4
XFILLER_0_58_230 VGND VGND VPWR VPWR sky130_fd_sc_hd__decap_6
Xaccumulator._2012_ accumulator._1104_ accumulator._1106_ VGND VGND VPWR VPWR accumulator._1107_
+ sky130_fd_sc_hd__xnor2_2
XFILLER_0_41_130 VGND VGND VPWR VPWR sky130_fd_sc_hd__decap_8
XFILLER_0_14_399 VGND VGND VPWR VPWR sky130_fd_sc_hd__fill_2
Xaccumulator._1658_ accumulator._0630_ VGND VGND VPWR VPWR accumulator._0753_ sky130_fd_sc_hd__inv_2
Xaccumulator._1727_ accumulator._0774_ accumulator._0775_ accumulator._0636_ accumulator._0821_
+ VGND VGND VPWR VPWR accumulator._0822_ sky130_fd_sc_hd__o31ai_2
Xaccumulator._1589_ accumulator._0514_ accumulator._0624_ accumulator._0627_ VGND
+ VGND VPWR VPWR accumulator._0684_ sky130_fd_sc_hd__and3_1
XFILLER_0_64_277 VPWR VGND VPWR VGND sky130_ef_sc_hd__decap_12
XFILLER_0_9_393 VGND VGND VPWR VPWR sky130_fd_sc_hd__decap_8
XTAP_TAPCELL_ROW_12_228 VGND VPWR sky130_fd_sc_hd__tapvpwrvgnd_1
XFILLER_0_32_141 VPWR VGND VPWR VGND sky130_ef_sc_hd__decap_12
XTAP_TAPCELL_ROW_20_283 VGND VPWR sky130_fd_sc_hd__tapvpwrvgnd_1
XFILLER_0_20_369 VGND VGND VPWR VPWR sky130_fd_sc_hd__decap_6
XFILLER_0_62_27 VGND VGND VPWR VPWR sky130_fd_sc_hd__fill_1
XFILLER_0_55_233 VGND VGND VPWR VPWR sky130_fd_sc_hd__fill_1
XFILLER_0_11_75 VGND VGND VPWR VPWR sky130_fd_sc_hd__decap_8
Xaccumulator._1512_ accumulator.io_accOut\[9\] accumulator._0591_ accumulator._0387_
+ VGND VGND VPWR VPWR accumulator._0607_ sky130_fd_sc_hd__mux2_2
XFILLER_0_36_83 VGND VGND VPWR VPWR sky130_fd_sc_hd__fill_1
Xaccumulator._1374_ accumulator.io_inMant\[12\] accumulator.io_inMant\[13\] accumulator._0428_
+ VGND VGND VPWR VPWR accumulator._0469_ sky130_fd_sc_hd__mux2_1
Xaccumulator._1443_ accumulator._0537_ VGND VGND VPWR VPWR accumulator._0538_ sky130_fd_sc_hd__buf_2
Xinput2 io_inA[1] VGND VGND VPWR VPWR net2 sky130_fd_sc_hd__buf_1
XTAP_TAPCELL_ROW_34_386 VGND VPWR sky130_fd_sc_hd__tapvpwrvgnd_1
XFILLER_0_6_363 VGND VGND VPWR VPWR sky130_fd_sc_hd__fill_1
XFILLER_0_14_141 VPWR VGND VPWR VGND sky130_ef_sc_hd__decap_12
XFILLER_0_37_211 VPWR VGND VPWR VGND sky130_ef_sc_hd__decap_12
XFILLER_0_32_19 VGND VGND VPWR VPWR sky130_fd_sc_hd__decap_8
XTAP_TAPCELL_ROW_25_320 VGND VPWR sky130_fd_sc_hd__tapvpwrvgnd_1
XFILLER_0_37_299 VGND VGND VPWR VPWR sky130_fd_sc_hd__decap_8
XFILLER_0_37_277 VGND VGND VPWR VPWR sky130_fd_sc_hd__decap_3
XFILLER_0_37_266 VGND VGND VPWR VPWR sky130_fd_sc_hd__decap_3
XFILLER_0_57_27 VGND VGND VPWR VPWR sky130_fd_sc_hd__decap_8
XscaleAdd._431_ scaleAdd._117_ scaleAdd._115_ VGND VGND VPWR VPWR scaleAdd._133_ sky130_fd_sc_hd__and2b_1
XscaleAdd._362_ scaleAdd._066_ net85 VGND VGND VPWR VPWR accumulator.io_inMant\[8\]
+ sky130_fd_sc_hd__xor2_2
XscaleAdd._293_ operator.io_outMant\[0\] scaleAdd._233_ scaleAdd._220_ VGND VGND VPWR
+ VPWR scaleAdd._001_ sky130_fd_sc_hd__a21o_1
X_02_ accumulator.io_accOut\[2\] VGND VGND VPWR VPWR net45 sky130_fd_sc_hd__clkbuf_1
XFILLER_0_43_225 VGND VGND VPWR VPWR sky130_fd_sc_hd__decap_4
XFILLER_0_43_203 VGND VGND VPWR VPWR sky130_fd_sc_hd__fill_1
XFILLER_0_28_200 VGND VGND VPWR VPWR sky130_fd_sc_hd__decap_6
XFILLER_0_22_85 VGND VGND VPWR VPWR sky130_fd_sc_hd__fill_2
XFILLER_0_7_127 VPWR VGND VPWR VGND sky130_ef_sc_hd__decap_12
XFILLER_0_7_149 VGND VGND VPWR VPWR sky130_fd_sc_hd__decap_3
Xaccumulator._1992_ accumulator._0904_ accumulator._1070_ accumulator._0906_ VGND
+ VGND VPWR VPWR accumulator._1087_ sky130_fd_sc_hd__o21ai_1
XFILLER_0_43_269 VGND VGND VPWR VPWR sky130_fd_sc_hd__decap_6
XFILLER_0_43_236 VGND VGND VPWR VPWR sky130_fd_sc_hd__decap_6
XFILLER_0_3_333 VGND VGND VPWR VPWR sky130_fd_sc_hd__decap_3
XPHY_EDGE_ROW_22_Left_90 VGND VGND VPWR VPWR sky130_fd_sc_hd__decap_3
XFILLER_0_59_391 VGND VGND VPWR VPWR sky130_fd_sc_hd__fill_1
Xaccumulator._1288_ accumulator.io_accOut\[30\] VGND VGND VPWR VPWR accumulator._0385_
+ sky130_fd_sc_hd__inv_2
Xaccumulator._1426_ net102 accumulator._0310_ accumulator._0445_ accumulator._0479_
+ accumulator._0463_ VGND VGND VPWR VPWR accumulator._0521_ sky130_fd_sc_hd__a221o_1
Xaccumulator._1357_ accumulator.io_inMant\[9\] accumulator.io_inMant\[10\] accumulator._0428_
+ VGND VGND VPWR VPWR accumulator._0452_ sky130_fd_sc_hd__mux2_1
XFILLER_0_19_222 VGND VGND VPWR VPWR sky130_fd_sc_hd__fill_2
XTAP_TAPCELL_ROW_22_301 VGND VPWR sky130_fd_sc_hd__tapvpwrvgnd_1
XFILLER_0_6_193 VGND VGND VPWR VPWR sky130_fd_sc_hd__decap_3
XFILLER_0_65_361 VPWR VGND VPWR VGND sky130_ef_sc_hd__decap_12
XFILLER_0_57_317 VGND VGND VPWR VPWR sky130_fd_sc_hd__decap_8
XTAP_TAPCELL_ROW_45_459 VGND VPWR sky130_fd_sc_hd__tapvpwrvgnd_1
XFILLER_0_25_225 VGND VGND VPWR VPWR sky130_fd_sc_hd__decap_6
XscaleAdd._414_ scaleAdd._190_ scaleAdd._074_ scaleAdd._099_ scaleAdd._116_ VGND VGND
+ VPWR VPWR scaleAdd._117_ sky130_fd_sc_hd__a31oi_2
XFILLER_0_0_314 VGND VGND VPWR VPWR sky130_fd_sc_hd__decap_4
XscaleAdd._345_ scaleAdd._050_ scaleAdd._049_ VGND VGND VPWR VPWR scaleAdd._051_ sky130_fd_sc_hd__nor2_4
XscaleAdd._276_ operator.io_outMant\[2\] scaleAdd._195_ VGND VGND VPWR VPWR scaleAdd._218_
+ sky130_fd_sc_hd__nand2_1
Xaccumulator._2260_ accumulator._0211_ accumulator._1083_ net103 VGND VGND VPWR VPWR
+ accumulator._0213_ sky130_fd_sc_hd__mux2_1
Xaccumulator._2191_ accumulator._0083_ accumulator._0114_ accumulator.io_accOut\[11\]
+ accumulator._0392_ VGND VGND VPWR VPWR accumulator._0146_ sky130_fd_sc_hd__a2bb2o_2
Xaccumulator._1211_ accumulator.io_inMant\[9\] accumulator._0307_ accumulator.io_inMant\[10\]
+ VGND VGND VPWR VPWR accumulator._0308_ sky130_fd_sc_hd__o21ba_1
Xaccumulator._1975_ accumulator._0891_ accumulator._0902_ accumulator._1053_ accumulator._0941_
+ VGND VGND VPWR VPWR accumulator._1070_ sky130_fd_sc_hd__a31o_1
XFILLER_0_31_228 VGND VGND VPWR VPWR sky130_fd_sc_hd__decap_6
Xaccumulator._1409_ accumulator._0490_ accumulator._0503_ accumulator._0473_ VGND
+ VGND VPWR VPWR accumulator._0504_ sky130_fd_sc_hd__a21o_1
XTAP_TAPCELL_ROW_50_495 VGND VPWR sky130_fd_sc_hd__tapvpwrvgnd_1
XFILLER_0_38_29 VGND VGND VPWR VPWR sky130_fd_sc_hd__fill_2
XTAP_TAPCELL_ROW_7_195 VGND VPWR sky130_fd_sc_hd__tapvpwrvgnd_1
XTAP_TAPCELL_ROW_58_551 VGND VPWR sky130_fd_sc_hd__tapvpwrvgnd_1
XFILLER_0_57_169 VPWR VGND VPWR VGND sky130_ef_sc_hd__decap_12
XFILLER_0_45_309 VPWR VGND VPWR VGND sky130_ef_sc_hd__decap_12
XFILLER_0_38_394 VGND VGND VPWR VPWR sky130_fd_sc_hd__decap_6
XFILLER_0_13_206 VPWR VGND VPWR VGND sky130_ef_sc_hd__decap_12
Xaccumulator._1760_ accumulator._0388_ accumulator._0496_ VGND VGND VPWR VPWR accumulator._0855_
+ sky130_fd_sc_hd__nand2_1
Xaccumulator._1691_ accumulator._0581_ accumulator._0582_ VGND VGND VPWR VPWR accumulator._0786_
+ sky130_fd_sc_hd__or2b_1
XFILLER_0_0_166 VGND VGND VPWR VPWR sky130_fd_sc_hd__fill_2
Xaccumulator._2312_ accumulator.io_accOut\[26\] accumulator._0383_ VGND VGND VPWR
+ VPWR accumulator._0264_ sky130_fd_sc_hd__or2_1
XscaleAdd._259_ net10 net12 net13 net9 VGND VGND VPWR VPWR scaleAdd._202_ sky130_fd_sc_hd__a22o_1
XscaleAdd._328_ scaleAdd._034_ scaleAdd._033_ scaleAdd._032_ VGND VGND VPWR VPWR scaleAdd._035_
+ sky130_fd_sc_hd__or3_4
XFILLER_0_63_117 VGND VGND VPWR VPWR sky130_fd_sc_hd__decap_3
Xaccumulator._2174_ accumulator._0128_ accumulator._0108_ accumulator._0080_ VGND
+ VGND VPWR VPWR accumulator._0129_ sky130_fd_sc_hd__mux2_1
Xaccumulator._2243_ accumulator._0138_ accumulator._1120_ VGND VGND VPWR VPWR accumulator._0196_
+ sky130_fd_sc_hd__and2b_1
XFILLER_0_48_158 VPWR VGND VPWR VGND sky130_ef_sc_hd__decap_12
XFILLER_0_44_83 VGND VGND VPWR VPWR sky130_fd_sc_hd__fill_1
XFILLER_0_8_244 VGND VGND VPWR VPWR sky130_fd_sc_hd__fill_1
XFILLER_0_56_180 VGND VGND VPWR VPWR sky130_fd_sc_hd__decap_6
XFILLER_0_44_320 VGND VGND VPWR VPWR sky130_fd_sc_hd__decap_4
XFILLER_0_8_83 VGND VGND VPWR VPWR sky130_fd_sc_hd__fill_1
Xaccumulator._1889_ accumulator._0803_ accumulator._0843_ VGND VGND VPWR VPWR accumulator._0984_
+ sky130_fd_sc_hd__and2_1
Xaccumulator._1958_ accumulator._0924_ accumulator._1039_ accumulator._0935_ VGND
+ VGND VPWR VPWR accumulator._1053_ sky130_fd_sc_hd__o21ai_1
XFILLER_0_12_294 VPWR VGND VPWR VGND sky130_ef_sc_hd__decap_12
XTAP_TAPCELL_ROW_55_532 VGND VPWR sky130_fd_sc_hd__tapvpwrvgnd_1
XTAP_TAPCELL_ROW_4_176 VGND VPWR sky130_fd_sc_hd__tapvpwrvgnd_1
XFILLER_0_62_150 VGND VGND VPWR VPWR sky130_fd_sc_hd__decap_8
XFILLER_0_54_139 VGND VGND VPWR VPWR sky130_fd_sc_hd__fill_1
XFILLER_0_35_364 VGND VGND VPWR VPWR sky130_fd_sc_hd__fill_1
XFILLER_0_27_309 VGND VGND VPWR VPWR sky130_fd_sc_hd__decap_6
XFILLER_0_50_389 VGND VGND VPWR VPWR sky130_fd_sc_hd__decap_8
XFILLER_0_65_27 VPWR VGND VPWR VGND sky130_ef_sc_hd__decap_12
Xaccumulator._1812_ accumulator._0904_ accumulator._0906_ VGND VGND VPWR VPWR accumulator._0907_
+ sky130_fd_sc_hd__nand2b_2
XFILLER_0_41_312 VGND VGND VPWR VPWR sky130_fd_sc_hd__decap_4
XFILLER_0_41_301 VGND VGND VPWR VPWR sky130_fd_sc_hd__fill_2
XFILLER_0_30_85 VPWR VGND VPWR VGND sky130_ef_sc_hd__decap_12
XFILLER_0_5_225 VPWR VGND VPWR VGND sky130_ef_sc_hd__decap_12
Xaccumulator._1743_ accumulator._0719_ accumulator._0720_ VGND VGND VPWR VPWR accumulator._0838_
+ sky130_fd_sc_hd__and2_1
Xaccumulator._1674_ accumulator._0580_ accumulator._0768_ accumulator._0537_ accumulator._0685_
+ VGND VGND VPWR VPWR accumulator._0769_ sky130_fd_sc_hd__a22o_1
Xaccumulator._2226_ accumulator._1166_ accumulator._0060_ accumulator._0158_ accumulator._0077_
+ VGND VGND VPWR VPWR accumulator._0180_ sky130_fd_sc_hd__or4b_1
Xaccumulator._2157_ accumulator._0107_ accumulator._0081_ accumulator._0111_ VGND
+ VGND VPWR VPWR accumulator._0112_ sky130_fd_sc_hd__o21a_1
Xaccumulator._2088_ accumulator._1172_ accumulator._1174_ accumulator._0042_ VGND
+ VGND VPWR VPWR accumulator._0043_ sky130_fd_sc_hd__mux2_4
XTAP_TAPCELL_ROW_52_513 VGND VPWR sky130_fd_sc_hd__tapvpwrvgnd_1
XFILLER_0_17_320 VPWR VGND VPWR VGND sky130_ef_sc_hd__decap_12
XFILLER_0_67_253 VPWR VGND VPWR VGND sky130_ef_sc_hd__decap_12
XFILLER_0_67_231 VPWR VGND VPWR VGND sky130_ef_sc_hd__decap_12
XTAP_TAPCELL_ROW_15_248 VGND VPWR sky130_fd_sc_hd__tapvpwrvgnd_1
XFILLER_0_42_109 VGND VGND VPWR VPWR sky130_fd_sc_hd__decap_4
XFILLER_0_35_161 VGND VGND VPWR VPWR sky130_fd_sc_hd__decap_6
XFILLER_0_35_150 VGND VGND VPWR VPWR sky130_fd_sc_hd__decap_4
XFILLER_0_23_312 VGND VGND VPWR VPWR sky130_fd_sc_hd__fill_1
XTAP_TAPCELL_ROW_66_605 VGND VPWR sky130_fd_sc_hd__tapvpwrvgnd_1
Xaccumulator._1390_ accumulator._0462_ accumulator._0474_ accumulator._0484_ VGND
+ VGND VPWR VPWR accumulator._0485_ sky130_fd_sc_hd__and3_1
Xaccumulator._2011_ accumulator._0946_ accumulator._1105_ VGND VGND VPWR VPWR accumulator._1106_
+ sky130_fd_sc_hd__nor2_1
XFILLER_0_25_96 VGND VGND VPWR VPWR sky130_fd_sc_hd__fill_2
XFILLER_0_18_128 VGND VGND VPWR VPWR sky130_fd_sc_hd__fill_1
XFILLER_0_18_139 VGND VGND VPWR VPWR sky130_fd_sc_hd__fill_1
XFILLER_0_67_3 VPWR VGND VPWR VGND sky130_ef_sc_hd__decap_12
XFILLER_0_26_194 VGND VGND VPWR VPWR sky130_fd_sc_hd__fill_2
XFILLER_0_26_161 VGND VGND VPWR VPWR sky130_fd_sc_hd__decap_8
XFILLER_0_14_378 VGND VGND VPWR VPWR sky130_fd_sc_hd__decap_4
Xaccumulator._1588_ accumulator._0681_ accumulator._0682_ VGND VGND VPWR VPWR accumulator._0683_
+ sky130_fd_sc_hd__nand2_1
Xaccumulator._1657_ accumulator._0606_ accumulator._0607_ VGND VGND VPWR VPWR accumulator._0752_
+ sky130_fd_sc_hd__xor2_4
XFILLER_0_5_51 VGND VGND VPWR VPWR sky130_fd_sc_hd__decap_4
Xaccumulator._1726_ accumulator._0579_ accumulator._0675_ accumulator._0820_ accumulator._0410_
+ VGND VGND VPWR VPWR accumulator._0821_ sky130_fd_sc_hd__o211ai_1
Xaccumulator._2209_ accumulator._0141_ accumulator._0162_ accumulator._0044_ VGND
+ VGND VPWR VPWR accumulator._0163_ sky130_fd_sc_hd__mux2_4
XFILLER_0_64_289 VPWR VGND VPWR VGND sky130_ef_sc_hd__decap_12
XTAP_TAPCELL_ROW_12_229 VGND VPWR sky130_fd_sc_hd__tapvpwrvgnd_1
XFILLER_0_32_153 VPWR VGND VPWR VGND sky130_ef_sc_hd__decap_12
XTAP_TAPCELL_ROW_20_284 VGND VPWR sky130_fd_sc_hd__tapvpwrvgnd_1
XFILLER_0_46_29 VGND VGND VPWR VPWR sky130_fd_sc_hd__fill_2
XTAP_TAPCELL_ROW_28_340 VGND VPWR sky130_fd_sc_hd__tapvpwrvgnd_1
XFILLER_0_55_223 VGND VGND VPWR VPWR sky130_fd_sc_hd__fill_1
XFILLER_0_55_278 VGND VGND VPWR VPWR sky130_fd_sc_hd__fill_2
XFILLER_0_11_348 VGND VGND VPWR VPWR sky130_fd_sc_hd__decap_8
Xaccumulator._1511_ accumulator._0586_ accumulator._0599_ accumulator._0604_ accumulator._0605_
+ VGND VGND VPWR VPWR accumulator._0606_ sky130_fd_sc_hd__o22ai_4
XPHY_EDGE_ROW_18_Right_18 VGND VGND VPWR VPWR sky130_fd_sc_hd__decap_3
Xaccumulator._1442_ accumulator._0409_ accumulator._0536_ VGND VGND VPWR VPWR accumulator._0537_
+ sky130_fd_sc_hd__nor2_1
XPHY_EDGE_ROW_27_Right_27 VGND VGND VPWR VPWR sky130_fd_sc_hd__decap_3
Xaccumulator._1373_ accumulator._0105_ accumulator._0467_ VGND VGND VPWR VPWR accumulator._0468_
+ sky130_fd_sc_hd__nor2_1
Xinput3 io_inA[2] VGND VGND VPWR VPWR net3 sky130_fd_sc_hd__buf_1
XTAP_TAPCELL_ROW_34_387 VGND VPWR sky130_fd_sc_hd__tapvpwrvgnd_1
XPHY_EDGE_ROW_36_Right_36 VGND VGND VPWR VPWR sky130_fd_sc_hd__decap_3
XFILLER_0_14_153 VPWR VGND VPWR VGND sky130_ef_sc_hd__decap_12
Xaccumulator._1709_ accumulator.io_accOut\[4\] VGND VGND VPWR VPWR accumulator._0804_
+ sky130_fd_sc_hd__inv_2
XPHY_EDGE_ROW_45_Right_45 VGND VGND VPWR VPWR sky130_fd_sc_hd__decap_3
XFILLER_0_37_223 VGND VGND VPWR VPWR sky130_fd_sc_hd__fill_1
XTAP_TAPCELL_ROW_25_321 VGND VPWR sky130_fd_sc_hd__tapvpwrvgnd_1
Xoperator._29_ operator._10_ VGND VGND VPWR VPWR operator.io_outMant\[3\] sky130_fd_sc_hd__buf_1
XPHY_EDGE_ROW_54_Right_54 VGND VGND VPWR VPWR sky130_fd_sc_hd__decap_3
XscaleAdd._430_ scaleAdd._129_ scaleAdd._131_ VGND VGND VPWR VPWR scaleAdd._132_ sky130_fd_sc_hd__xnor2_2
X_01_ accumulator.io_accOut\[1\] VGND VGND VPWR VPWR net34 sky130_fd_sc_hd__buf_1
XscaleAdd._292_ operator.io_outMant\[0\] scaleAdd._220_ scaleAdd._233_ VGND VGND VPWR
+ VPWR scaleAdd._000_ sky130_fd_sc_hd__nand3_1
XFILLER_0_20_167 VGND VGND VPWR VPWR sky130_fd_sc_hd__fill_2
XscaleAdd._361_ scaleAdd._039_ scaleAdd._008_ scaleAdd._038_ VGND VGND VPWR VPWR scaleAdd._067_
+ sky130_fd_sc_hd__a21o_1
XPHY_EDGE_ROW_63_Right_63 VGND VGND VPWR VPWR sky130_fd_sc_hd__decap_3
XTAP_TAPCELL_ROW_48_479 VGND VPWR sky130_fd_sc_hd__tapvpwrvgnd_1
Xaccumulator._1991_ accumulator._1022_ accumulator._1085_ VGND VGND VPWR VPWR accumulator._1086_
+ sky130_fd_sc_hd__nand2_1
XFILLER_0_7_139 VGND VGND VPWR VPWR sky130_fd_sc_hd__decap_4
XFILLER_0_3_367 VGND VGND VPWR VPWR sky130_fd_sc_hd__decap_3
XFILLER_0_11_167 VGND VGND VPWR VPWR sky130_fd_sc_hd__fill_1
Xaccumulator._1425_ accumulator._0427_ accumulator._0453_ VGND VGND VPWR VPWR accumulator._0520_
+ sky130_fd_sc_hd__or2_1
XFILLER_0_2_41 VPWR VGND VPWR VGND sky130_ef_sc_hd__decap_12
XFILLER_0_66_307 VGND VGND VPWR VPWR sky130_fd_sc_hd__fill_1
Xaccumulator._1287_ accumulator._0383_ VGND VGND VPWR VPWR accumulator._0384_ sky130_fd_sc_hd__buf_2
Xaccumulator._1356_ accumulator.io_inMant\[7\] accumulator.io_inMant\[8\] accumulator._0428_
+ VGND VGND VPWR VPWR accumulator._0451_ sky130_fd_sc_hd__mux2_1
XTAP_TAPCELL_ROW_22_302 VGND VPWR sky130_fd_sc_hd__tapvpwrvgnd_1
XFILLER_0_2_85 VPWR VGND VPWR VGND sky130_ef_sc_hd__decap_12
XFILLER_0_19_212 VGND VGND VPWR VPWR sky130_fd_sc_hd__fill_1
XFILLER_0_65_373 VPWR VGND VPWR VGND sky130_ef_sc_hd__decap_12
XFILLER_0_4_109 VGND VGND VPWR VPWR sky130_fd_sc_hd__decap_4
XFILLER_0_33_281 VGND VGND VPWR VPWR sky130_fd_sc_hd__decap_4
XscaleAdd._413_ scaleAdd._098_ scaleAdd._097_ VGND VGND VPWR VPWR scaleAdd._116_ sky130_fd_sc_hd__and2b_1
XscaleAdd._344_ scaleAdd._047_ scaleAdd._048_ VGND VGND VPWR VPWR scaleAdd._050_ sky130_fd_sc_hd__nor2_1
XscaleAdd._275_ operator.io_outMant\[2\] scaleAdd._216_ scaleAdd._195_ VGND VGND VPWR
+ VPWR scaleAdd._217_ sky130_fd_sc_hd__and3_1
Xaccumulator._2190_ accumulator._1122_ accumulator._0143_ VGND VGND VPWR VPWR accumulator._0145_
+ sky130_fd_sc_hd__and2_1
XFILLER_0_33_74 VGND VGND VPWR VPWR sky130_fd_sc_hd__decap_8
Xaccumulator._1210_ accumulator.io_inMant\[7\] accumulator._0306_ accumulator.io_inMant\[8\]
+ VGND VGND VPWR VPWR accumulator._0307_ sky130_fd_sc_hd__o21ba_1
Xaccumulator._1974_ accumulator._1050_ accumulator._1052_ accumulator._1065_ accumulator._1068_
+ VGND VGND VPWR VPWR accumulator._1069_ sky130_fd_sc_hd__or4_4
XFILLER_0_24_281 VGND VGND VPWR VPWR sky130_fd_sc_hd__fill_2
XFILLER_0_24_270 VGND VGND VPWR VPWR sky130_fd_sc_hd__fill_2
XFILLER_0_16_204 VGND VGND VPWR VPWR sky130_fd_sc_hd__decap_8
XFILLER_0_24_292 VPWR VGND VPWR VGND sky130_ef_sc_hd__decap_12
Xaccumulator._2388_ clknet_2_3__leaf_clock accumulator._0033_ VGND VGND VPWR VPWR
+ accumulator.state\[0\] sky130_fd_sc_hd__dfxtp_1
Xaccumulator._1408_ accumulator.io_accOut\[15\] accumulator._0502_ accumulator._0377_
+ VGND VGND VPWR VPWR accumulator._0503_ sky130_fd_sc_hd__mux2_4
XFILLER_0_66_126 VGND VGND VPWR VPWR sky130_fd_sc_hd__decap_3
XFILLER_0_62_321 VPWR VGND VPWR VGND sky130_ef_sc_hd__decap_12
XFILLER_0_39_329 VGND VGND VPWR VPWR sky130_fd_sc_hd__fill_2
Xaccumulator._1339_ accumulator.io_inMant\[6\] accumulator.io_inMant\[7\] accumulator._0428_
+ VGND VGND VPWR VPWR accumulator._0434_ sky130_fd_sc_hd__mux2_1
XPHY_EDGE_ROW_0_Right_0 VGND VGND VPWR VPWR sky130_fd_sc_hd__decap_3
XFILLER_0_62_365 VPWR VGND VPWR VGND sky130_ef_sc_hd__decap_12
XTAP_TAPCELL_ROW_50_496 VGND VPWR sky130_fd_sc_hd__tapvpwrvgnd_1
XFILLER_0_30_251 VGND VGND VPWR VPWR sky130_fd_sc_hd__fill_1
XTAP_TAPCELL_ROW_7_196 VGND VPWR sky130_fd_sc_hd__tapvpwrvgnd_1
XTAP_TAPCELL_ROW_58_552 VGND VPWR sky130_fd_sc_hd__tapvpwrvgnd_1
XFILLER_0_38_340 VGND VGND VPWR VPWR sky130_fd_sc_hd__fill_1
XTAP_TAPCELL_ROW_41_430 VGND VPWR sky130_fd_sc_hd__tapvpwrvgnd_1
XFILLER_0_13_218 VGND VGND VPWR VPWR sky130_fd_sc_hd__decap_6
Xaccumulator._1690_ accumulator._0583_ accumulator._0767_ accumulator._0783_ accumulator._0784_
+ VGND VGND VPWR VPWR accumulator._0785_ sky130_fd_sc_hd__o31a_1
XFILLER_0_0_189 VGND VGND VPWR VPWR sky130_fd_sc_hd__decap_3
XscaleAdd._327_ operator.io_outMant\[1\] scaleAdd._233_ VGND VGND VPWR VPWR scaleAdd._034_
+ sky130_fd_sc_hd__nand2_1
Xaccumulator._2311_ accumulator._0260_ accumulator._0262_ VGND VGND VPWR VPWR accumulator._0263_
+ sky130_fd_sc_hd__and2_1
Xaccumulator._2242_ net106 accumulator._0147_ accumulator._0381_ accumulator._0195_
+ VGND VGND VPWR VPWR accumulator._0019_ sky130_fd_sc_hd__o211a_1
XscaleAdd._258_ scaleAdd._199_ scaleAdd._201_ VGND VGND VPWR VPWR accumulator.io_inMant\[4\]
+ sky130_fd_sc_hd__xnor2_1
XFILLER_0_60_83 VGND VGND VPWR VPWR sky130_fd_sc_hd__fill_1
Xaccumulator._2173_ accumulator._1103_ accumulator._1107_ accumulator._0047_ VGND
+ VGND VPWR VPWR accumulator._0128_ sky130_fd_sc_hd__mux2_1
XFILLER_0_56_192 VGND VGND VPWR VPWR sky130_fd_sc_hd__decap_4
XFILLER_0_29_384 VGND VGND VPWR VPWR sky130_fd_sc_hd__decap_4
XFILLER_0_8_267 VGND VGND VPWR VPWR sky130_fd_sc_hd__decap_4
Xaccumulator._1957_ accumulator._1047_ accumulator._1051_ VGND VGND VPWR VPWR accumulator._1052_
+ sky130_fd_sc_hd__xor2_2
XFILLER_0_44_365 VPWR VGND VPWR VGND sky130_ef_sc_hd__decap_12
Xaccumulator._1888_ accumulator._0756_ accumulator._0982_ VGND VGND VPWR VPWR accumulator._0983_
+ sky130_fd_sc_hd__xor2_2
XTAP_TAPCELL_ROW_55_533 VGND VPWR sky130_fd_sc_hd__tapvpwrvgnd_1
XTAP_TAPCELL_ROW_4_177 VGND VPWR sky130_fd_sc_hd__tapvpwrvgnd_1
Xclone42 accumulator._1170_ VGND VGND VPWR VPWR net100 sky130_fd_sc_hd__clkbuf_16
XFILLER_0_62_195 VGND VGND VPWR VPWR sky130_fd_sc_hd__fill_1
XFILLER_0_65_39 VPWR VGND VPWR VGND sky130_ef_sc_hd__decap_12
XFILLER_0_26_332 VGND VGND VPWR VPWR sky130_fd_sc_hd__fill_1
XFILLER_0_14_54 VGND VGND VPWR VPWR sky130_fd_sc_hd__decap_3
XFILLER_0_53_162 VGND VGND VPWR VPWR sky130_fd_sc_hd__decap_6
XFILLER_0_41_324 VGND VGND VPWR VPWR sky130_fd_sc_hd__decap_4
XFILLER_0_30_97 VPWR VGND VPWR VGND sky130_ef_sc_hd__decap_12
XFILLER_0_26_365 VGND VGND VPWR VPWR sky130_fd_sc_hd__fill_2
Xaccumulator._1811_ accumulator._0905_ accumulator._0903_ VGND VGND VPWR VPWR accumulator._0906_
+ sky130_fd_sc_hd__or2_1
XFILLER_0_5_215 VGND VGND VPWR VPWR sky130_fd_sc_hd__fill_1
XFILLER_0_5_237 VPWR VGND VPWR VGND sky130_ef_sc_hd__decap_12
XFILLER_0_39_73 VPWR VGND VPWR VGND sky130_ef_sc_hd__decap_12
Xaccumulator._1742_ accumulator._0836_ VGND VGND VPWR VPWR accumulator._0837_ sky130_fd_sc_hd__inv_2
Xaccumulator._1673_ accumulator._0608_ accumulator._0610_ VGND VGND VPWR VPWR accumulator._0768_
+ sky130_fd_sc_hd__nor2_1
Xaccumulator._2156_ accumulator._0107_ accumulator._0110_ VGND VGND VPWR VPWR accumulator._0111_
+ sky130_fd_sc_hd__nand2_1
Xaccumulator._2225_ accumulator._1122_ accumulator._0178_ VGND VGND VPWR VPWR accumulator._0179_
+ sky130_fd_sc_hd__nand2_1
XFILLER_0_12_3 VPWR VGND VPWR VGND sky130_ef_sc_hd__decap_12
Xaccumulator._2087_ accumulator._0041_ VGND VGND VPWR VPWR accumulator._0042_ sky130_fd_sc_hd__clkbuf_4
XFILLER_0_29_181 VPWR VGND VPWR VGND sky130_ef_sc_hd__decap_12
XFILLER_0_17_332 VGND VGND VPWR VPWR sky130_fd_sc_hd__decap_4
XFILLER_0_17_354 VPWR VGND VPWR VGND sky130_ef_sc_hd__decap_12
XFILLER_0_44_195 VGND VGND VPWR VPWR sky130_fd_sc_hd__fill_1
XFILLER_0_4_281 VPWR VGND VPWR VGND sky130_ef_sc_hd__decap_12
XFILLER_0_67_265 VPWR VGND VPWR VGND sky130_ef_sc_hd__decap_12
XFILLER_0_67_243 VGND VGND VPWR VPWR sky130_fd_sc_hd__decap_8
XFILLER_0_67_221 VGND VGND VPWR VPWR sky130_fd_sc_hd__decap_3
XTAP_TAPCELL_ROW_15_249 VGND VPWR sky130_fd_sc_hd__tapvpwrvgnd_1
XPHY_EDGE_ROW_41_Left_109 VGND VGND VPWR VPWR sky130_fd_sc_hd__decap_3
XPHY_EDGE_ROW_50_Left_118 VGND VGND VPWR VPWR sky130_fd_sc_hd__decap_3
XTAP_TAPCELL_ROW_66_606 VGND VPWR sky130_fd_sc_hd__tapvpwrvgnd_1
Xaccumulator._2010_ accumulator._0955_ accumulator._0959_ VGND VGND VPWR VPWR accumulator._1105_
+ sky130_fd_sc_hd__nor2_1
XFILLER_0_25_64 VPWR VGND VPWR VGND sky130_ef_sc_hd__decap_12
XFILLER_0_41_74 VGND VGND VPWR VPWR sky130_fd_sc_hd__fill_1
XFILLER_0_41_30 VGND VGND VPWR VPWR sky130_fd_sc_hd__decap_4
XFILLER_0_41_198 VPWR VGND VPWR VGND sky130_ef_sc_hd__decap_12
XFILLER_0_41_143 VGND VGND VPWR VPWR sky130_fd_sc_hd__decap_3
XFILLER_0_1_262 VGND VGND VPWR VPWR sky130_fd_sc_hd__decap_4
Xaccumulator._1725_ accumulator._0554_ accumulator._0817_ accumulator._0819_ accumulator._0513_
+ VGND VGND VPWR VPWR accumulator._0820_ sky130_fd_sc_hd__a211o_1
Xaccumulator._1656_ accumulator._0667_ accumulator._0683_ accumulator._0749_ accumulator._0750_
+ VGND VGND VPWR VPWR accumulator._0751_ sky130_fd_sc_hd__a31oi_2
Xaccumulator._1587_ accumulator.io_accOut\[5\] accumulator._0378_ VGND VGND VPWR VPWR
+ accumulator._0682_ sky130_fd_sc_hd__nand2_1
Xaccumulator._2208_ accumulator._1008_ accumulator._1006_ accumulator._0057_ VGND
+ VGND VPWR VPWR accumulator._0162_ sky130_fd_sc_hd__mux2_2
XFILLER_0_64_235 VPWR VGND VPWR VGND sky130_ef_sc_hd__decap_12
Xaccumulator._2139_ accumulator._0079_ accumulator._0093_ accumulator._0042_ VGND
+ VGND VPWR VPWR accumulator._0094_ sky130_fd_sc_hd__mux2_2
XFILLER_0_32_165 VGND VGND VPWR VPWR sky130_fd_sc_hd__decap_8
XTAP_TAPCELL_ROW_20_285 VGND VPWR sky130_fd_sc_hd__tapvpwrvgnd_1
XFILLER_0_20_305 VGND VGND VPWR VPWR sky130_fd_sc_hd__decap_3
XFILLER_0_1_3 VPWR VGND VPWR VGND sky130_ef_sc_hd__decap_12
XFILLER_0_13_390 VGND VGND VPWR VPWR sky130_fd_sc_hd__fill_2
XFILLER_0_62_29 VPWR VGND VPWR VGND sky130_ef_sc_hd__decap_12
XTAP_TAPCELL_ROW_28_341 VGND VPWR sky130_fd_sc_hd__tapvpwrvgnd_1
XFILLER_0_55_246 VPWR VGND VPWR VGND sky130_ef_sc_hd__decap_12
XFILLER_0_23_121 VGND VGND VPWR VPWR sky130_fd_sc_hd__fill_2
XFILLER_0_11_55 VGND VGND VPWR VPWR sky130_fd_sc_hd__fill_1
XFILLER_0_11_99 VGND VGND VPWR VPWR sky130_fd_sc_hd__decap_4
XFILLER_0_36_63 VGND VGND VPWR VPWR sky130_fd_sc_hd__decap_3
Xinput4 io_inA[3] VGND VGND VPWR VPWR net4 sky130_fd_sc_hd__buf_1
Xaccumulator._1372_ net91 accumulator._0465_ accumulator._0466_ VGND VGND VPWR VPWR
+ accumulator._0467_ sky130_fd_sc_hd__a21oi_1
Xaccumulator._1441_ accumulator._0513_ VGND VGND VPWR VPWR accumulator._0536_ sky130_fd_sc_hd__buf_2
Xaccumulator._1510_ accumulator._0409_ accumulator._0579_ VGND VGND VPWR VPWR accumulator._0605_
+ sky130_fd_sc_hd__or2_2
XFILLER_0_52_62 VPWR VGND VPWR VGND sky130_ef_sc_hd__decap_12
XFILLER_0_36_85 VGND VGND VPWR VPWR sky130_fd_sc_hd__decap_6
XFILLER_0_6_365 VGND VGND VPWR VPWR sky130_fd_sc_hd__decap_6
XFILLER_0_6_376 VGND VGND VPWR VPWR sky130_fd_sc_hd__decap_3
XFILLER_0_14_165 VPWR VGND VPWR VGND sky130_ef_sc_hd__decap_12
Xaccumulator._1708_ accumulator._0799_ accumulator._0800_ accumulator._0756_ accumulator._0802_
+ accumulator._0754_ VGND VGND VPWR VPWR accumulator._0803_ sky130_fd_sc_hd__o32a_1
Xoperator._28_ net1 operator._07_ operator._06_ VGND VGND VPWR VPWR operator._10_
+ sky130_fd_sc_hd__and3_1
Xaccumulator._1639_ accumulator.io_accOut\[0\] net107 accumulator._0414_ accumulator._0424_
+ VGND VGND VPWR VPWR accumulator._0734_ sky130_fd_sc_hd__and4_1
XTAP_TAPCELL_ROW_25_322 VGND VPWR sky130_fd_sc_hd__tapvpwrvgnd_1
XscaleAdd._360_ scaleAdd._064_ scaleAdd._065_ VGND VGND VPWR VPWR scaleAdd._066_ sky130_fd_sc_hd__and2b_1
XFILLER_0_20_102 VGND VGND VPWR VPWR sky130_fd_sc_hd__fill_1
XFILLER_0_20_124 VGND VGND VPWR VPWR sky130_fd_sc_hd__fill_2
X_00_ accumulator.io_accOut\[0\] VGND VGND VPWR VPWR net23 sky130_fd_sc_hd__buf_1
XscaleAdd._291_ scaleAdd._232_ scaleAdd._230_ VGND VGND VPWR VPWR scaleAdd._233_ sky130_fd_sc_hd__xnor2_2
XFILLER_0_28_224 VGND VGND VPWR VPWR sky130_fd_sc_hd__decap_6
Xaccumulator._1990_ accumulator._1074_ accumulator._1079_ VGND VGND VPWR VPWR accumulator._1085_
+ sky130_fd_sc_hd__nand2_1
XFILLER_0_3_324 VGND VGND VPWR VPWR sky130_fd_sc_hd__decap_4
XFILLER_0_7_118 VGND VGND VPWR VPWR sky130_fd_sc_hd__decap_3
XscaleAdd._489_ scaleAdd._176_ scaleAdd._178_ scaleAdd._180_ VGND VGND VPWR VPWR accumulator.io_inExp\[6\]
+ sky130_fd_sc_hd__a21oi_1
XFILLER_0_11_113 VPWR VGND VPWR VGND sky130_ef_sc_hd__decap_12
Xaccumulator._1355_ accumulator._0448_ accumulator._0449_ accumulator._0203_ VGND
+ VGND VPWR VPWR accumulator._0450_ sky130_fd_sc_hd__mux2_1
Xaccumulator._1424_ accumulator._0518_ VGND VGND VPWR VPWR accumulator._0519_ sky130_fd_sc_hd__inv_2
XFILLER_0_2_53 VPWR VGND VPWR VGND sky130_ef_sc_hd__decap_12
XFILLER_0_63_72 VPWR VGND VPWR VGND sky130_ef_sc_hd__decap_12
XFILLER_0_59_393 VGND VGND VPWR VPWR sky130_fd_sc_hd__decap_8
Xaccumulator._1286_ accumulator._0382_ VGND VGND VPWR VPWR accumulator._0383_ sky130_fd_sc_hd__buf_2
XFILLER_0_34_205 VGND VGND VPWR VPWR sky130_fd_sc_hd__fill_2
XTAP_TAPCELL_ROW_22_303 VGND VPWR sky130_fd_sc_hd__tapvpwrvgnd_1
XFILLER_0_2_97 VPWR VGND VPWR VGND sky130_ef_sc_hd__decap_12
XFILLER_0_19_246 VGND VGND VPWR VPWR sky130_fd_sc_hd__decap_4
XFILLER_0_19_279 VGND VGND VPWR VPWR sky130_fd_sc_hd__fill_1
XFILLER_0_42_293 VGND VGND VPWR VPWR sky130_fd_sc_hd__fill_2
XFILLER_0_65_385 VGND VGND VPWR VPWR sky130_fd_sc_hd__decap_6
XscaleAdd._412_ scaleAdd._104_ scaleAdd._114_ VGND VGND VPWR VPWR scaleAdd._115_ sky130_fd_sc_hd__xnor2_2
XscaleAdd._343_ scaleAdd._047_ scaleAdd._048_ VGND VGND VPWR VPWR scaleAdd._049_ sky130_fd_sc_hd__and2_4
XscaleAdd._274_ operator.io_outMant\[3\] scaleAdd._185_ scaleAdd._184_ VGND VGND VPWR
+ VPWR scaleAdd._216_ sky130_fd_sc_hd__and3_1
XFILLER_0_56_363 VGND VGND VPWR VPWR sky130_fd_sc_hd__fill_1
XFILLER_0_56_330 VGND VGND VPWR VPWR sky130_fd_sc_hd__fill_1
XFILLER_0_33_20 VPWR VGND VPWR VGND sky130_ef_sc_hd__decap_12
Xaccumulator._1973_ accumulator._1067_ VGND VGND VPWR VPWR accumulator._1068_ sky130_fd_sc_hd__inv_2
XFILLER_0_12_400 VGND VGND VPWR VPWR sky130_fd_sc_hd__fill_1
XFILLER_0_58_72 VGND VGND VPWR VPWR sky130_fd_sc_hd__fill_1
XFILLER_0_42_3 VPWR VGND VPWR VGND sky130_ef_sc_hd__decap_12
Xaccumulator._2387_ clknet_2_2__leaf_clock accumulator._0032_ VGND VGND VPWR VPWR
+ accumulator.io_accOut\[30\] sky130_fd_sc_hd__dfxtp_2
Xaccumulator._1407_ net62 accumulator._0432_ accumulator._0435_ net98 VGND VGND VPWR
+ VPWR accumulator._0502_ sky130_fd_sc_hd__a22o_1
Xaccumulator._1338_ accumulator.io_inMant\[4\] accumulator.io_inMant\[5\] accumulator._0311_
+ VGND VGND VPWR VPWR accumulator._0433_ sky130_fd_sc_hd__mux2_1
XFILLER_0_66_138 VGND VGND VPWR VPWR sky130_fd_sc_hd__fill_2
XFILLER_0_62_333 VPWR VGND VPWR VGND sky130_ef_sc_hd__decap_12
XTAP_TAPCELL_ROW_50_497 VGND VPWR sky130_fd_sc_hd__tapvpwrvgnd_1
Xaccumulator._1269_ net64 accumulator._0333_ accumulator._0365_ VGND VGND VPWR VPWR
+ accumulator._0366_ sky130_fd_sc_hd__o21ba_1
XFILLER_0_62_377 VPWR VGND VPWR VGND sky130_ef_sc_hd__decap_12
XTAP_TAPCELL_ROW_58_553 VGND VPWR sky130_fd_sc_hd__tapvpwrvgnd_1
XTAP_TAPCELL_ROW_7_197 VGND VPWR sky130_fd_sc_hd__tapvpwrvgnd_1
XTAP_TAPCELL_ROW_41_431 VGND VPWR sky130_fd_sc_hd__tapvpwrvgnd_1
XFILLER_0_38_363 VGND VGND VPWR VPWR sky130_fd_sc_hd__fill_1
XFILLER_0_28_20 VGND VGND VPWR VPWR sky130_fd_sc_hd__decap_8
XFILLER_0_0_113 VPWR VGND VPWR VGND sky130_ef_sc_hd__decap_12
XscaleAdd._326_ scaleAdd._028_ scaleAdd._030_ scaleAdd._031_ VGND VGND VPWR VPWR scaleAdd._033_
+ sky130_fd_sc_hd__a21oi_1
Xaccumulator._2310_ accumulator._0259_ accumulator._0257_ VGND VGND VPWR VPWR accumulator._0262_
+ sky130_fd_sc_hd__nand2_2
Xaccumulator._2241_ accumulator._0061_ accumulator._0158_ accumulator._0147_ accumulator._0194_
+ VGND VGND VPWR VPWR accumulator._0195_ sky130_fd_sc_hd__o211ai_2
Xaccumulator._2172_ accumulator._0061_ accumulator._0114_ VGND VGND VPWR VPWR accumulator._0127_
+ sky130_fd_sc_hd__nor2_1
XFILLER_0_44_85 VGND VGND VPWR VPWR sky130_fd_sc_hd__fill_1
XFILLER_0_44_41 VGND VGND VPWR VPWR sky130_fd_sc_hd__decap_6
XscaleAdd._257_ scaleAdd._184_ accumulator.io_inMant\[1\] VGND VGND VPWR VPWR scaleAdd._201_
+ sky130_fd_sc_hd__and2_1
XFILLER_0_63_108 VGND VGND VPWR VPWR sky130_fd_sc_hd__decap_4
XFILLER_0_60_73 VGND VGND VPWR VPWR sky130_fd_sc_hd__fill_1
XFILLER_0_44_333 VPWR VGND VPWR VGND sky130_ef_sc_hd__decap_12
Xaccumulator._1956_ accumulator._1022_ accumulator._1044_ VGND VGND VPWR VPWR accumulator._1051_
+ sky130_fd_sc_hd__nand2_1
XFILLER_0_44_377 VPWR VGND VPWR VGND sky130_ef_sc_hd__decap_12
Xaccumulator._1887_ accumulator._0918_ accumulator._0801_ accumulator._0979_ accumulator._0981_
+ VGND VGND VPWR VPWR accumulator._0982_ sky130_fd_sc_hd__o31a_1
XFILLER_0_8_41 VPWR VGND VPWR VGND sky130_ef_sc_hd__decap_12
XTAP_TAPCELL_ROW_55_534 VGND VPWR sky130_fd_sc_hd__tapvpwrvgnd_1
XFILLER_0_39_127 VPWR VGND VPWR VGND sky130_ef_sc_hd__decap_12
Xclone43 accumulator._1170_ VGND VGND VPWR VPWR net101 sky130_fd_sc_hd__clkbuf_16
XFILLER_0_50_314 VGND VGND VPWR VPWR sky130_fd_sc_hd__decap_8
XFILLER_0_35_300 VGND VGND VPWR VPWR sky130_fd_sc_hd__decap_3
XFILLER_0_53_141 VGND VGND VPWR VPWR sky130_fd_sc_hd__decap_8
XTAP_TAPCELL_ROW_18_269 VGND VPWR sky130_fd_sc_hd__tapvpwrvgnd_1
XFILLER_0_41_347 VPWR VGND VPWR VGND sky130_ef_sc_hd__decap_12
Xaccumulator._1741_ accumulator._0704_ accumulator._0705_ VGND VGND VPWR VPWR accumulator._0836_
+ sky130_fd_sc_hd__xnor2_1
Xaccumulator._1810_ accumulator._0663_ accumulator._0787_ VGND VGND VPWR VPWR accumulator._0905_
+ sky130_fd_sc_hd__nor2_1
XFILLER_0_5_249 VPWR VGND VPWR VGND sky130_ef_sc_hd__decap_12
XFILLER_0_55_51 VGND VGND VPWR VPWR sky130_fd_sc_hd__decap_4
Xaccumulator._1672_ accumulator._0585_ accumulator._0634_ accumulator._0759_ accumulator._0764_
+ accumulator._0766_ VGND VGND VPWR VPWR accumulator._0767_ sky130_fd_sc_hd__a41o_1
XscaleAdd._309_ scaleAdd._015_ scaleAdd._012_ VGND VGND VPWR VPWR scaleAdd._016_ sky130_fd_sc_hd__nor2_2
Xaccumulator._2224_ accumulator._0142_ accumulator._0177_ accumulator._0107_ VGND
+ VGND VPWR VPWR accumulator._0178_ sky130_fd_sc_hd__mux2_1
Xaccumulator._2155_ accumulator._0108_ accumulator._0109_ accumulator._0044_ VGND
+ VGND VPWR VPWR accumulator._0110_ sky130_fd_sc_hd__mux2_4
Xaccumulator._2086_ accumulator._1175_ accumulator._0040_ accumulator._1090_ VGND
+ VGND VPWR VPWR accumulator._0041_ sky130_fd_sc_hd__a21o_1
XFILLER_0_44_141 VPWR VGND VPWR VGND sky130_ef_sc_hd__decap_12
XFILLER_0_32_336 VGND VGND VPWR VPWR sky130_fd_sc_hd__fill_1
XFILLER_0_29_193 VGND VGND VPWR VPWR sky130_fd_sc_hd__fill_2
XFILLER_0_4_260 VGND VGND VPWR VPWR sky130_fd_sc_hd__fill_1
XFILLER_0_17_366 VPWR VGND VPWR VGND sky130_ef_sc_hd__decap_12
Xaccumulator._1939_ accumulator._0988_ accumulator._0992_ accumulator._0947_ VGND
+ VGND VPWR VPWR accumulator._1034_ sky130_fd_sc_hd__a21o_1
XFILLER_0_4_293 VPWR VGND VPWR VGND sky130_ef_sc_hd__decap_12
XFILLER_0_67_277 VGND VGND VPWR VPWR sky130_fd_sc_hd__decap_3
XFILLER_0_27_119 VGND VGND VPWR VPWR sky130_fd_sc_hd__fill_1
XFILLER_0_27_108 VGND VGND VPWR VPWR sky130_fd_sc_hd__decap_4
XTAP_TAPCELL_ROW_66_607 VGND VPWR sky130_fd_sc_hd__tapvpwrvgnd_1
XFILLER_0_25_76 VPWR VGND VPWR VGND sky130_ef_sc_hd__decap_12
XFILLER_0_26_185 VGND VGND VPWR VPWR sky130_fd_sc_hd__fill_1
XFILLER_0_26_141 VGND VGND VPWR VPWR sky130_fd_sc_hd__decap_4
XFILLER_0_14_303 VGND VGND VPWR VPWR sky130_fd_sc_hd__decap_4
XFILLER_0_1_241 VGND VGND VPWR VPWR sky130_fd_sc_hd__fill_1
Xaccumulator._1724_ accumulator._0818_ accumulator._0551_ accumulator._0488_ accumulator._0457_
+ VGND VGND VPWR VPWR accumulator._0819_ sky130_fd_sc_hd__and4b_1
XFILLER_0_66_83 VGND VGND VPWR VPWR sky130_fd_sc_hd__fill_1
Xaccumulator._1655_ accumulator._0665_ accumulator._0666_ VGND VGND VPWR VPWR accumulator._0750_
+ sky130_fd_sc_hd__nor2_1
Xaccumulator._1586_ accumulator._0670_ accumulator._0605_ accumulator._0676_ accumulator._0680_
+ VGND VGND VPWR VPWR accumulator._0681_ sky130_fd_sc_hd__o211a_1
Xaccumulator._2069_ accumulator._1164_ accumulator._1142_ accumulator._1050_ VGND
+ VGND VPWR VPWR accumulator._1165_ sky130_fd_sc_hd__a21o_1
XFILLER_0_64_247 VGND VGND VPWR VPWR sky130_fd_sc_hd__decap_4
Xaccumulator._2138_ accumulator._1148_ accumulator._0092_ accumulator._0046_ VGND
+ VGND VPWR VPWR accumulator._0093_ sky130_fd_sc_hd__mux2_2
XFILLER_0_49_233 VGND VGND VPWR VPWR sky130_fd_sc_hd__fill_1
Xaccumulator._2207_ accumulator._0097_ accumulator._0158_ accumulator._0384_ VGND
+ VGND VPWR VPWR accumulator._0161_ sky130_fd_sc_hd__o21ai_1
XTAP_TAPCELL_ROW_20_286 VGND VPWR sky130_fd_sc_hd__tapvpwrvgnd_1
XTAP_TAPCELL_ROW_28_342 VGND VPWR sky130_fd_sc_hd__tapvpwrvgnd_1
XFILLER_0_55_258 VPWR VGND VPWR VGND sky130_ef_sc_hd__decap_12
XFILLER_0_55_225 VGND VGND VPWR VPWR sky130_fd_sc_hd__decap_8
XTAP_TAPCELL_ROW_11_220 VGND VPWR sky130_fd_sc_hd__tapvpwrvgnd_1
XFILLER_0_23_144 VGND VGND VPWR VPWR sky130_fd_sc_hd__fill_1
XFILLER_0_11_317 VPWR VGND VPWR VGND sky130_ef_sc_hd__decap_12
Xaccumulator._1440_ accumulator._0534_ VGND VGND VPWR VPWR accumulator._0535_ sky130_fd_sc_hd__buf_2
Xaccumulator._1371_ accumulator._0203_ accumulator._0463_ accumulator._0429_ VGND
+ VGND VPWR VPWR accumulator._0466_ sky130_fd_sc_hd__and3_1
Xinput5 io_inB[0] VGND VGND VPWR VPWR net5 sky130_fd_sc_hd__clkbuf_1
XFILLER_0_52_74 VGND VGND VPWR VPWR sky130_fd_sc_hd__fill_1
XFILLER_0_6_355 VGND VGND VPWR VPWR sky130_fd_sc_hd__decap_8
XFILLER_0_14_100 VGND VGND VPWR VPWR sky130_fd_sc_hd__decap_3
XFILLER_0_14_133 VGND VGND VPWR VPWR sky130_fd_sc_hd__decap_6
XFILLER_0_14_177 VPWR VGND VPWR VGND sky130_ef_sc_hd__decap_12
Xaccumulator._1707_ accumulator._0755_ accumulator._0801_ VGND VGND VPWR VPWR accumulator._0802_
+ sky130_fd_sc_hd__nor2_1
Xaccumulator._1638_ accumulator._0462_ accumulator._0655_ accumulator._0689_ accumulator._0488_
+ VGND VGND VPWR VPWR accumulator._0733_ sky130_fd_sc_hd__a211o_1
XTAP_TAPCELL_ROW_25_323 VGND VPWR sky130_fd_sc_hd__tapvpwrvgnd_1
Xaccumulator._1569_ accumulator._0661_ accumulator._0605_ accumulator._0637_ accumulator._0663_
+ VGND VGND VPWR VPWR accumulator._0664_ sky130_fd_sc_hd__o22a_1
Xoperator._27_ operator._09_ VGND VGND VPWR VPWR operator.io_outMant\[2\] sky130_fd_sc_hd__clkbuf_1
XFILLER_0_60_261 VGND VGND VPWR VPWR sky130_fd_sc_hd__fill_1
XscaleAdd._290_ net11 scaleAdd._203_ scaleAdd._231_ VGND VGND VPWR VPWR scaleAdd._232_
+ sky130_fd_sc_hd__o21ba_1
XFILLER_0_20_136 VGND VGND VPWR VPWR sky130_fd_sc_hd__decap_4
XFILLER_0_22_11 VGND VGND VPWR VPWR sky130_fd_sc_hd__fill_2
XFILLER_0_51_250 VPWR VGND VPWR VGND sky130_ef_sc_hd__decap_12
XFILLER_0_22_77 VGND VGND VPWR VPWR sky130_fd_sc_hd__decap_6
XFILLER_0_22_55 VGND VGND VPWR VPWR sky130_fd_sc_hd__fill_1
XFILLER_0_3_303 VGND VGND VPWR VPWR sky130_fd_sc_hd__decap_8
XscaleAdd._488_ scaleAdd._176_ scaleAdd._178_ scaleAdd._180_ VGND VGND VPWR VPWR accumulator.io_inExp\[4\]
+ sky130_fd_sc_hd__a21oi_1
XFILLER_0_11_125 VGND VGND VPWR VPWR sky130_fd_sc_hd__fill_2
XFILLER_0_11_169 VPWR VGND VPWR VGND sky130_ef_sc_hd__decap_12
XFILLER_0_66_309 VPWR VGND VPWR VGND sky130_ef_sc_hd__decap_12
XFILLER_0_63_84 VPWR VGND VPWR VGND sky130_ef_sc_hd__decap_12
XFILLER_0_63_51 VGND VGND VPWR VPWR sky130_fd_sc_hd__fill_2
Xaccumulator._1285_ accumulator.state\[1\] accumulator.state\[0\] VGND VGND VPWR VPWR
+ accumulator._0382_ sky130_fd_sc_hd__and2b_1
Xaccumulator._1423_ accumulator._0340_ accumulator._0517_ accumulator._0386_ VGND
+ VGND VPWR VPWR accumulator._0518_ sky130_fd_sc_hd__mux2_4
Xaccumulator._1354_ accumulator.io_inMant\[5\] accumulator.io_inMant\[6\] accumulator._0311_
+ VGND VGND VPWR VPWR accumulator._0449_ sky130_fd_sc_hd__mux2_1
XFILLER_0_2_65 VPWR VGND VPWR VGND sky130_ef_sc_hd__decap_12
XFILLER_0_59_361 VPWR VGND VPWR VGND sky130_ef_sc_hd__decap_12
XFILLER_0_34_239 VGND VGND VPWR VPWR sky130_fd_sc_hd__fill_2
XFILLER_0_6_130 VGND VGND VPWR VPWR sky130_fd_sc_hd__decap_8
XFILLER_0_6_141 VGND VGND VPWR VPWR sky130_fd_sc_hd__decap_8
XFILLER_0_42_261 VPWR VGND VPWR VGND sky130_ef_sc_hd__decap_12
Xmax_cap56 accumulator._0822_ VGND VGND VPWR VPWR net56 sky130_fd_sc_hd__buf_2
XFILLER_0_25_239 VPWR VGND VPWR VGND sky130_ef_sc_hd__decap_12
XscaleAdd._411_ scaleAdd._111_ scaleAdd._113_ VGND VGND VPWR VPWR scaleAdd._114_ sky130_fd_sc_hd__xnor2_2
XFILLER_0_0_328 VGND VGND VPWR VPWR sky130_fd_sc_hd__decap_4
XscaleAdd._342_ scaleAdd._015_ scaleAdd._013_ VGND VGND VPWR VPWR scaleAdd._048_ sky130_fd_sc_hd__or2_1
XscaleAdd._273_ scaleAdd._214_ scaleAdd._215_ VGND VGND VPWR VPWR accumulator.io_inMant\[5\]
+ sky130_fd_sc_hd__xor2_2
XFILLER_0_48_309 VPWR VGND VPWR VGND sky130_ef_sc_hd__decap_12
XFILLER_0_17_55 VGND VGND VPWR VPWR sky130_fd_sc_hd__fill_1
XFILLER_0_17_77 VGND VGND VPWR VPWR sky130_fd_sc_hd__fill_2
XFILLER_0_17_99 VGND VGND VPWR VPWR sky130_fd_sc_hd__fill_1
XFILLER_0_56_397 VGND VGND VPWR VPWR sky130_fd_sc_hd__fill_1
XTAP_TAPCELL_ROW_44_451 VGND VPWR sky130_fd_sc_hd__tapvpwrvgnd_1
XFILLER_0_33_65 VGND VGND VPWR VPWR sky130_fd_sc_hd__decap_3
XFILLER_0_33_32 VGND VGND VPWR VPWR sky130_fd_sc_hd__decap_4
XPHY_EDGE_ROW_26_Left_94 VGND VGND VPWR VPWR sky130_fd_sc_hd__decap_3
Xaccumulator._1972_ accumulator._1062_ accumulator._1066_ VGND VGND VPWR VPWR accumulator._1067_
+ sky130_fd_sc_hd__xor2_1
XFILLER_0_3_111 VGND VGND VPWR VPWR sky130_fd_sc_hd__fill_1
XFILLER_0_58_51 VGND VGND VPWR VPWR sky130_fd_sc_hd__fill_1
XPHY_EDGE_ROW_10_Left_78 VGND VGND VPWR VPWR sky130_fd_sc_hd__decap_3
XFILLER_0_66_106 VPWR VGND VPWR VGND sky130_ef_sc_hd__decap_12
Xaccumulator._2386_ clknet_2_3__leaf_clock accumulator._0031_ VGND VGND VPWR VPWR
+ accumulator.io_accOut\[29\] sky130_fd_sc_hd__dfxtp_1
XFILLER_0_39_309 VGND VGND VPWR VPWR sky130_fd_sc_hd__decap_6
Xaccumulator._1337_ accumulator._0429_ accumulator._0430_ accumulator._0431_ VGND
+ VGND VPWR VPWR accumulator._0432_ sky130_fd_sc_hd__mux2_1
Xaccumulator._1406_ accumulator._0494_ accumulator._0499_ accumulator._0500_ VGND
+ VGND VPWR VPWR accumulator._0501_ sky130_fd_sc_hd__a21o_1
Xaccumulator._1268_ net63 accumulator._0333_ accumulator._0364_ VGND VGND VPWR VPWR
+ accumulator._0365_ sky130_fd_sc_hd__and3_1
XFILLER_0_62_389 VPWR VGND VPWR VGND sky130_ef_sc_hd__decap_12
XFILLER_0_62_345 VPWR VGND VPWR VGND sky130_ef_sc_hd__decap_12
XFILLER_0_62_301 VGND VGND VPWR VPWR sky130_fd_sc_hd__decap_6
XTAP_TAPCELL_ROW_50_498 VGND VPWR sky130_fd_sc_hd__tapvpwrvgnd_1
XFILLER_0_47_353 VPWR VGND VPWR VGND sky130_ef_sc_hd__decap_12
Xaccumulator._1199_ accumulator.io_inMant\[7\] accumulator.io_inMant\[5\] accumulator.io_inMant\[4\]
+ accumulator.io_inMant\[6\] VGND VGND VPWR VPWR accumulator._0222_ sky130_fd_sc_hd__or4_1
XFILLER_0_22_209 VGND VGND VPWR VPWR sky130_fd_sc_hd__fill_1
XFILLER_0_30_275 VGND VGND VPWR VPWR sky130_fd_sc_hd__decap_8
XFILLER_0_30_253 VGND VGND VPWR VPWR sky130_fd_sc_hd__decap_6
XFILLER_0_15_294 VGND VGND VPWR VPWR sky130_fd_sc_hd__fill_1
XTAP_TAPCELL_ROW_58_554 VGND VPWR sky130_fd_sc_hd__tapvpwrvgnd_1
XTAP_TAPCELL_ROW_7_198 VGND VPWR sky130_fd_sc_hd__tapvpwrvgnd_1
XTAP_TAPCELL_ROW_41_432 VGND VPWR sky130_fd_sc_hd__tapvpwrvgnd_1
XFILLER_0_53_334 VGND VGND VPWR VPWR sky130_fd_sc_hd__fill_2
XFILLER_0_0_125 VPWR VGND VPWR VGND sky130_ef_sc_hd__decap_12
XFILLER_0_28_54 VGND VGND VPWR VPWR sky130_fd_sc_hd__fill_2
XFILLER_0_0_169 VPWR VGND VPWR VGND sky130_ef_sc_hd__decap_12
XscaleAdd._325_ scaleAdd._028_ scaleAdd._030_ scaleAdd._031_ VGND VGND VPWR VPWR scaleAdd._032_
+ sky130_fd_sc_hd__and3_1
XscaleAdd._256_ scaleAdd._200_ VGND VGND VPWR VPWR accumulator.io_inMant\[1\] sky130_fd_sc_hd__buf_1
Xaccumulator._2240_ accumulator._0132_ accumulator._1121_ accumulator._0192_ VGND
+ VGND VPWR VPWR accumulator._0194_ sky130_fd_sc_hd__a21oi_2
Xaccumulator._2171_ accumulator._0126_ VGND VGND VPWR VPWR accumulator._0010_ sky130_fd_sc_hd__clkbuf_1
XFILLER_0_29_320 VPWR VGND VPWR VGND sky130_ef_sc_hd__decap_12
XFILLER_0_60_85 VGND VGND VPWR VPWR sky130_fd_sc_hd__decap_4
XFILLER_0_60_41 VGND VGND VPWR VPWR sky130_fd_sc_hd__fill_2
XFILLER_0_56_150 VGND VGND VPWR VPWR sky130_fd_sc_hd__decap_3
XFILLER_0_44_389 VGND VGND VPWR VPWR sky130_fd_sc_hd__decap_8
XFILLER_0_44_345 VPWR VGND VPWR VGND sky130_ef_sc_hd__decap_12
XFILLER_0_29_375 VGND VGND VPWR VPWR sky130_fd_sc_hd__fill_1
XFILLER_0_29_364 VGND VGND VPWR VPWR sky130_fd_sc_hd__fill_1
Xaccumulator._1955_ accumulator._1043_ accumulator._1049_ VGND VGND VPWR VPWR accumulator._1050_
+ sky130_fd_sc_hd__xnor2_2
Xaccumulator._1886_ accumulator._0918_ accumulator._0980_ VGND VGND VPWR VPWR accumulator._0981_
+ sky130_fd_sc_hd__nand2_1
XFILLER_0_8_53 VPWR VGND VPWR VGND sky130_ef_sc_hd__decap_12
XTAP_TAPCELL_ROW_63_590 VGND VPWR sky130_fd_sc_hd__tapvpwrvgnd_1
XFILLER_0_39_139 VPWR VGND VPWR VGND sky130_ef_sc_hd__decap_12
XFILLER_0_39_117 VGND VGND VPWR VPWR sky130_fd_sc_hd__fill_2
XFILLER_0_35_323 VPWR VGND VPWR VGND sky130_ef_sc_hd__decap_12
Xaccumulator._2369_ clknet_2_0__leaf_clock accumulator._0014_ VGND VGND VPWR VPWR
+ accumulator.io_accOut\[12\] sky130_fd_sc_hd__dfxtp_1
XFILLER_0_50_337 VPWR VGND VPWR VGND sky130_ef_sc_hd__decap_12
XFILLER_0_35_356 VGND VGND VPWR VPWR sky130_fd_sc_hd__decap_8
XFILLER_0_35_345 VGND VGND VPWR VPWR sky130_fd_sc_hd__decap_4
Xclone11 net78 accumulator.io_accOut\[30\] VGND VGND VPWR VPWR net69 sky130_fd_sc_hd__xnor2_4
XFILLER_0_38_183 VPWR VGND VPWR VGND sky130_ef_sc_hd__decap_12
XFILLER_0_38_161 VGND VGND VPWR VPWR sky130_fd_sc_hd__fill_1
XFILLER_0_26_389 VGND VGND VPWR VPWR sky130_fd_sc_hd__decap_4
XFILLER_0_41_359 VPWR VGND VPWR VGND sky130_ef_sc_hd__decap_12
XFILLER_0_41_337 VGND VGND VPWR VPWR sky130_fd_sc_hd__decap_6
XFILLER_0_39_31 VGND VGND VPWR VPWR sky130_fd_sc_hd__fill_1
Xaccumulator._1671_ accumulator._0584_ accumulator._0765_ VGND VGND VPWR VPWR accumulator._0766_
+ sky130_fd_sc_hd__nor2_1
Xaccumulator._1740_ accumulator._0719_ accumulator._0720_ accumulator._0834_ accumulator._0730_
+ VGND VGND VPWR VPWR accumulator._0835_ sky130_fd_sc_hd__o22a_1
XFILLER_0_55_85 VPWR VGND VPWR VGND sky130_ef_sc_hd__decap_12
XscaleAdd._308_ scaleAdd._011_ scaleAdd._182_ net13 VGND VGND VPWR VPWR scaleAdd._015_
+ sky130_fd_sc_hd__and3_1
XscaleAdd._239_ scaleAdd._185_ operator.io_outMant\[0\] VGND VGND VPWR VPWR scaleAdd._186_
+ sky130_fd_sc_hd__and2_1
Xaccumulator._2223_ accumulator._0162_ accumulator._0176_ accumulator._0080_ VGND
+ VGND VPWR VPWR accumulator._0177_ sky130_fd_sc_hd__mux2_2
Xaccumulator._2085_ accumulator._1065_ accumulator._1068_ accumulator._0039_ VGND
+ VGND VPWR VPWR accumulator._0040_ sky130_fd_sc_hd__or3_1
Xaccumulator._2154_ accumulator._1113_ accumulator._1111_ accumulator._0057_ VGND
+ VGND VPWR VPWR accumulator._0109_ sky130_fd_sc_hd__mux2_2
XFILLER_0_17_301 VGND VGND VPWR VPWR sky130_fd_sc_hd__decap_6
XFILLER_0_44_197 VGND VGND VPWR VPWR sky130_fd_sc_hd__decap_3
XFILLER_0_44_153 VPWR VGND VPWR VGND sky130_ef_sc_hd__decap_12
XFILLER_0_17_378 VGND VGND VPWR VPWR sky130_fd_sc_hd__fill_1
Xaccumulator._1938_ accumulator._1000_ accumulator._1032_ VGND VGND VPWR VPWR accumulator._1033_
+ sky130_fd_sc_hd__xnor2_1
Xaccumulator._1869_ accumulator._0809_ accumulator._0839_ VGND VGND VPWR VPWR accumulator._0964_
+ sky130_fd_sc_hd__nand2_1
XPHY_EDGE_ROW_13_Left_81 VGND VGND VPWR VPWR sky130_fd_sc_hd__decap_3
XFILLER_0_67_289 VGND VGND VPWR VPWR sky130_fd_sc_hd__fill_1
XFILLER_0_50_178 VGND VGND VPWR VPWR sky130_fd_sc_hd__decap_3
XFILLER_0_50_123 VGND VGND VPWR VPWR sky130_fd_sc_hd__fill_2
XFILLER_0_50_112 VGND VGND VPWR VPWR sky130_fd_sc_hd__decap_6
XFILLER_0_35_197 VGND VGND VPWR VPWR sky130_fd_sc_hd__fill_1
XFILLER_0_23_337 VGND VGND VPWR VPWR sky130_fd_sc_hd__fill_2
XFILLER_0_2_209 VGND VGND VPWR VPWR sky130_fd_sc_hd__decap_6
XTAP_TAPCELL_ROW_66_608 VGND VPWR sky130_fd_sc_hd__tapvpwrvgnd_1
XFILLER_0_25_11 VGND VGND VPWR VPWR sky130_fd_sc_hd__fill_1
XFILLER_0_58_245 VGND VGND VPWR VPWR sky130_fd_sc_hd__fill_2
XFILLER_0_58_223 VGND VGND VPWR VPWR sky130_fd_sc_hd__fill_1
XFILLER_0_25_88 VGND VGND VPWR VPWR sky130_fd_sc_hd__decap_8
XFILLER_0_18_109 VGND VGND VPWR VPWR sky130_fd_sc_hd__decap_4
XFILLER_0_41_167 VGND VGND VPWR VPWR sky130_fd_sc_hd__fill_1
XFILLER_0_41_43 VGND VGND VPWR VPWR sky130_fd_sc_hd__decap_4
XFILLER_0_26_197 VGND VGND VPWR VPWR sky130_fd_sc_hd__fill_1
XFILLER_0_14_359 VGND VGND VPWR VPWR sky130_fd_sc_hd__fill_2
Xaccumulator._1654_ accumulator._0696_ accumulator._0706_ accumulator._0746_ accumulator._0747_
+ accumulator._0748_ VGND VGND VPWR VPWR accumulator._0749_ sky130_fd_sc_hd__a311o_1
XFILLER_0_1_286 VGND VGND VPWR VPWR sky130_fd_sc_hd__decap_4
Xaccumulator._1723_ accumulator.io_accOut\[0\] accumulator._0653_ VGND VGND VPWR VPWR
+ accumulator._0818_ sky130_fd_sc_hd__nand2_1
XFILLER_0_49_212 VPWR VGND VPWR VGND sky130_ef_sc_hd__decap_12
Xaccumulator._2206_ net105 accumulator._0147_ accumulator._0381_ accumulator._0160_
+ VGND VGND VPWR VPWR accumulator._0014_ sky130_fd_sc_hd__o211a_1
Xaccumulator._1585_ accumulator._0678_ accumulator._0679_ VGND VGND VPWR VPWR accumulator._0680_
+ sky130_fd_sc_hd__nand2_1
Xaccumulator._2068_ accumulator._1163_ accumulator._1143_ accumulator._1025_ VGND
+ VGND VPWR VPWR accumulator._1164_ sky130_fd_sc_hd__a21o_1
XFILLER_0_64_215 VGND VGND VPWR VPWR sky130_fd_sc_hd__decap_6
Xaccumulator._2137_ accumulator._0972_ accumulator._1116_ VGND VGND VPWR VPWR accumulator._0092_
+ sky130_fd_sc_hd__xor2_1
XFILLER_0_17_131 VGND VGND VPWR VPWR sky130_fd_sc_hd__fill_1
XFILLER_0_17_164 VGND VGND VPWR VPWR sky130_fd_sc_hd__decap_4
XTAP_TAPCELL_ROW_20_287 VGND VPWR sky130_fd_sc_hd__tapvpwrvgnd_1
XTAP_TAPCELL_ROW_28_343 VGND VPWR sky130_fd_sc_hd__tapvpwrvgnd_1
XFILLER_0_63_281 VPWR VGND VPWR VGND sky130_ef_sc_hd__decap_12
XFILLER_0_11_57 VGND VGND VPWR VPWR sky130_fd_sc_hd__decap_4
XTAP_TAPCELL_ROW_11_221 VGND VPWR sky130_fd_sc_hd__tapvpwrvgnd_1
XFILLER_0_11_329 VGND VGND VPWR VPWR sky130_fd_sc_hd__decap_6
Xaccumulator._1370_ accumulator._0430_ accumulator._0433_ accumulator._0203_ VGND
+ VGND VPWR VPWR accumulator._0465_ sky130_fd_sc_hd__mux2_1
Xinput6 io_inB[1] VGND VGND VPWR VPWR net6 sky130_fd_sc_hd__buf_1
XFILLER_0_65_3 VPWR VGND VPWR VGND sky130_ef_sc_hd__decap_12
XFILLER_0_14_189 VGND VGND VPWR VPWR sky130_fd_sc_hd__decap_6
Xaccumulator._1706_ accumulator.io_accOut\[7\] accumulator._0379_ accumulator._0649_
+ VGND VGND VPWR VPWR accumulator._0801_ sky130_fd_sc_hd__and3_1
Xaccumulator._1568_ accumulator._0662_ VGND VGND VPWR VPWR accumulator._0663_ sky130_fd_sc_hd__inv_2
Xaccumulator._1637_ accumulator._0576_ accumulator._0610_ accumulator._0613_ accumulator._0637_
+ VGND VGND VPWR VPWR accumulator._0732_ sky130_fd_sc_hd__a211o_1
XTAP_TAPCELL_ROW_25_324 VGND VPWR sky130_fd_sc_hd__tapvpwrvgnd_1
Xoperator._26_ operator.io_outMant\[0\] operator._07_ operator._08_ VGND VGND VPWR
+ VPWR operator._09_ sky130_fd_sc_hd__and3b_1
Xaccumulator._1499_ accumulator._0590_ accumulator._0593_ accumulator._0551_ VGND
+ VGND VPWR VPWR accumulator._0594_ sky130_fd_sc_hd__a21o_1
XFILLER_0_45_281 VGND VGND VPWR VPWR sky130_fd_sc_hd__decap_8
XPHY_EDGE_ROW_14_Right_14 VGND VGND VPWR VPWR sky130_fd_sc_hd__decap_3
XFILLER_0_60_251 VGND VGND VPWR VPWR sky130_fd_sc_hd__fill_1
XPHY_EDGE_ROW_23_Right_23 VGND VGND VPWR VPWR sky130_fd_sc_hd__decap_3
XPHY_EDGE_ROW_38_Left_106 VGND VGND VPWR VPWR sky130_fd_sc_hd__decap_3
XPHY_EDGE_ROW_32_Right_32 VGND VGND VPWR VPWR sky130_fd_sc_hd__decap_3
XFILLER_0_28_259 VGND VGND VPWR VPWR sky130_fd_sc_hd__fill_1
XFILLER_0_51_262 VGND VGND VPWR VPWR sky130_fd_sc_hd__fill_1
XPHY_EDGE_ROW_47_Left_115 VGND VGND VPWR VPWR sky130_fd_sc_hd__decap_3
XFILLER_0_43_229 VGND VGND VPWR VPWR sky130_fd_sc_hd__fill_1
XFILLER_0_3_337 VGND VGND VPWR VPWR sky130_fd_sc_hd__decap_8
XPHY_EDGE_ROW_41_Right_41 VGND VGND VPWR VPWR sky130_fd_sc_hd__decap_3
XTAP_TAPCELL_ROW_39_416 VGND VPWR sky130_fd_sc_hd__tapvpwrvgnd_1
Xaccumulator._1422_ accumulator._0515_ accumulator._0516_ VGND VGND VPWR VPWR accumulator._0517_
+ sky130_fd_sc_hd__nor2_1
XscaleAdd._487_ net16 net19 scaleAdd._173_ scaleAdd._179_ VGND VGND VPWR VPWR scaleAdd._180_
+ sky130_fd_sc_hd__a31o_1
XFILLER_0_63_96 VPWR VGND VPWR VGND sky130_ef_sc_hd__decap_12
XFILLER_0_59_373 VPWR VGND VPWR VGND sky130_ef_sc_hd__decap_12
XPHY_EDGE_ROW_56_Left_124 VGND VGND VPWR VPWR sky130_fd_sc_hd__decap_3
XPHY_EDGE_ROW_50_Right_50 VGND VGND VPWR VPWR sky130_fd_sc_hd__decap_3
Xaccumulator._1284_ accumulator._0380_ VGND VGND VPWR VPWR accumulator._0381_ sky130_fd_sc_hd__buf_2
Xaccumulator._1353_ accumulator.io_inMant\[3\] accumulator.io_inMant\[4\] accumulator._0311_
+ VGND VGND VPWR VPWR accumulator._0448_ sky130_fd_sc_hd__mux2_1
XFILLER_0_2_77 VGND VGND VPWR VPWR sky130_fd_sc_hd__decap_6
XPHY_EDGE_ROW_65_Left_133 VGND VGND VPWR VPWR sky130_fd_sc_hd__decap_3
XFILLER_0_27_281 VPWR VGND VPWR VGND sky130_ef_sc_hd__decap_12
XFILLER_0_42_273 VPWR VGND VPWR VGND sky130_ef_sc_hd__decap_12
XFILLER_0_42_251 VGND VGND VPWR VPWR sky130_fd_sc_hd__fill_1
XFILLER_0_6_197 VPWR VGND VPWR VGND sky130_ef_sc_hd__decap_12
XscaleAdd._410_ scaleAdd._094_ scaleAdd._095_ scaleAdd._112_ VGND VGND VPWR VPWR scaleAdd._113_
+ sky130_fd_sc_hd__o21ba_1
XFILLER_0_0_307 VGND VGND VPWR VPWR sky130_fd_sc_hd__fill_1
XscaleAdd._341_ scaleAdd._045_ scaleAdd._046_ VGND VGND VPWR VPWR scaleAdd._047_ sky130_fd_sc_hd__nor2_1
XscaleAdd._272_ scaleAdd._198_ scaleAdd._201_ scaleAdd._197_ VGND VGND VPWR VPWR scaleAdd._215_
+ sky130_fd_sc_hd__a21bo_1
XFILLER_0_56_365 VPWR VGND VPWR VGND sky130_ef_sc_hd__decap_12
Xinput20 io_resetAcc VGND VGND VPWR VPWR net20 sky130_fd_sc_hd__buf_1
XTAP_TAPCELL_ROW_44_452 VGND VPWR sky130_fd_sc_hd__tapvpwrvgnd_1
XFILLER_0_33_44 VPWR VGND VPWR VGND sky130_ef_sc_hd__decap_12
Xaccumulator._1971_ accumulator._1022_ accumulator._1058_ VGND VGND VPWR VPWR accumulator._1066_
+ sky130_fd_sc_hd__nand2_1
XFILLER_0_3_167 VGND VGND VPWR VPWR sky130_fd_sc_hd__fill_1
XFILLER_0_58_85 VGND VGND VPWR VPWR sky130_fd_sc_hd__decap_6
Xaccumulator._2385_ clknet_2_3__leaf_clock accumulator._0030_ VGND VGND VPWR VPWR
+ accumulator.io_accOut\[28\] sky130_fd_sc_hd__dfxtp_1
XFILLER_0_28_3 VGND VGND VPWR VPWR sky130_fd_sc_hd__decap_8
Xaccumulator._1405_ accumulator._0420_ VGND VGND VPWR VPWR accumulator._0500_ sky130_fd_sc_hd__buf_4
XFILLER_0_66_118 VGND VGND VPWR VPWR sky130_fd_sc_hd__decap_8
XFILLER_0_47_365 VPWR VGND VPWR VGND sky130_ef_sc_hd__decap_12
Xaccumulator._1336_ accumulator._0203_ VGND VGND VPWR VPWR accumulator._0431_ sky130_fd_sc_hd__clkbuf_4
Xaccumulator._1198_ accumulator.io_inExp\[1\] accumulator._0203_ VGND VGND VPWR VPWR
+ accumulator._0212_ sky130_fd_sc_hd__or2_1
Xaccumulator._1267_ accumulator._0337_ accumulator._0338_ VGND VGND VPWR VPWR accumulator._0364_
+ sky130_fd_sc_hd__nor2_1
XFILLER_0_62_357 VGND VGND VPWR VPWR sky130_fd_sc_hd__decap_6
XTAP_TAPCELL_ROW_50_499 VGND VPWR sky130_fd_sc_hd__tapvpwrvgnd_1
XTAP_TAPCELL_ROW_58_555 VGND VPWR sky130_fd_sc_hd__tapvpwrvgnd_1
XFILLER_0_65_162 VGND VGND VPWR VPWR sky130_fd_sc_hd__fill_1
XTAP_TAPCELL_ROW_41_433 VGND VPWR sky130_fd_sc_hd__tapvpwrvgnd_1
XFILLER_0_38_376 VGND VGND VPWR VPWR sky130_fd_sc_hd__decap_4
XFILLER_0_0_137 VGND VGND VPWR VPWR sky130_fd_sc_hd__decap_3
XscaleAdd._324_ operator.io_outMant\[0\] scaleAdd._220_ scaleAdd._233_ scaleAdd._217_
+ VGND VGND VPWR VPWR scaleAdd._031_ sky130_fd_sc_hd__a31o_1
XscaleAdd._255_ scaleAdd._185_ operator.io_outMant\[1\] VGND VGND VPWR VPWR scaleAdd._200_
+ sky130_fd_sc_hd__and2_1
Xaccumulator._2170_ accumulator._0380_ accumulator._0124_ VGND VGND VPWR VPWR accumulator._0126_
+ sky130_fd_sc_hd__and2_1
XFILLER_0_29_332 VGND VGND VPWR VPWR sky130_fd_sc_hd__decap_4
Xaccumulator._1954_ accumulator._0947_ accumulator._1048_ VGND VGND VPWR VPWR accumulator._1049_
+ sky130_fd_sc_hd__nor2_1
XFILLER_0_44_357 VGND VGND VPWR VPWR sky130_fd_sc_hd__decap_6
XFILLER_0_8_65 VPWR VGND VPWR VGND sky130_ef_sc_hd__decap_12
Xaccumulator._1885_ accumulator._0651_ accumulator._0751_ accumulator._0758_ VGND
+ VGND VPWR VPWR accumulator._0980_ sky130_fd_sc_hd__a21oi_1
XPHY_EDGE_ROW_4_Right_4 VGND VGND VPWR VPWR sky130_fd_sc_hd__decap_3
Xaccumulator._2368_ clknet_2_1__leaf_clock accumulator._0013_ VGND VGND VPWR VPWR
+ accumulator.io_accOut\[11\] sky130_fd_sc_hd__dfxtp_1
Xaccumulator._2299_ accumulator._0244_ accumulator._0249_ VGND VGND VPWR VPWR accumulator._0250_
+ sky130_fd_sc_hd__xnor2_1
XFILLER_0_35_335 VGND VGND VPWR VPWR sky130_fd_sc_hd__fill_1
Xaccumulator._1319_ accumulator._0413_ VGND VGND VPWR VPWR accumulator._0414_ sky130_fd_sc_hd__buf_2
Xclone45 accumulator._1171_ VGND VGND VPWR VPWR net103 sky130_fd_sc_hd__clkbuf_16
XFILLER_0_50_349 VPWR VGND VPWR VGND sky130_ef_sc_hd__decap_12
XFILLER_0_43_390 VGND VGND VPWR VPWR sky130_fd_sc_hd__fill_2
XFILLER_0_35_368 VPWR VGND VPWR VGND sky130_ef_sc_hd__decap_12
XFILLER_0_7_281 VGND VGND VPWR VPWR sky130_fd_sc_hd__decap_8
XFILLER_0_38_195 VGND VGND VPWR VPWR sky130_fd_sc_hd__fill_1
Xaccumulator._1670_ accumulator._0761_ accumulator._0762_ VGND VGND VPWR VPWR accumulator._0765_
+ sky130_fd_sc_hd__or2_1
XscaleAdd._307_ scaleAdd._231_ scaleAdd._230_ scaleAdd._013_ VGND VGND VPWR VPWR scaleAdd._014_
+ sky130_fd_sc_hd__a21oi_1
Xaccumulator._2222_ accumulator._1017_ accumulator._1025_ accumulator._0047_ VGND
+ VGND VPWR VPWR accumulator._0176_ sky130_fd_sc_hd__mux2_2
XFILLER_0_55_97 VGND VGND VPWR VPWR sky130_fd_sc_hd__fill_1
XFILLER_0_55_42 VGND VGND VPWR VPWR sky130_fd_sc_hd__decap_6
XscaleAdd._238_ net9 VGND VGND VPWR VPWR scaleAdd._185_ sky130_fd_sc_hd__buf_2
Xaccumulator._2084_ accumulator._1143_ accumulator._1176_ accumulator._0038_ accumulator._1052_
+ accumulator._1050_ VGND VGND VPWR VPWR accumulator._0039_ sky130_fd_sc_hd__a311oi_1
Xaccumulator._2153_ accumulator._1115_ accumulator._1117_ accumulator._0057_ VGND
+ VGND VPWR VPWR accumulator._0108_ sky130_fd_sc_hd__mux2_2
Xaccumulator._1937_ accumulator._0947_ accumulator._0997_ VGND VGND VPWR VPWR accumulator._1032_
+ sky130_fd_sc_hd__nor2_1
XFILLER_0_44_165 VPWR VGND VPWR VGND sky130_ef_sc_hd__decap_12
XFILLER_0_4_251 VGND VGND VPWR VPWR sky130_fd_sc_hd__fill_1
XFILLER_0_4_240 VGND VGND VPWR VPWR sky130_fd_sc_hd__fill_2
XTAP_TAPCELL_ROW_9_206 VGND VPWR sky130_fd_sc_hd__tapvpwrvgnd_1
Xaccumulator._1868_ accumulator._0696_ accumulator._0962_ VGND VGND VPWR VPWR accumulator._0963_
+ sky130_fd_sc_hd__xnor2_1
Xaccumulator._1799_ accumulator._0787_ accumulator._0604_ accumulator._0874_ VGND
+ VGND VPWR VPWR accumulator._0894_ sky130_fd_sc_hd__o21a_1
XFILLER_0_35_154 VGND VGND VPWR VPWR sky130_fd_sc_hd__fill_1
XFILLER_0_35_143 VGND VGND VPWR VPWR sky130_fd_sc_hd__fill_1
XFILLER_0_31_360 VGND VGND VPWR VPWR sky130_fd_sc_hd__decap_4
XFILLER_0_16_390 VGND VGND VPWR VPWR sky130_fd_sc_hd__decap_8
XTAP_TAPCELL_ROW_66_609 VGND VPWR sky130_fd_sc_hd__tapvpwrvgnd_1
XFILLER_0_58_213 VGND VGND VPWR VPWR sky130_fd_sc_hd__fill_1
XFILLER_0_41_66 VGND VGND VPWR VPWR sky130_fd_sc_hd__decap_8
XTAP_TAPCELL_ROW_14_241 VGND VPWR sky130_fd_sc_hd__tapvpwrvgnd_1
XFILLER_0_41_113 VGND VGND VPWR VPWR sky130_fd_sc_hd__fill_2
XFILLER_0_41_88 VGND VGND VPWR VPWR sky130_fd_sc_hd__fill_2
XFILLER_0_22_360 VGND VGND VPWR VPWR sky130_fd_sc_hd__decap_4
XFILLER_0_66_85 VPWR VGND VPWR VGND sky130_ef_sc_hd__decap_12
XFILLER_0_66_41 VPWR VGND VPWR VGND sky130_ef_sc_hd__decap_12
Xaccumulator._1653_ accumulator._0681_ accumulator._0682_ VGND VGND VPWR VPWR accumulator._0748_
+ sky130_fd_sc_hd__nor2_1
XFILLER_0_5_55 VGND VGND VPWR VPWR sky130_fd_sc_hd__fill_1
XFILLER_0_1_298 VPWR VGND VPWR VGND sky130_ef_sc_hd__decap_12
Xaccumulator._1722_ accumulator._0551_ accumulator._0725_ accumulator._0726_ VGND
+ VGND VPWR VPWR accumulator._0817_ sky130_fd_sc_hd__o21a_1
Xaccumulator._1584_ accumulator._0536_ accumulator._0636_ VGND VGND VPWR VPWR accumulator._0679_
+ sky130_fd_sc_hd__nor2_1
Xaccumulator._2205_ accumulator._0157_ accumulator._0156_ accumulator._0034_ accumulator._0159_
+ VGND VGND VPWR VPWR accumulator._0160_ sky130_fd_sc_hd__a211o_1
XFILLER_0_10_3 VPWR VGND VPWR VGND sky130_ef_sc_hd__decap_12
Xaccumulator._2067_ accumulator._1161_ accumulator._1008_ accumulator._1162_ VGND
+ VGND VPWR VPWR accumulator._1163_ sky130_fd_sc_hd__o21ai_1
XFILLER_0_49_279 VGND VGND VPWR VPWR sky130_fd_sc_hd__fill_1
Xaccumulator._2136_ accumulator._0074_ accumulator._0091_ VGND VGND VPWR VPWR accumulator._0006_
+ sky130_fd_sc_hd__nor2_1
XFILLER_0_13_393 VGND VGND VPWR VPWR sky130_fd_sc_hd__decap_8
XTAP_TAPCELL_ROW_20_288 VGND VPWR sky130_fd_sc_hd__tapvpwrvgnd_1
XTAP_TAPCELL_ROW_28_344 VGND VPWR sky130_fd_sc_hd__tapvpwrvgnd_1
XFILLER_0_63_293 VPWR VGND VPWR VGND sky130_ef_sc_hd__decap_12
XFILLER_0_63_260 VPWR VGND VPWR VGND sky130_ef_sc_hd__decap_12
XTAP_TAPCELL_ROW_11_222 VGND VPWR sky130_fd_sc_hd__tapvpwrvgnd_1
XFILLER_0_31_190 VGND VGND VPWR VPWR sky130_fd_sc_hd__fill_1
XFILLER_0_36_44 VGND VGND VPWR VPWR sky130_fd_sc_hd__decap_6
Xinput7 io_inB[2] VGND VGND VPWR VPWR net7 sky130_fd_sc_hd__buf_1
XFILLER_0_52_98 VGND VGND VPWR VPWR sky130_fd_sc_hd__decap_4
XFILLER_0_6_335 VGND VGND VPWR VPWR sky130_fd_sc_hd__fill_2
XFILLER_0_58_3 VPWR VGND VPWR VGND sky130_ef_sc_hd__decap_12
Xaccumulator._1705_ accumulator._0758_ accumulator._0651_ VGND VGND VPWR VPWR accumulator._0800_
+ sky130_fd_sc_hd__and2b_1
XFILLER_0_10_352 VGND VGND VPWR VPWR sky130_fd_sc_hd__fill_1
Xaccumulator._1636_ accumulator._0722_ accumulator._0729_ accumulator._0730_ VGND
+ VGND VPWR VPWR accumulator._0731_ sky130_fd_sc_hd__and3_1
Xaccumulator._1567_ accumulator._0539_ accumulator._0421_ accumulator._0525_ VGND
+ VGND VPWR VPWR accumulator._0662_ sky130_fd_sc_hd__and3_1
Xaccumulator._2119_ accumulator._0073_ VGND VGND VPWR VPWR accumulator._0074_ sky130_fd_sc_hd__clkbuf_4
XFILLER_0_37_249 VGND VGND VPWR VPWR sky130_fd_sc_hd__decap_8
Xoperator._25_ net2 net3 VGND VGND VPWR VPWR operator._08_ sky130_fd_sc_hd__or2_1
Xaccumulator._1498_ accumulator._0426_ accumulator._0592_ accumulator._0457_ VGND
+ VGND VPWR VPWR accumulator._0593_ sky130_fd_sc_hd__a21o_1
XTAP_TAPCELL_ROW_33_380 VGND VPWR sky130_fd_sc_hd__tapvpwrvgnd_1
XFILLER_0_9_195 VGND VGND VPWR VPWR sky130_fd_sc_hd__decap_4
XFILLER_0_36_293 VGND VGND VPWR VPWR sky130_fd_sc_hd__fill_1
XscaleAdd._486_ scaleAdd._175_ VGND VGND VPWR VPWR scaleAdd._179_ sky130_fd_sc_hd__inv_2
XFILLER_0_47_32 VGND VGND VPWR VPWR sky130_fd_sc_hd__fill_1
XTAP_TAPCELL_ROW_39_417 VGND VPWR sky130_fd_sc_hd__tapvpwrvgnd_1
Xaccumulator._1421_ accumulator.io_accOut\[30\] accumulator.io_accOut\[29\] accumulator.io_accOut\[28\]
+ accumulator.io_accOut\[27\] VGND VGND VPWR VPWR accumulator._0516_ sky130_fd_sc_hd__or4_1
XFILLER_0_59_385 VGND VGND VPWR VPWR sky130_fd_sc_hd__decap_6
Xaccumulator._1283_ net20 net22 VGND VGND VPWR VPWR accumulator._0380_ sky130_fd_sc_hd__nor2_1
XTAP_TAPCELL_ROW_47_472 VGND VPWR sky130_fd_sc_hd__tapvpwrvgnd_1
Xaccumulator._1352_ accumulator._0431_ accumulator._0444_ accumulator._0446_ VGND
+ VGND VPWR VPWR accumulator._0447_ sky130_fd_sc_hd__a21o_1
XFILLER_0_27_293 VGND VGND VPWR VPWR sky130_fd_sc_hd__decap_6
XFILLER_0_42_285 VGND VGND VPWR VPWR sky130_fd_sc_hd__decap_8
Xaccumulator._1619_ accumulator._0576_ accumulator._0652_ accumulator._0656_ accumulator._0513_
+ VGND VGND VPWR VPWR accumulator._0714_ sky130_fd_sc_hd__a31o_1
XFILLER_0_18_260 VGND VGND VPWR VPWR sky130_fd_sc_hd__decap_8
XscaleAdd._340_ net11 scaleAdd._011_ scaleAdd._044_ VGND VGND VPWR VPWR scaleAdd._046_
+ sky130_fd_sc_hd__and3_1
XscaleAdd._271_ scaleAdd._212_ scaleAdd._213_ VGND VGND VPWR VPWR scaleAdd._214_ sky130_fd_sc_hd__nor2_1
XTAP_TAPCELL_ROW_44_453 VGND VPWR sky130_fd_sc_hd__tapvpwrvgnd_1
XFILLER_0_17_57 VPWR VGND VPWR VGND sky130_ef_sc_hd__decap_12
Xinput21 io_start VGND VGND VPWR VPWR net21 sky130_fd_sc_hd__clkbuf_1
XFILLER_0_56_377 VPWR VGND VPWR VGND sky130_ef_sc_hd__decap_12
Xaccumulator._1970_ accumulator._1057_ accumulator._1064_ VGND VGND VPWR VPWR accumulator._1065_
+ sky130_fd_sc_hd__xnor2_4
XFILLER_0_3_113 VPWR VGND VPWR VGND sky130_ef_sc_hd__decap_12
Xinput10 io_inScaleA[1] VGND VGND VPWR VPWR net10 sky130_fd_sc_hd__buf_8
XscaleAdd._469_ net16 net19 VGND VGND VPWR VPWR scaleAdd._164_ sky130_fd_sc_hd__nand2_1
Xaccumulator._2384_ clknet_2_2__leaf_clock accumulator._0029_ VGND VGND VPWR VPWR
+ accumulator.io_accOut\[27\] sky130_fd_sc_hd__dfxtp_1
Xaccumulator._1335_ accumulator.io_inMant\[2\] accumulator.io_inMant\[3\] accumulator._0311_
+ VGND VGND VPWR VPWR accumulator._0430_ sky130_fd_sc_hd__mux2_1
Xaccumulator._1404_ accumulator._0490_ accumulator._0497_ accumulator._0498_ VGND
+ VGND VPWR VPWR accumulator._0499_ sky130_fd_sc_hd__a21o_1
XFILLER_0_47_377 VPWR VGND VPWR VGND sky130_ef_sc_hd__decap_12
Xaccumulator._1266_ accumulator._0361_ accumulator._0342_ accumulator._0362_ VGND
+ VGND VPWR VPWR accumulator._0363_ sky130_fd_sc_hd__a21o_1
Xaccumulator._1197_ accumulator._0193_ VGND VGND VPWR VPWR accumulator._0203_ sky130_fd_sc_hd__buf_2
XFILLER_0_57_119 VPWR VGND VPWR VGND sky130_ef_sc_hd__decap_12
XTAP_TAPCELL_ROW_41_434 VGND VPWR sky130_fd_sc_hd__tapvpwrvgnd_1
XFILLER_0_61_391 VGND VGND VPWR VPWR sky130_fd_sc_hd__fill_1
XFILLER_0_21_299 VPWR VGND VPWR VGND sky130_ef_sc_hd__decap_12
XFILLER_0_0_149 VGND VGND VPWR VPWR sky130_fd_sc_hd__fill_1
XscaleAdd._323_ scaleAdd._029_ scaleAdd._027_ scaleAdd._022_ VGND VGND VPWR VPWR scaleAdd._030_
+ sky130_fd_sc_hd__nand3_1
XFILLER_0_28_67 VGND VGND VPWR VPWR sky130_fd_sc_hd__decap_3
XscaleAdd._254_ scaleAdd._197_ scaleAdd._198_ VGND VGND VPWR VPWR scaleAdd._199_ sky130_fd_sc_hd__nand2_1
XFILLER_0_48_108 VPWR VGND VPWR VGND sky130_ef_sc_hd__decap_12
XFILLER_0_44_99 VPWR VGND VPWR VGND sky130_ef_sc_hd__decap_12
XFILLER_0_44_77 VGND VGND VPWR VPWR sky130_fd_sc_hd__decap_6
Xaccumulator._1953_ accumulator._1044_ accumulator._1047_ VGND VGND VPWR VPWR accumulator._1048_
+ sky130_fd_sc_hd__and2b_1
XFILLER_0_60_65 VGND VGND VPWR VPWR sky130_fd_sc_hd__decap_8
Xaccumulator._1884_ accumulator._0973_ accumulator._0974_ accumulator._0800_ VGND
+ VGND VPWR VPWR accumulator._0979_ sky130_fd_sc_hd__o21ba_1
XFILLER_0_29_399 VGND VGND VPWR VPWR sky130_fd_sc_hd__fill_2
XFILLER_0_8_77 VGND VGND VPWR VPWR sky130_fd_sc_hd__decap_6
XFILLER_0_40_3 VGND VGND VPWR VPWR sky130_fd_sc_hd__fill_1
Xaccumulator._2298_ accumulator._0248_ accumulator._0239_ VGND VGND VPWR VPWR accumulator._0249_
+ sky130_fd_sc_hd__xor2_1
Xaccumulator._2367_ clknet_2_3__leaf_clock accumulator._0012_ VGND VGND VPWR VPWR
+ accumulator.io_accOut\[10\] sky130_fd_sc_hd__dfxtp_1
Xaccumulator._1318_ net74 accumulator._0400_ VGND VGND VPWR VPWR accumulator._0413_
+ sky130_fd_sc_hd__and2_1
Xclone46 accumulator._1126_ VGND VGND VPWR VPWR net104 sky130_fd_sc_hd__clkbuf_16
XFILLER_0_50_306 VGND VGND VPWR VPWR sky130_fd_sc_hd__fill_2
Xaccumulator._1249_ accumulator._0321_ accumulator._0345_ accumulator._0340_ VGND
+ VGND VPWR VPWR accumulator._0346_ sky130_fd_sc_hd__a21o_4
XFILLER_0_62_177 VGND VGND VPWR VPWR sky130_fd_sc_hd__decap_3
XTAP_TAPCELL_ROW_3_170 VGND VPWR sky130_fd_sc_hd__tapvpwrvgnd_1
XFILLER_0_38_141 VGND VGND VPWR VPWR sky130_fd_sc_hd__fill_2
XFILLER_0_53_199 VGND VGND VPWR VPWR sky130_fd_sc_hd__decap_6
XFILLER_0_41_328 VGND VGND VPWR VPWR sky130_fd_sc_hd__fill_1
XFILLER_0_39_44 VPWR VGND VPWR VGND sky130_ef_sc_hd__decap_12
XscaleAdd._306_ scaleAdd._009_ scaleAdd._012_ VGND VGND VPWR VPWR scaleAdd._013_ sky130_fd_sc_hd__nor2_1
Xaccumulator._2152_ accumulator._1128_ VGND VGND VPWR VPWR accumulator._0107_ sky130_fd_sc_hd__buf_2
XTAP_TAPCELL_ROW_52_507 VGND VPWR sky130_fd_sc_hd__tapvpwrvgnd_1
Xaccumulator._2221_ accumulator._0168_ accumulator._0173_ accumulator._0175_ VGND
+ VGND VPWR VPWR accumulator._0016_ sky130_fd_sc_hd__a21oi_1
XscaleAdd._237_ scaleAdd._182_ scaleAdd._183_ VGND VGND VPWR VPWR scaleAdd._184_ sky130_fd_sc_hd__nor2_1
Xaccumulator._2083_ accumulator._1036_ accumulator._0037_ accumulator._1009_ VGND
+ VGND VPWR VPWR accumulator._0038_ sky130_fd_sc_hd__a21o_1
XFILLER_0_44_111 VGND VGND VPWR VPWR sky130_fd_sc_hd__decap_3
Xaccumulator._1936_ accumulator._1028_ accumulator._1030_ VGND VGND VPWR VPWR accumulator._1031_
+ sky130_fd_sc_hd__nor2_1
XFILLER_0_44_177 VGND VGND VPWR VPWR sky130_fd_sc_hd__fill_1
Xaccumulator._1867_ accumulator._0960_ accumulator._0961_ VGND VGND VPWR VPWR accumulator._0962_
+ sky130_fd_sc_hd__nand2_1
XTAP_TAPCELL_ROW_9_207 VGND VPWR sky130_fd_sc_hd__tapvpwrvgnd_1
Xaccumulator._1798_ accumulator._0868_ accumulator._0857_ accumulator._0872_ accumulator._0882_
+ accumulator._0892_ VGND VGND VPWR VPWR accumulator._0893_ sky130_fd_sc_hd__a311o_1
XTAP_TAPCELL_ROW_0_140 VGND VPWR sky130_fd_sc_hd__tapvpwrvgnd_1
Xclkbuf_2_1__f_clock clknet_0_clock VGND VGND VPWR VPWR clknet_2_1__leaf_clock sky130_fd_sc_hd__clkbuf_16
XTAP_TAPCELL_ROW_14_242 VGND VPWR sky130_fd_sc_hd__tapvpwrvgnd_1
XFILLER_0_41_169 VPWR VGND VPWR VGND sky130_ef_sc_hd__decap_12
XFILLER_0_1_233 VGND VGND VPWR VPWR sky130_fd_sc_hd__decap_8
XFILLER_0_1_266 VGND VGND VPWR VPWR sky130_fd_sc_hd__fill_1
Xaccumulator._1721_ accumulator._0812_ accumulator._0410_ accumulator._0814_ accumulator._0527_
+ accumulator._0815_ VGND VGND VPWR VPWR accumulator._0816_ sky130_fd_sc_hd__a32o_2
XFILLER_0_66_53 VPWR VGND VPWR VGND sky130_ef_sc_hd__decap_12
Xaccumulator._1652_ accumulator._0694_ accumulator._0695_ VGND VGND VPWR VPWR accumulator._0747_
+ sky130_fd_sc_hd__nor2_1
Xaccumulator._1583_ accumulator._0554_ accumulator._0677_ VGND VGND VPWR VPWR accumulator._0678_
+ sky130_fd_sc_hd__nor2_1
Xaccumulator._2204_ accumulator._0158_ accumulator._0107_ accumulator._0048_ VGND
+ VGND VPWR VPWR accumulator._0159_ sky130_fd_sc_hd__and3b_1
XFILLER_0_49_225 VGND VGND VPWR VPWR sky130_fd_sc_hd__decap_8
Xaccumulator._2135_ accumulator._0804_ accumulator._0384_ accumulator._1094_ accumulator._0090_
+ VGND VGND VPWR VPWR accumulator._0091_ sky130_fd_sc_hd__o22a_1
XFILLER_0_9_322 VPWR VGND VPWR VGND sky130_ef_sc_hd__decap_12
Xaccumulator._2066_ accumulator._1006_ VGND VGND VPWR VPWR accumulator._1162_ sky130_fd_sc_hd__inv_2
XFILLER_0_64_228 VGND VGND VPWR VPWR sky130_fd_sc_hd__fill_1
XFILLER_0_17_155 VGND VGND VPWR VPWR sky130_fd_sc_hd__decap_3
XFILLER_0_17_177 VPWR VGND VPWR VGND sky130_ef_sc_hd__decap_12
XTAP_TAPCELL_ROW_20_289 VGND VPWR sky130_fd_sc_hd__tapvpwrvgnd_1
XFILLER_0_40_180 VGND VGND VPWR VPWR sky130_fd_sc_hd__decap_8
Xaccumulator._1919_ accumulator._1013_ accumulator._0785_ accumulator._0930_ VGND
+ VGND VPWR VPWR accumulator._1014_ sky130_fd_sc_hd__o21bai_1
XFILLER_0_20_309 VPWR VGND VPWR VGND sky130_ef_sc_hd__decap_12
XTAP_TAPCELL_ROW_28_345 VGND VPWR sky130_fd_sc_hd__tapvpwrvgnd_1
XFILLER_0_48_291 VGND VGND VPWR VPWR sky130_fd_sc_hd__decap_8
XFILLER_0_11_15 VPWR VGND VPWR VGND sky130_ef_sc_hd__decap_12
XFILLER_0_63_272 VGND VGND VPWR VPWR sky130_fd_sc_hd__decap_8
XFILLER_0_23_169 VGND VGND VPWR VPWR sky130_fd_sc_hd__decap_4
XTAP_TAPCELL_ROW_11_223 VGND VPWR sky130_fd_sc_hd__tapvpwrvgnd_1
XFILLER_0_36_23 VGND VGND VPWR VPWR sky130_fd_sc_hd__decap_4
Xinput8 io_inB[3] VGND VGND VPWR VPWR net8 sky130_fd_sc_hd__buf_1
Xaccumulator._1704_ accumulator._0796_ accumulator._0797_ accumulator._0798_ VGND
+ VGND VPWR VPWR accumulator._0799_ sky130_fd_sc_hd__o21ba_1
XFILLER_0_10_320 VGND VGND VPWR VPWR sky130_fd_sc_hd__fill_1
Xaccumulator._1497_ accumulator.io_accOut\[9\] accumulator._0591_ net59 VGND VGND
+ VPWR VPWR accumulator._0592_ sky130_fd_sc_hd__mux2_4
Xaccumulator._1635_ accumulator.io_accOut\[1\] accumulator._0378_ VGND VGND VPWR VPWR
+ accumulator._0730_ sky130_fd_sc_hd__nand2_1
Xoperator._24_ net7 net6 VGND VGND VPWR VPWR operator._07_ sky130_fd_sc_hd__or2_1
Xaccumulator._1566_ accumulator._0489_ accumulator._0512_ VGND VGND VPWR VPWR accumulator._0661_
+ sky130_fd_sc_hd__nand2_1
Xaccumulator._2049_ accumulator._1035_ VGND VGND VPWR VPWR accumulator._1144_ sky130_fd_sc_hd__inv_2
Xaccumulator._2118_ net20 net22 VGND VGND VPWR VPWR accumulator._0073_ sky130_fd_sc_hd__or2_1
XFILLER_0_60_253 VGND VGND VPWR VPWR sky130_fd_sc_hd__decap_8
XFILLER_0_36_261 VPWR VGND VPWR VGND sky130_ef_sc_hd__decap_12
XFILLER_0_22_47 VGND VGND VPWR VPWR sky130_fd_sc_hd__decap_8
XscaleAdd._485_ scaleAdd._177_ scaleAdd._178_ VGND VGND VPWR VPWR accumulator.io_inExp\[3\]
+ sky130_fd_sc_hd__xnor2_1
XFILLER_0_47_99 VGND VGND VPWR VPWR sky130_fd_sc_hd__decap_3
XFILLER_0_47_55 VGND VGND VPWR VPWR sky130_fd_sc_hd__fill_1
XTAP_TAPCELL_ROW_39_418 VGND VPWR sky130_fd_sc_hd__tapvpwrvgnd_1
Xaccumulator._1420_ accumulator.io_accOut\[26\] accumulator.io_accOut\[25\] accumulator.io_accOut\[24\]
+ accumulator.io_accOut\[23\] VGND VGND VPWR VPWR accumulator._0515_ sky130_fd_sc_hd__or4_1
Xaccumulator._1351_ accumulator.io_inMant\[0\] accumulator._0428_ accumulator._0445_
+ VGND VGND VPWR VPWR accumulator._0446_ sky130_fd_sc_hd__and3_1
XTAP_TAPCELL_ROW_47_473 VGND VPWR sky130_fd_sc_hd__tapvpwrvgnd_1
Xaccumulator._1282_ accumulator._0378_ VGND VGND VPWR VPWR accumulator._0379_ sky130_fd_sc_hd__buf_2
XFILLER_0_19_228 VGND VGND VPWR VPWR sky130_fd_sc_hd__decap_4
XFILLER_0_27_261 VGND VGND VPWR VPWR sky130_fd_sc_hd__decap_4
Xaccumulator._1618_ accumulator._0710_ accumulator._0712_ accumulator._0421_ VGND
+ VGND VPWR VPWR accumulator._0713_ sky130_fd_sc_hd__mux2_1
XFILLER_0_10_161 VGND VGND VPWR VPWR sky130_fd_sc_hd__fill_2
Xaccumulator._1549_ accumulator._0638_ accumulator._0643_ accumulator._0536_ VGND
+ VGND VPWR VPWR accumulator._0644_ sky130_fd_sc_hd__a21o_1
XFILLER_0_0_309 VGND VGND VPWR VPWR sky130_fd_sc_hd__fill_2
XscaleAdd._270_ operator.io_outMant\[1\] scaleAdd._195_ scaleAdd._211_ VGND VGND VPWR
+ VPWR scaleAdd._213_ sky130_fd_sc_hd__a21oi_1
XFILLER_0_17_69 VGND VGND VPWR VPWR sky130_fd_sc_hd__decap_8
XFILLER_0_56_345 VPWR VGND VPWR VGND sky130_ef_sc_hd__decap_12
XTAP_TAPCELL_ROW_44_454 VGND VPWR sky130_fd_sc_hd__tapvpwrvgnd_1
XFILLER_0_33_57 VGND VGND VPWR VPWR sky130_fd_sc_hd__decap_8
XFILLER_0_56_389 VGND VGND VPWR VPWR sky130_fd_sc_hd__decap_8
Xinput22 reset VGND VGND VPWR VPWR net22 sky130_fd_sc_hd__buf_1
XFILLER_0_24_253 VGND VGND VPWR VPWR sky130_fd_sc_hd__decap_4
XFILLER_0_3_169 VPWR VGND VPWR VGND sky130_ef_sc_hd__decap_12
XFILLER_0_3_125 VPWR VGND VPWR VGND sky130_ef_sc_hd__decap_12
Xinput11 io_inScaleA[2] VGND VGND VPWR VPWR net11 sky130_fd_sc_hd__buf_6
XFILLER_0_58_76 VGND VGND VPWR VPWR sky130_fd_sc_hd__decap_8
XscaleAdd._399_ scaleAdd._088_ scaleAdd._086_ scaleAdd._085_ VGND VGND VPWR VPWR scaleAdd._103_
+ sky130_fd_sc_hd__a21o_1
XscaleAdd._468_ scaleAdd._163_ VGND VGND VPWR VPWR accumulator.io_inExp\[1\] sky130_fd_sc_hd__clkbuf_1
Xaccumulator._2383_ clknet_2_3__leaf_clock accumulator._0028_ VGND VGND VPWR VPWR
+ accumulator.io_accOut\[26\] sky130_fd_sc_hd__dfxtp_1
Xaccumulator._1265_ accumulator.io_accOut\[27\] accumulator._0341_ VGND VGND VPWR
+ VPWR accumulator._0362_ sky130_fd_sc_hd__and2_1
Xaccumulator._1334_ accumulator.io_inMant\[0\] accumulator.io_inMant\[1\] accumulator._0428_
+ VGND VGND VPWR VPWR accumulator._0429_ sky130_fd_sc_hd__mux2_1
Xaccumulator._1403_ accumulator._0418_ VGND VGND VPWR VPWR accumulator._0498_ sky130_fd_sc_hd__buf_2
XFILLER_0_47_389 VGND VGND VPWR VPWR sky130_fd_sc_hd__decap_3
XFILLER_0_47_301 VGND VGND VPWR VPWR sky130_fd_sc_hd__fill_1
Xaccumulator._1196_ accumulator.io_inMant\[15\] accumulator.io_inMant\[14\] accumulator._0183_
+ VGND VGND VPWR VPWR accumulator._0193_ sky130_fd_sc_hd__or3_1
XFILLER_0_57_109 VGND VGND VPWR VPWR sky130_fd_sc_hd__decap_3
XFILLER_0_53_337 VPWR VGND VPWR VGND sky130_ef_sc_hd__decap_12
XFILLER_0_53_326 VGND VGND VPWR VPWR sky130_fd_sc_hd__decap_8
XTAP_TAPCELL_ROW_41_435 VGND VPWR sky130_fd_sc_hd__tapvpwrvgnd_1
XFILLER_0_21_201 VGND VGND VPWR VPWR sky130_fd_sc_hd__decap_3
XFILLER_0_28_46 VGND VGND VPWR VPWR sky130_fd_sc_hd__decap_3
XFILLER_0_21_289 VGND VGND VPWR VPWR sky130_fd_sc_hd__fill_1
XFILLER_0_21_245 VGND VGND VPWR VPWR sky130_fd_sc_hd__fill_1
XFILLER_0_21_234 VGND VGND VPWR VPWR sky130_fd_sc_hd__decap_4
XFILLER_0_21_223 VGND VGND VPWR VPWR sky130_fd_sc_hd__fill_1
XscaleAdd._322_ operator.io_outMant\[0\] VGND VGND VPWR VPWR scaleAdd._029_ sky130_fd_sc_hd__buf_2
XscaleAdd._253_ scaleAdd._187_ scaleAdd._196_ VGND VGND VPWR VPWR scaleAdd._198_ sky130_fd_sc_hd__or2_1
XTAP_TAPCELL_ROW_6_190 VGND VPWR sky130_fd_sc_hd__tapvpwrvgnd_1
XFILLER_0_56_197 VGND VGND VPWR VPWR sky130_fd_sc_hd__fill_1
XFILLER_0_29_301 VGND VGND VPWR VPWR sky130_fd_sc_hd__decap_8
Xaccumulator._1883_ accumulator._0972_ accumulator._0968_ accumulator._0977_ VGND
+ VGND VPWR VPWR accumulator._0978_ sky130_fd_sc_hd__nor3b_4
Xaccumulator._1952_ accumulator._0875_ accumulator._1046_ VGND VGND VPWR VPWR accumulator._1047_
+ sky130_fd_sc_hd__xnor2_2
XFILLER_0_12_212 VGND VGND VPWR VPWR sky130_fd_sc_hd__fill_1
XFILLER_0_33_3 VPWR VGND VPWR VGND sky130_ef_sc_hd__decap_12
Xaccumulator._2297_ accumulator._0247_ accumulator._1127_ VGND VGND VPWR VPWR accumulator._0248_
+ sky130_fd_sc_hd__xor2_2
Xaccumulator._2366_ clknet_2_1__leaf_clock accumulator._0011_ VGND VGND VPWR VPWR
+ accumulator.io_accOut\[9\] sky130_fd_sc_hd__dfxtp_1
Xaccumulator._1248_ accumulator._0318_ accumulator._0320_ accumulator._0343_ accumulator._0344_
+ VGND VGND VPWR VPWR accumulator._0345_ sky130_fd_sc_hd__o211ai_1
Xaccumulator._1317_ accumulator._0398_ accumulator._0411_ VGND VGND VPWR VPWR accumulator._0412_
+ sky130_fd_sc_hd__xor2_4
XFILLER_0_62_189 VGND VGND VPWR VPWR sky130_fd_sc_hd__decap_6
Xaccumulator._1179_ accumulator.state\[1\] accumulator.state\[0\] VGND VGND VPWR VPWR
+ accumulator._1166_ sky130_fd_sc_hd__nand2b_2
XFILLER_0_47_197 VGND VGND VPWR VPWR sky130_fd_sc_hd__fill_2
XFILLER_0_35_337 VGND VGND VPWR VPWR sky130_fd_sc_hd__decap_4
XFILLER_0_38_197 VPWR VGND VPWR VGND sky130_ef_sc_hd__decap_12
XFILLER_0_26_315 VGND VGND VPWR VPWR sky130_fd_sc_hd__fill_1
XFILLER_0_14_15 VPWR VGND VPWR VGND sky130_ef_sc_hd__decap_12
XFILLER_0_14_37 VGND VGND VPWR VPWR sky130_fd_sc_hd__fill_2
XFILLER_0_30_25 VGND VGND VPWR VPWR sky130_fd_sc_hd__decap_3
XscaleAdd._305_ net11 net13 scaleAdd._011_ net10 VGND VGND VPWR VPWR scaleAdd._012_
+ sky130_fd_sc_hd__a22oi_2
XscaleAdd._236_ net10 net11 VGND VGND VPWR VPWR scaleAdd._183_ sky130_fd_sc_hd__nor2_1
Xaccumulator._2082_ accumulator._1123_ accumulator._0036_ accumulator._1031_ VGND
+ VGND VPWR VPWR accumulator._0037_ sky130_fd_sc_hd__a21bo_1
XFILLER_0_55_77 VGND VGND VPWR VPWR sky130_fd_sc_hd__decap_3
XFILLER_0_55_55 VGND VGND VPWR VPWR sky130_fd_sc_hd__fill_1
XTAP_TAPCELL_ROW_52_508 VGND VPWR sky130_fd_sc_hd__tapvpwrvgnd_1
Xaccumulator._2220_ net110 accumulator._0384_ accumulator._0381_ VGND VGND VPWR VPWR
+ accumulator._0175_ sky130_fd_sc_hd__o21ai_1
Xaccumulator._2151_ accumulator._0074_ accumulator._0106_ VGND VGND VPWR VPWR accumulator._0008_
+ sky130_fd_sc_hd__nor2_1
XTAP_TAPCELL_ROW_17_262 VGND VPWR sky130_fd_sc_hd__tapvpwrvgnd_1
XTAP_TAPCELL_ROW_60_563 VGND VPWR sky130_fd_sc_hd__tapvpwrvgnd_1
XFILLER_0_32_307 VGND VGND VPWR VPWR sky130_fd_sc_hd__fill_1
XFILLER_0_17_337 VGND VGND VPWR VPWR sky130_fd_sc_hd__decap_4
Xaccumulator._1935_ accumulator._0992_ accumulator._1029_ VGND VGND VPWR VPWR accumulator._1030_
+ sky130_fd_sc_hd__xor2_2
Xaccumulator._1797_ accumulator._0886_ accumulator._0891_ VGND VGND VPWR VPWR accumulator._0892_
+ sky130_fd_sc_hd__or2_1
Xaccumulator._1866_ accumulator._0917_ accumulator._0808_ accumulator._0837_ accumulator._0956_
+ VGND VGND VPWR VPWR accumulator._0961_ sky130_fd_sc_hd__o22a_1
XTAP_TAPCELL_ROW_9_208 VGND VPWR sky130_fd_sc_hd__tapvpwrvgnd_1
Xaccumulator._2349_ accumulator._0295_ accumulator._0296_ accumulator._0299_ VGND
+ VGND VPWR VPWR accumulator._0300_ sky130_fd_sc_hd__and3_1
XFILLER_0_35_101 VGND VGND VPWR VPWR sky130_fd_sc_hd__decap_8
XTAP_TAPCELL_ROW_0_141 VGND VPWR sky130_fd_sc_hd__tapvpwrvgnd_1
XFILLER_0_35_178 VPWR VGND VPWR VGND sky130_ef_sc_hd__decap_12
XFILLER_0_35_167 VGND VGND VPWR VPWR sky130_fd_sc_hd__fill_1
XFILLER_0_31_384 VGND VGND VPWR VPWR sky130_fd_sc_hd__decap_8
XFILLER_0_25_36 VPWR VGND VPWR VGND sky130_ef_sc_hd__decap_12
XFILLER_0_26_189 VGND VGND VPWR VPWR sky130_fd_sc_hd__fill_1
XTAP_TAPCELL_ROW_14_243 VGND VPWR sky130_fd_sc_hd__tapvpwrvgnd_1
XFILLER_0_14_307 VGND VGND VPWR VPWR sky130_fd_sc_hd__fill_1
XFILLER_0_41_126 VGND VGND VPWR VPWR sky130_fd_sc_hd__fill_1
Xaccumulator._1651_ accumulator._0721_ accumulator._0743_ accumulator._0744_ accumulator._0745_
+ VGND VGND VPWR VPWR accumulator._0746_ sky130_fd_sc_hd__a211o_1
XFILLER_0_22_340 VGND VGND VPWR VPWR sky130_fd_sc_hd__decap_6
Xaccumulator._1720_ accumulator._0636_ VGND VGND VPWR VPWR accumulator._0815_ sky130_fd_sc_hd__inv_2
XFILLER_0_66_65 VPWR VGND VPWR VGND sky130_ef_sc_hd__decap_12
XTAP_TAPCELL_ROW_65_600 VGND VPWR sky130_fd_sc_hd__tapvpwrvgnd_1
XFILLER_0_5_57 VPWR VGND VPWR VGND sky130_ef_sc_hd__decap_12
Xaccumulator._1582_ accumulator._0551_ accumulator._0567_ accumulator._0568_ accumulator._0602_
+ VGND VGND VPWR VPWR accumulator._0677_ sky130_fd_sc_hd__o31a_1
Xaccumulator._2065_ accumulator._1160_ accumulator._1144_ accumulator._1033_ VGND
+ VGND VPWR VPWR accumulator._1161_ sky130_fd_sc_hd__a21oi_1
Xaccumulator._2203_ accumulator._1093_ accumulator._1119_ VGND VGND VPWR VPWR accumulator._0158_
+ sky130_fd_sc_hd__nand2_2
XFILLER_0_57_281 VPWR VGND VPWR VGND sky130_ef_sc_hd__decap_12
Xaccumulator._2134_ accumulator._0088_ accumulator._0089_ accumulator._1120_ VGND
+ VGND VPWR VPWR accumulator._0090_ sky130_fd_sc_hd__mux2_4
XFILLER_0_9_312 VGND VGND VPWR VPWR sky130_fd_sc_hd__decap_6
XFILLER_0_9_334 VGND VGND VPWR VPWR sky130_fd_sc_hd__fill_2
XFILLER_0_9_378 VGND VGND VPWR VPWR sky130_fd_sc_hd__fill_1
XPHY_EDGE_ROW_17_Left_85 VGND VGND VPWR VPWR sky130_fd_sc_hd__decap_3
XFILLER_0_17_189 VGND VGND VPWR VPWR sky130_fd_sc_hd__decap_6
Xaccumulator._1849_ accumulator._0936_ accumulator._0943_ accumulator._0918_ VGND
+ VGND VPWR VPWR accumulator._0944_ sky130_fd_sc_hd__o21a_1
Xaccumulator._1918_ accumulator._0532_ VGND VGND VPWR VPWR accumulator._1013_ sky130_fd_sc_hd__inv_2
XFILLER_0_55_207 VGND VGND VPWR VPWR sky130_fd_sc_hd__decap_8
XFILLER_0_11_27 VPWR VGND VPWR VGND sky130_ef_sc_hd__decap_12
XTAP_TAPCELL_ROW_11_224 VGND VPWR sky130_fd_sc_hd__tapvpwrvgnd_1
XFILLER_0_23_148 VPWR VGND VPWR VGND sky130_ef_sc_hd__decap_12
XFILLER_0_36_79 VGND VGND VPWR VPWR sky130_fd_sc_hd__decap_4
XFILLER_0_36_35 VGND VGND VPWR VPWR sky130_fd_sc_hd__fill_1
Xinput9 io_inScaleA[0] VGND VGND VPWR VPWR net9 sky130_fd_sc_hd__buf_1
XFILLER_0_39_270 VGND VGND VPWR VPWR sky130_fd_sc_hd__fill_1
XFILLER_0_39_281 VGND VGND VPWR VPWR sky130_fd_sc_hd__decap_4
Xaccumulator._1703_ accumulator.io_accOut\[6\] accumulator._0379_ accumulator._0665_
+ VGND VGND VPWR VPWR accumulator._0798_ sky130_fd_sc_hd__and3_1
Xaccumulator._1634_ accumulator._0536_ accumulator._0595_ accumulator._0598_ accumulator._0728_
+ VGND VGND VPWR VPWR accumulator._0729_ sky130_fd_sc_hd__a31o_1
Xaccumulator._1496_ accumulator._0431_ accumulator._0427_ accumulator._0105_ accumulator._0429_
+ VGND VGND VPWR VPWR accumulator._0591_ sky130_fd_sc_hd__and4_1
Xaccumulator._1565_ accumulator._0539_ accumulator._0652_ accumulator._0656_ accumulator._0659_
+ VGND VGND VPWR VPWR accumulator._0660_ sky130_fd_sc_hd__a31oi_1
Xoperator._23_ operator._05_ operator._06_ VGND VGND VPWR VPWR operator.io_outMant\[1\]
+ sky130_fd_sc_hd__xnor2_2
Xaccumulator._2048_ accumulator._1017_ VGND VGND VPWR VPWR accumulator._1143_ sky130_fd_sc_hd__inv_2
Xaccumulator._2117_ accumulator._0072_ VGND VGND VPWR VPWR accumulator._0004_ sky130_fd_sc_hd__clkbuf_1
XFILLER_0_9_175 VGND VGND VPWR VPWR sky130_fd_sc_hd__fill_2
XFILLER_0_60_276 VPWR VGND VPWR VGND sky130_ef_sc_hd__decap_12
XFILLER_0_60_265 VGND VGND VPWR VPWR sky130_fd_sc_hd__decap_3
XFILLER_0_36_273 VPWR VGND VPWR VGND sky130_ef_sc_hd__decap_12
XFILLER_0_22_26 VGND VGND VPWR VPWR sky130_fd_sc_hd__fill_2
XFILLER_0_51_276 VGND VGND VPWR VPWR sky130_fd_sc_hd__fill_1
XscaleAdd._484_ operator.io_outExp\[2\] scaleAdd._168_ scaleAdd._170_ VGND VGND VPWR
+ VPWR scaleAdd._178_ sky130_fd_sc_hd__a21o_1
XTAP_TAPCELL_ROW_39_419 VGND VPWR sky130_fd_sc_hd__tapvpwrvgnd_1
Xaccumulator._1350_ accumulator._0203_ VGND VGND VPWR VPWR accumulator._0445_ sky130_fd_sc_hd__inv_2
XPHY_EDGE_ROW_10_Right_10 VGND VGND VPWR VPWR sky130_fd_sc_hd__decap_3
Xaccumulator._1281_ net59 VGND VGND VPWR VPWR accumulator._0378_ sky130_fd_sc_hd__clkbuf_4
XTAP_TAPCELL_ROW_47_474 VGND VPWR sky130_fd_sc_hd__tapvpwrvgnd_1
XFILLER_0_63_3 VPWR VGND VPWR VGND sky130_ef_sc_hd__decap_12
XFILLER_0_42_298 VGND VGND VPWR VPWR sky130_fd_sc_hd__decap_8
XFILLER_0_6_167 VGND VGND VPWR VPWR sky130_fd_sc_hd__decap_6
XPHY_EDGE_ROW_34_Left_102 VGND VGND VPWR VPWR sky130_fd_sc_hd__decap_3
Xaccumulator._1617_ accumulator._0473_ accumulator._0698_ accumulator._0711_ VGND
+ VGND VPWR VPWR accumulator._0712_ sky130_fd_sc_hd__o21a_1
XPHY_EDGE_ROW_43_Left_111 VGND VGND VPWR VPWR sky130_fd_sc_hd__decap_3
Xaccumulator._1548_ accumulator._0639_ accumulator._0642_ accumulator._0554_ VGND
+ VGND VPWR VPWR accumulator._0643_ sky130_fd_sc_hd__a21o_1
Xaccumulator._1479_ accumulator._0572_ accumulator._0573_ accumulator._0518_ accumulator._0415_
+ accumulator._0457_ VGND VGND VPWR VPWR accumulator._0574_ sky130_fd_sc_hd__a2111o_1
XFILLER_0_65_335 VGND VGND VPWR VPWR sky130_fd_sc_hd__fill_1
XFILLER_0_18_284 VGND VGND VPWR VPWR sky130_fd_sc_hd__decap_4
XPHY_EDGE_ROW_52_Left_120 VGND VGND VPWR VPWR sky130_fd_sc_hd__decap_3
XFILLER_0_33_298 VGND VGND VPWR VPWR sky130_fd_sc_hd__decap_6
XFILLER_0_33_276 VGND VGND VPWR VPWR sky130_fd_sc_hd__decap_4
XFILLER_0_17_15 VPWR VGND VPWR VGND sky130_ef_sc_hd__decap_12
XFILLER_0_56_357 VGND VGND VPWR VPWR sky130_fd_sc_hd__decap_6
XTAP_TAPCELL_ROW_44_455 VGND VPWR sky130_fd_sc_hd__tapvpwrvgnd_1
XFILLER_0_3_137 VPWR VGND VPWR VGND sky130_ef_sc_hd__decap_12
Xinput12 io_inScaleA[3] VGND VGND VPWR VPWR net12 sky130_fd_sc_hd__clkbuf_2
XFILLER_0_35_7 VGND VGND VPWR VPWR sky130_fd_sc_hd__decap_4
Xaccumulator._1402_ accumulator.io_accOut\[16\] accumulator._0496_ accumulator._0377_
+ VGND VGND VPWR VPWR accumulator._0497_ sky130_fd_sc_hd__mux2_4
XscaleAdd._398_ scaleAdd._100_ scaleAdd._101_ VGND VGND VPWR VPWR scaleAdd._102_ sky130_fd_sc_hd__xor2_2
XscaleAdd._467_ scaleAdd._161_ scaleAdd._162_ VGND VGND VPWR VPWR scaleAdd._163_ sky130_fd_sc_hd__and2_1
XFILLER_0_59_140 VGND VGND VPWR VPWR sky130_fd_sc_hd__decap_3
Xaccumulator._2382_ clknet_2_2__leaf_clock accumulator._0027_ VGND VGND VPWR VPWR
+ accumulator.io_accOut\[25\] sky130_fd_sc_hd__dfxtp_2
Xaccumulator._1264_ accumulator._0359_ accumulator._0356_ accumulator._0360_ VGND
+ VGND VPWR VPWR accumulator._0361_ sky130_fd_sc_hd__a21o_1
Xaccumulator._1333_ accumulator._0311_ VGND VGND VPWR VPWR accumulator._0428_ sky130_fd_sc_hd__buf_2
Xaccumulator._1195_ accumulator.io_inMant\[10\] accumulator.io_inMant\[11\] accumulator._0164_
+ accumulator._0174_ VGND VGND VPWR VPWR accumulator._0183_ sky130_fd_sc_hd__o31a_1
XFILLER_0_15_221 VGND VGND VPWR VPWR sky130_fd_sc_hd__decap_3
XFILLER_0_53_305 VPWR VGND VPWR VGND sky130_ef_sc_hd__decap_12
XTAP_TAPCELL_ROW_41_436 VGND VPWR sky130_fd_sc_hd__tapvpwrvgnd_1
XFILLER_0_61_393 VGND VGND VPWR VPWR sky130_fd_sc_hd__decap_8
XFILLER_0_53_349 VPWR VGND VPWR VGND sky130_ef_sc_hd__decap_12
XPHY_EDGE_ROW_5_Left_73 VGND VGND VPWR VPWR sky130_fd_sc_hd__decap_3
XscaleAdd._321_ scaleAdd._022_ operator.io_outMant\[0\] scaleAdd._027_ VGND VGND VPWR
+ VPWR scaleAdd._028_ sky130_fd_sc_hd__a21o_1
XscaleAdd._252_ scaleAdd._187_ scaleAdd._196_ VGND VGND VPWR VPWR scaleAdd._197_ sky130_fd_sc_hd__nand2_1
XTAP_TAPCELL_ROW_6_191 VGND VPWR sky130_fd_sc_hd__tapvpwrvgnd_1
XFILLER_0_60_89 VGND VGND VPWR VPWR sky130_fd_sc_hd__fill_1
XFILLER_0_60_56 VGND VGND VPWR VPWR sky130_fd_sc_hd__fill_2
XFILLER_0_56_110 VGND VGND VPWR VPWR sky130_fd_sc_hd__fill_1
Xaccumulator._1882_ accumulator._0800_ accumulator._0976_ VGND VGND VPWR VPWR accumulator._0977_
+ sky130_fd_sc_hd__xnor2_2
Xaccumulator._1951_ accumulator._1040_ accumulator._1045_ accumulator._0919_ VGND
+ VGND VPWR VPWR accumulator._1046_ sky130_fd_sc_hd__mux2_1
XFILLER_0_12_268 VGND VGND VPWR VPWR sky130_fd_sc_hd__fill_2
Xaccumulator._2365_ clknet_2_3__leaf_clock accumulator._0010_ VGND VGND VPWR VPWR
+ accumulator.io_accOut\[8\] sky130_fd_sc_hd__dfxtp_1
XFILLER_0_26_3 VGND VGND VPWR VPWR sky130_fd_sc_hd__decap_6
Xaccumulator._1178_ accumulator._1145_ VGND VGND VPWR VPWR net55 sky130_fd_sc_hd__buf_1
XTAP_TAPCELL_ROW_55_528 VGND VPWR sky130_fd_sc_hd__tapvpwrvgnd_1
Xaccumulator._2296_ accumulator.io_accOut\[25\] accumulator._0379_ accumulator._0246_
+ VGND VGND VPWR VPWR accumulator._0247_ sky130_fd_sc_hd__a21o_1
Xaccumulator._1247_ accumulator._0212_ accumulator._0313_ accumulator._0281_ VGND
+ VGND VPWR VPWR accumulator._0344_ sky130_fd_sc_hd__a21o_1
Xaccumulator._1316_ accumulator._0378_ accumulator._0401_ VGND VGND VPWR VPWR accumulator._0411_
+ sky130_fd_sc_hd__nor2_4
XFILLER_0_43_393 VGND VGND VPWR VPWR sky130_fd_sc_hd__decap_8
XFILLER_0_7_262 VGND VGND VPWR VPWR sky130_fd_sc_hd__decap_6
XPHY_EDGE_ROW_31_Left_99 VGND VGND VPWR VPWR sky130_fd_sc_hd__decap_3
XFILLER_0_14_27 VGND VGND VPWR VPWR sky130_fd_sc_hd__fill_1
XFILLER_0_53_113 VGND VGND VPWR VPWR sky130_fd_sc_hd__fill_1
XFILLER_0_61_190 VGND VGND VPWR VPWR sky130_fd_sc_hd__decap_4
XscaleAdd._304_ scaleAdd._010_ VGND VGND VPWR VPWR scaleAdd._011_ sky130_fd_sc_hd__buf_6
XscaleAdd._235_ net10 net11 VGND VGND VPWR VPWR scaleAdd._182_ sky130_fd_sc_hd__and2_1
Xaccumulator._2081_ accumulator._1108_ accumulator._0035_ accumulator._1118_ VGND
+ VGND VPWR VPWR accumulator._0036_ sky130_fd_sc_hd__a21bo_1
XTAP_TAPCELL_ROW_52_509 VGND VPWR sky130_fd_sc_hd__tapvpwrvgnd_1
Xaccumulator._2150_ accumulator.io_accOut\[6\] accumulator._0392_ accumulator._1094_
+ accumulator._0104_ VGND VGND VPWR VPWR accumulator._0106_ sky130_fd_sc_hd__o2bb2a_1
XFILLER_0_29_110 VGND VGND VPWR VPWR sky130_fd_sc_hd__fill_2
XPHY_EDGE_ROW_8_Right_8 VGND VGND VPWR VPWR sky130_fd_sc_hd__decap_3
XTAP_TAPCELL_ROW_17_263 VGND VPWR sky130_fd_sc_hd__tapvpwrvgnd_1
XTAP_TAPCELL_ROW_60_564 VGND VPWR sky130_fd_sc_hd__tapvpwrvgnd_1
Xaccumulator._1934_ accumulator._0946_ accumulator._0988_ VGND VGND VPWR VPWR accumulator._1029_
+ sky130_fd_sc_hd__or2_1
XPHY_EDGE_ROW_39_Right_39 VGND VGND VPWR VPWR sky130_fd_sc_hd__decap_3
Xaccumulator._1865_ accumulator._0706_ accumulator._0746_ accumulator._0534_ VGND
+ VGND VPWR VPWR accumulator._0960_ sky130_fd_sc_hd__a21o_1
Xaccumulator._1796_ accumulator._0889_ accumulator._0890_ VGND VGND VPWR VPWR accumulator._0891_
+ sky130_fd_sc_hd__nand2b_4
XTAP_TAPCELL_ROW_9_209 VGND VPWR sky130_fd_sc_hd__tapvpwrvgnd_1
Xaccumulator._2348_ accumulator._0297_ accumulator._0298_ VGND VGND VPWR VPWR accumulator._0299_
+ sky130_fd_sc_hd__or2_1
XFILLER_0_29_90 VPWR VGND VPWR VGND sky130_ef_sc_hd__decap_12
XTAP_TAPCELL_ROW_0_142 VGND VPWR sky130_fd_sc_hd__tapvpwrvgnd_1
Xaccumulator._2279_ accumulator._0227_ accumulator._0383_ accumulator._0114_ accumulator._0172_
+ accumulator._0230_ VGND VGND VPWR VPWR accumulator._0231_ sky130_fd_sc_hd__o221a_1
XPHY_EDGE_ROW_48_Right_48 VGND VGND VPWR VPWR sky130_fd_sc_hd__decap_3
XFILLER_0_35_113 VPWR VGND VPWR VGND sky130_ef_sc_hd__decap_12
XPHY_EDGE_ROW_57_Right_57 VGND VGND VPWR VPWR sky130_fd_sc_hd__decap_3
XFILLER_0_50_138 VGND VGND VPWR VPWR sky130_fd_sc_hd__fill_2
XFILLER_0_50_105 VGND VGND VPWR VPWR sky130_fd_sc_hd__decap_3
XFILLER_0_23_308 VGND VGND VPWR VPWR sky130_fd_sc_hd__decap_4
XFILLER_0_16_360 VGND VGND VPWR VPWR sky130_fd_sc_hd__decap_4
XPHY_EDGE_ROW_66_Right_66 VGND VGND VPWR VPWR sky130_fd_sc_hd__decap_3
XFILLER_0_25_48 VGND VGND VPWR VPWR sky130_fd_sc_hd__decap_8
XFILLER_0_41_149 VPWR VGND VPWR VGND sky130_ef_sc_hd__decap_12
XFILLER_0_41_138 VGND VGND VPWR VPWR sky130_fd_sc_hd__fill_2
XFILLER_0_41_47 VGND VGND VPWR VPWR sky130_fd_sc_hd__fill_1
XTAP_TAPCELL_ROW_14_244 VGND VPWR sky130_fd_sc_hd__tapvpwrvgnd_1
Xaccumulator._1650_ accumulator._0704_ accumulator._0705_ VGND VGND VPWR VPWR accumulator._0745_
+ sky130_fd_sc_hd__nor2_1
XFILLER_0_5_69 VPWR VGND VPWR VGND sky130_ef_sc_hd__decap_12
Xaccumulator._1581_ accumulator._0537_ accumulator._0675_ VGND VGND VPWR VPWR accumulator._0676_
+ sky130_fd_sc_hd__nand2_1
XFILLER_0_66_77 VGND VGND VPWR VPWR sky130_fd_sc_hd__decap_6
XTAP_TAPCELL_ROW_65_601 VGND VPWR sky130_fd_sc_hd__tapvpwrvgnd_1
Xaccumulator._2202_ accumulator._1121_ accumulator._0088_ VGND VGND VPWR VPWR accumulator._0157_
+ sky130_fd_sc_hd__nand2_1
Xaccumulator._2133_ accumulator._1128_ accumulator._0048_ VGND VGND VPWR VPWR accumulator._0089_
+ sky130_fd_sc_hd__nand2_1
Xaccumulator._2064_ accumulator._1159_ accumulator._1146_ accumulator._1030_ VGND
+ VGND VPWR VPWR accumulator._1160_ sky130_fd_sc_hd__a21o_1
XFILLER_0_57_293 VPWR VGND VPWR VGND sky130_ef_sc_hd__decap_12
XFILLER_0_17_113 VPWR VGND VPWR VGND sky130_ef_sc_hd__decap_12
Xaccumulator._1917_ accumulator._0532_ accumulator._0848_ accumulator._0870_ VGND
+ VGND VPWR VPWR accumulator._1012_ sky130_fd_sc_hd__o21a_1
XFILLER_0_32_127 VPWR VGND VPWR VGND sky130_ef_sc_hd__decap_12
XFILLER_0_31_80 VGND VGND VPWR VPWR sky130_fd_sc_hd__fill_1
XFILLER_0_13_330 VGND VGND VPWR VPWR sky130_fd_sc_hd__decap_6
Xaccumulator._1848_ accumulator._0937_ accumulator._0904_ accumulator._0940_ accumulator._0925_
+ accumulator._0942_ VGND VGND VPWR VPWR accumulator._0943_ sky130_fd_sc_hd__a221o_1
XFILLER_0_40_193 VGND VGND VPWR VPWR sky130_fd_sc_hd__decap_3
Xaccumulator._1779_ accumulator.io_accOut\[17\] accumulator._0492_ accumulator._0389_
+ VGND VGND VPWR VPWR accumulator._0874_ sky130_fd_sc_hd__mux2_2
XFILLER_0_55_219 VGND VGND VPWR VPWR sky130_fd_sc_hd__decap_4
XFILLER_0_11_39 VPWR VGND VPWR VGND sky130_ef_sc_hd__decap_12
XTAP_TAPCELL_ROW_11_225 VGND VPWR sky130_fd_sc_hd__tapvpwrvgnd_1
XFILLER_0_54_274 VPWR VGND VPWR VGND sky130_ef_sc_hd__decap_12
XFILLER_0_6_327 VGND VGND VPWR VPWR sky130_fd_sc_hd__decap_8
Xaccumulator._1702_ accumulator.io_accOut\[5\] accumulator._0379_ accumulator._0681_
+ VGND VGND VPWR VPWR accumulator._0797_ sky130_fd_sc_hd__nand3_1
Xaccumulator._1564_ accumulator._0658_ accumulator._0657_ accumulator._0511_ VGND
+ VGND VPWR VPWR accumulator._0659_ sky130_fd_sc_hd__and3_1
Xaccumulator._1633_ accumulator._0412_ accumulator._0723_ accumulator._0727_ accumulator._0409_
+ VGND VGND VPWR VPWR accumulator._0728_ sky130_fd_sc_hd__a31o_1
Xoperator._22_ net2 net3 net5 VGND VGND VPWR VPWR operator._06_ sky130_fd_sc_hd__o21a_1
Xaccumulator._1495_ accumulator._0426_ accumulator._0589_ accumulator._0442_ VGND
+ VGND VPWR VPWR accumulator._0590_ sky130_fd_sc_hd__a21o_1
Xaccumulator._2047_ accumulator._1052_ VGND VGND VPWR VPWR accumulator._1142_ sky130_fd_sc_hd__inv_2
Xaccumulator._2116_ accumulator._0380_ accumulator._0071_ VGND VGND VPWR VPWR accumulator._0072_
+ sky130_fd_sc_hd__and2_1
XFILLER_0_45_274 VGND VGND VPWR VPWR sky130_fd_sc_hd__decap_6
XFILLER_0_9_187 VGND VGND VPWR VPWR sky130_fd_sc_hd__fill_2
XFILLER_0_60_288 VPWR VGND VPWR VGND sky130_ef_sc_hd__decap_12
XFILLER_0_5_393 VGND VGND VPWR VPWR sky130_fd_sc_hd__decap_8
XFILLER_0_51_200 VPWR VGND VPWR VGND sky130_ef_sc_hd__decap_12
XFILLER_0_36_285 VGND VGND VPWR VPWR sky130_fd_sc_hd__decap_8
XFILLER_0_36_241 VGND VGND VPWR VPWR sky130_fd_sc_hd__decap_8
XFILLER_0_47_57 VGND VGND VPWR VPWR sky130_fd_sc_hd__decap_6
XscaleAdd._483_ scaleAdd._175_ scaleAdd._176_ VGND VGND VPWR VPWR scaleAdd._177_ sky130_fd_sc_hd__nand2_1
XTAP_TAPCELL_ROW_47_475 VGND VPWR sky130_fd_sc_hd__tapvpwrvgnd_1
Xaccumulator._1280_ accumulator._0376_ VGND VGND VPWR VPWR accumulator._0377_ sky130_fd_sc_hd__buf_6
XFILLER_0_2_15 VPWR VGND VPWR VGND sky130_ef_sc_hd__decap_12
XTAP_TAPCELL_ROW_30_353 VGND VPWR sky130_fd_sc_hd__tapvpwrvgnd_1
XFILLER_0_27_274 VGND VGND VPWR VPWR sky130_fd_sc_hd__decap_6
XFILLER_0_56_3 VPWR VGND VPWR VGND sky130_ef_sc_hd__decap_12
XFILLER_0_6_179 VGND VGND VPWR VPWR sky130_fd_sc_hd__decap_8
XFILLER_0_10_141 VPWR VGND VPWR VGND sky130_ef_sc_hd__decap_12
Xaccumulator._1616_ accumulator.io_accOut\[2\] net107 accumulator._0571_ accumulator._0418_
+ VGND VGND VPWR VPWR accumulator._0711_ sky130_fd_sc_hd__a31o_1
Xaccumulator._1547_ accumulator._0551_ accumulator._0641_ VGND VGND VPWR VPWR accumulator._0642_
+ sky130_fd_sc_hd__or2_1
Xaccumulator._1478_ accumulator._0378_ accumulator._0423_ VGND VGND VPWR VPWR accumulator._0573_
+ sky130_fd_sc_hd__nand2_1
XFILLER_0_17_27 VPWR VGND VPWR VGND sky130_ef_sc_hd__decap_12
XTAP_TAPCELL_ROW_44_456 VGND VPWR sky130_fd_sc_hd__tapvpwrvgnd_1
Xinput13 io_inScaleA[4] VGND VGND VPWR VPWR net13 sky130_fd_sc_hd__buf_4
XscaleAdd._466_ scaleAdd._150_ scaleAdd._160_ VGND VGND VPWR VPWR scaleAdd._162_ sky130_fd_sc_hd__nand2_1
XFILLER_0_3_149 VPWR VGND VPWR VGND sky130_ef_sc_hd__decap_12
XFILLER_0_3_105 VGND VGND VPWR VPWR sky130_fd_sc_hd__decap_6
Xaccumulator._2381_ clknet_2_2__leaf_clock accumulator._0026_ VGND VGND VPWR VPWR
+ accumulator.io_accOut\[24\] sky130_fd_sc_hd__dfxtp_1
Xaccumulator._1401_ accumulator._0427_ accumulator._0335_ accumulator._0476_ accumulator._0495_
+ VGND VGND VPWR VPWR accumulator._0496_ sky130_fd_sc_hd__a31o_1
XscaleAdd._397_ scaleAdd._081_ scaleAdd._083_ VGND VGND VPWR VPWR scaleAdd._101_ sky130_fd_sc_hd__or2b_1
XFILLER_0_47_325 VGND VGND VPWR VPWR sky130_fd_sc_hd__decap_3
Xaccumulator._1263_ accumulator.io_accOut\[26\] accumulator._0358_ VGND VGND VPWR
+ VPWR accumulator._0360_ sky130_fd_sc_hd__and2_1
Xaccumulator._1194_ accumulator.io_inMant\[12\] accumulator.io_inMant\[13\] VGND VGND
+ VPWR VPWR accumulator._0174_ sky130_fd_sc_hd__nor2_1
Xaccumulator._1332_ net90 VGND VGND VPWR VPWR accumulator._0427_ sky130_fd_sc_hd__clkbuf_2
XFILLER_0_55_391 VGND VGND VPWR VPWR sky130_fd_sc_hd__fill_1
XFILLER_0_15_255 VPWR VGND VPWR VGND sky130_ef_sc_hd__decap_12
XFILLER_0_53_317 VGND VGND VPWR VPWR sky130_fd_sc_hd__decap_4
XFILLER_0_38_347 VGND VGND VPWR VPWR sky130_fd_sc_hd__fill_1
XFILLER_0_38_336 VGND VGND VPWR VPWR sky130_fd_sc_hd__decap_4
XFILLER_0_61_361 VPWR VGND VPWR VGND sky130_ef_sc_hd__decap_12
XscaleAdd._320_ scaleAdd._218_ scaleAdd._023_ scaleAdd._026_ VGND VGND VPWR VPWR scaleAdd._027_
+ sky130_fd_sc_hd__o21a_1
XFILLER_0_28_59 VGND VGND VPWR VPWR sky130_fd_sc_hd__decap_8
XscaleAdd._251_ scaleAdd._191_ scaleAdd._189_ scaleAdd._195_ operator.io_outMant\[0\]
+ VGND VGND VPWR VPWR scaleAdd._196_ sky130_fd_sc_hd__a22o_1
XFILLER_0_44_47 VGND VGND VPWR VPWR sky130_fd_sc_hd__fill_1
XFILLER_0_8_208 VPWR VGND VPWR VGND sky130_ef_sc_hd__decap_12
XFILLER_0_60_79 VGND VGND VPWR VPWR sky130_fd_sc_hd__decap_4
XFILLER_0_56_133 VGND VGND VPWR VPWR sky130_fd_sc_hd__decap_3
Xaccumulator._1950_ accumulator._0866_ accumulator._0932_ accumulator._0938_ VGND
+ VGND VPWR VPWR accumulator._1045_ sky130_fd_sc_hd__a21bo_1
Xaccumulator._1881_ accumulator._0534_ accumulator._0751_ accumulator._0975_ VGND
+ VGND VPWR VPWR accumulator._0976_ sky130_fd_sc_hd__o21ai_1
XscaleAdd._449_ scaleAdd._124_ scaleAdd._137_ scaleAdd._146_ net99 VGND VGND VPWR
+ VPWR accumulator.io_inMant\[15\] sky130_fd_sc_hd__a2bb2o_4
XTAP_TAPCELL_ROW_55_529 VGND VPWR sky130_fd_sc_hd__tapvpwrvgnd_1
Xaccumulator._2364_ clknet_2_1__leaf_clock accumulator._0009_ VGND VGND VPWR VPWR
+ accumulator.io_accOut\[7\] sky130_fd_sc_hd__dfxtp_2
Xaccumulator._1315_ accumulator._0409_ VGND VGND VPWR VPWR accumulator._0410_ sky130_fd_sc_hd__inv_2
XFILLER_0_19_3 VPWR VGND VPWR VGND sky130_ef_sc_hd__decap_12
XTAP_TAPCELL_ROW_63_584 VGND VPWR sky130_fd_sc_hd__tapvpwrvgnd_1
Xaccumulator._1177_ accumulator.state\[0\] accumulator.state\[1\] VGND VGND VPWR VPWR
+ accumulator._1145_ sky130_fd_sc_hd__and2b_1
XFILLER_0_47_166 VGND VGND VPWR VPWR sky130_fd_sc_hd__fill_2
Xaccumulator._2295_ accumulator._0346_ accumulator._0379_ VGND VGND VPWR VPWR accumulator._0246_
+ sky130_fd_sc_hd__nor2_1
Xaccumulator._1246_ accumulator._0312_ accumulator._0320_ accumulator._0271_ VGND
+ VGND VPWR VPWR accumulator._0343_ sky130_fd_sc_hd__a21o_1
XFILLER_0_62_158 VGND VGND VPWR VPWR sky130_fd_sc_hd__decap_3
XFILLER_0_62_125 VGND VGND VPWR VPWR sky130_fd_sc_hd__fill_2
Xclone38 accumulator._0425_ VGND VGND VPWR VPWR net96 sky130_fd_sc_hd__buf_4
XFILLER_0_38_122 VGND VGND VPWR VPWR sky130_fd_sc_hd__fill_1
XFILLER_0_53_169 VGND VGND VPWR VPWR sky130_fd_sc_hd__fill_2
XFILLER_0_19_380 VGND VGND VPWR VPWR sky130_fd_sc_hd__fill_1
XFILLER_0_19_391 VGND VGND VPWR VPWR sky130_fd_sc_hd__fill_1
XscaleAdd._303_ net14 net15 net16 VGND VGND VPWR VPWR scaleAdd._010_ sky130_fd_sc_hd__or3_4
XFILLER_0_55_57 VPWR VGND VPWR VGND sky130_ef_sc_hd__decap_12
XscaleAdd._234_ operator.io_outMant\[3\] VGND VGND VPWR VPWR scaleAdd._181_ sky130_fd_sc_hd__buf_2
XTAP_TAPCELL_ROW_60_565 VGND VPWR sky130_fd_sc_hd__tapvpwrvgnd_1
Xaccumulator._2080_ accumulator._1173_ accumulator._1140_ accumulator._1101_ VGND
+ VGND VPWR VPWR accumulator._0035_ sky130_fd_sc_hd__a21bo_1
XFILLER_0_29_133 VGND VGND VPWR VPWR sky130_fd_sc_hd__decap_6
XTAP_TAPCELL_ROW_17_264 VGND VPWR sky130_fd_sc_hd__tapvpwrvgnd_1
Xaccumulator._1933_ accumulator._0987_ accumulator._1027_ VGND VGND VPWR VPWR accumulator._1028_
+ sky130_fd_sc_hd__xnor2_2
Xaccumulator._1864_ accumulator._0837_ accumulator._0958_ VGND VGND VPWR VPWR accumulator._0959_
+ sky130_fd_sc_hd__xnor2_2
XFILLER_0_25_361 VPWR VGND VPWR VGND sky130_ef_sc_hd__decap_12
XFILLER_0_4_266 VPWR VGND VPWR VGND sky130_ef_sc_hd__decap_12
XFILLER_0_4_233 VGND VGND VPWR VPWR sky130_fd_sc_hd__fill_1
Xaccumulator._1795_ accumulator._0887_ accumulator._0888_ VGND VGND VPWR VPWR accumulator._0890_
+ sky130_fd_sc_hd__nand2_1
Xaccumulator._2278_ accumulator._1122_ accumulator._0229_ VGND VGND VPWR VPWR accumulator._0230_
+ sky130_fd_sc_hd__nand2_1
Xaccumulator._2347_ accumulator.io_accOut\[30\] net79 accumulator._1093_ accumulator._0290_
+ VGND VGND VPWR VPWR accumulator._0298_ sky130_fd_sc_hd__a211oi_1
XTAP_TAPCELL_ROW_0_143 VGND VPWR sky130_fd_sc_hd__tapvpwrvgnd_1
XFILLER_0_35_125 VPWR VGND VPWR VGND sky130_ef_sc_hd__decap_12
XFILLER_0_0_81 VGND VGND VPWR VPWR sky130_fd_sc_hd__decap_3
Xaccumulator._1229_ accumulator._0321_ accumulator._0324_ VGND VGND VPWR VPWR accumulator._0326_
+ sky130_fd_sc_hd__nor2_1
XFILLER_0_31_364 VGND VGND VPWR VPWR sky130_fd_sc_hd__fill_1
XFILLER_0_8_3 VPWR VGND VPWR VGND sky130_ef_sc_hd__decap_12
XFILLER_0_25_16 VPWR VGND VPWR VGND sky130_ef_sc_hd__decap_12
XFILLER_0_58_217 VGND VGND VPWR VPWR sky130_fd_sc_hd__decap_6
XTAP_TAPCELL_ROW_14_245 VGND VPWR sky130_fd_sc_hd__tapvpwrvgnd_1
XFILLER_0_34_180 VGND VGND VPWR VPWR sky130_fd_sc_hd__fill_1
XFILLER_0_26_169 VGND VGND VPWR VPWR sky130_fd_sc_hd__decap_3
XFILLER_0_26_136 VGND VGND VPWR VPWR sky130_fd_sc_hd__decap_4
XFILLER_0_1_225 VGND VGND VPWR VPWR sky130_fd_sc_hd__fill_1
XFILLER_0_5_15 VPWR VGND VPWR VGND sky130_ef_sc_hd__decap_12
Xaccumulator._1580_ accumulator._0554_ accumulator._0587_ accumulator._0594_ accumulator._0674_
+ VGND VGND VPWR VPWR accumulator._0675_ sky130_fd_sc_hd__a31o_1
XTAP_TAPCELL_ROW_65_602 VGND VPWR sky130_fd_sc_hd__tapvpwrvgnd_1
Xaccumulator._2201_ accumulator._1121_ accumulator._0155_ VGND VGND VPWR VPWR accumulator._0156_
+ sky130_fd_sc_hd__or2_4
Xaccumulator._2132_ accumulator._0043_ accumulator._0087_ net104 VGND VGND VPWR VPWR
+ accumulator._0088_ sky130_fd_sc_hd__mux2_4
XFILLER_0_64_209 VGND VGND VPWR VPWR sky130_fd_sc_hd__decap_3
Xaccumulator._2063_ accumulator._1158_ accumulator._1147_ accumulator._1111_ VGND
+ VGND VPWR VPWR accumulator._1159_ sky130_fd_sc_hd__a21o_1
XFILLER_0_17_125 VGND VGND VPWR VPWR sky130_fd_sc_hd__decap_6
XFILLER_0_17_147 VGND VGND VPWR VPWR sky130_fd_sc_hd__decap_8
XFILLER_0_17_169 VGND VGND VPWR VPWR sky130_fd_sc_hd__decap_4
Xaccumulator._1916_ accumulator._0947_ accumulator._1010_ VGND VGND VPWR VPWR accumulator._1011_
+ sky130_fd_sc_hd__nor2_1
Xaccumulator._1847_ accumulator._0922_ accumulator._0941_ accumulator._0913_ VGND
+ VGND VPWR VPWR accumulator._0942_ sky130_fd_sc_hd__a21o_1
XFILLER_0_32_139 VGND VGND VPWR VPWR sky130_fd_sc_hd__fill_1
XFILLER_0_25_191 VGND VGND VPWR VPWR sky130_fd_sc_hd__decap_3
Xaccumulator._1778_ accumulator._0787_ accumulator._0604_ VGND VGND VPWR VPWR accumulator._0873_
+ sky130_fd_sc_hd__nor2_1
XFILLER_0_48_250 VGND VGND VPWR VPWR sky130_fd_sc_hd__fill_2
XFILLER_0_23_128 VPWR VGND VPWR VGND sky130_ef_sc_hd__decap_12
XFILLER_0_23_106 VGND VGND VPWR VPWR sky130_fd_sc_hd__decap_6
XTAP_TAPCELL_ROW_11_226 VGND VPWR sky130_fd_sc_hd__tapvpwrvgnd_1
XFILLER_0_54_220 VPWR VGND VPWR VGND sky130_ef_sc_hd__decap_12
XFILLER_0_6_317 VGND VGND VPWR VPWR sky130_fd_sc_hd__fill_2
XFILLER_0_54_286 VPWR VGND VPWR VGND sky130_ef_sc_hd__decap_12
Xaccumulator._1701_ accumulator._0665_ accumulator._0666_ VGND VGND VPWR VPWR accumulator._0796_
+ sky130_fd_sc_hd__and2b_1
XFILLER_0_14_139 VGND VGND VPWR VPWR sky130_fd_sc_hd__fill_1
Xaccumulator._1494_ accumulator.io_accOut\[10\] accumulator._0588_ accumulator._0376_
+ VGND VGND VPWR VPWR accumulator._0589_ sky130_fd_sc_hd__mux2_2
Xaccumulator._1563_ accumulator._0615_ accumulator._0616_ accumulator._0462_ VGND
+ VGND VPWR VPWR accumulator._0658_ sky130_fd_sc_hd__a21o_1
Xoperator._21_ net7 net6 net1 VGND VGND VPWR VPWR operator._05_ sky130_fd_sc_hd__o21ai_1
XFILLER_0_10_356 VGND VGND VPWR VPWR sky130_fd_sc_hd__decap_8
Xaccumulator._1632_ accumulator._0563_ accumulator._0725_ accumulator._0726_ accumulator._0514_
+ VGND VGND VPWR VPWR accumulator._0727_ sky130_fd_sc_hd__o211ai_1
Xaccumulator._2115_ accumulator._0070_ accumulator._0062_ accumulator._1166_ accumulator.io_accOut\[2\]
+ VGND VGND VPWR VPWR accumulator._0071_ sky130_fd_sc_hd__a2bb2o_1
XTAP_TAPCELL_ROW_25_318 VGND VPWR sky130_fd_sc_hd__tapvpwrvgnd_1
XFILLER_0_9_111 VGND VGND VPWR VPWR sky130_fd_sc_hd__fill_1
Xaccumulator._2046_ accumulator._0945_ accumulator._1089_ VGND VGND VPWR VPWR accumulator._1141_
+ sky130_fd_sc_hd__nand2_1
XFILLER_0_5_361 VGND VGND VPWR VPWR sky130_fd_sc_hd__fill_1
XFILLER_0_36_253 VGND VGND VPWR VPWR sky130_fd_sc_hd__fill_1
XFILLER_0_51_212 VGND VGND VPWR VPWR sky130_fd_sc_hd__decap_4
XscaleAdd._482_ net58 scaleAdd._174_ VGND VGND VPWR VPWR scaleAdd._176_ sky130_fd_sc_hd__nand2_2
XFILLER_0_11_109 VGND VGND VPWR VPWR sky130_fd_sc_hd__decap_3
XFILLER_0_63_57 VGND VGND VPWR VPWR sky130_fd_sc_hd__fill_2
XFILLER_0_59_334 VGND VGND VPWR VPWR sky130_fd_sc_hd__fill_2
XTAP_TAPCELL_ROW_47_476 VGND VPWR sky130_fd_sc_hd__tapvpwrvgnd_1
XFILLER_0_2_27 VGND VGND VPWR VPWR sky130_fd_sc_hd__fill_1
XTAP_TAPCELL_ROW_30_354 VGND VPWR sky130_fd_sc_hd__tapvpwrvgnd_1
XFILLER_0_6_158 VGND VGND VPWR VPWR sky130_fd_sc_hd__decap_3
XFILLER_0_10_153 VGND VGND VPWR VPWR sky130_fd_sc_hd__decap_8
XFILLER_0_10_175 VGND VGND VPWR VPWR sky130_fd_sc_hd__fill_2
XFILLER_0_49_3 VGND VGND VPWR VPWR sky130_fd_sc_hd__decap_8
XTAP_TAPCELL_ROW_38_410 VGND VPWR sky130_fd_sc_hd__tapvpwrvgnd_1
Xaccumulator._1615_ accumulator._0687_ accumulator._0688_ VGND VGND VPWR VPWR accumulator._0710_
+ sky130_fd_sc_hd__or2_1
XFILLER_0_10_197 VGND VGND VPWR VPWR sky130_fd_sc_hd__decap_4
Xaccumulator._1546_ accumulator._0457_ accumulator._0490_ accumulator._0620_ accumulator._0640_
+ VGND VGND VPWR VPWR accumulator._0641_ sky130_fd_sc_hd__a31o_1
Xaccumulator._1477_ accumulator._0387_ accumulator._0571_ VGND VGND VPWR VPWR accumulator._0572_
+ sky130_fd_sc_hd__nand2_1
XFILLER_0_65_337 VPWR VGND VPWR VGND sky130_ef_sc_hd__decap_12
Xaccumulator._2029_ accumulator._1109_ accumulator._1118_ accumulator._1123_ accumulator._1037_
+ VGND VGND VPWR VPWR accumulator._1124_ sky130_fd_sc_hd__a31oi_1
XFILLER_0_33_223 VGND VGND VPWR VPWR sky130_fd_sc_hd__fill_1
XFILLER_0_5_180 VGND VGND VPWR VPWR sky130_fd_sc_hd__fill_1
XFILLER_0_17_39 VPWR VGND VPWR VGND sky130_ef_sc_hd__decap_12
XTAP_TAPCELL_ROW_44_457 VGND VPWR sky130_fd_sc_hd__tapvpwrvgnd_1
Xinput14 io_inScaleA[5] VGND VGND VPWR VPWR net14 sky130_fd_sc_hd__buf_1
XFILLER_0_58_68 VGND VGND VPWR VPWR sky130_fd_sc_hd__decap_4
XFILLER_0_58_35 VGND VGND VPWR VPWR sky130_fd_sc_hd__fill_1
XscaleAdd._465_ scaleAdd._150_ scaleAdd._160_ VGND VGND VPWR VPWR scaleAdd._161_ sky130_fd_sc_hd__or2_1
Xaccumulator._2380_ clknet_2_2__leaf_clock accumulator._0025_ VGND VGND VPWR VPWR
+ accumulator.io_accOut\[23\] sky130_fd_sc_hd__dfxtp_1
Xaccumulator._1400_ net61 accumulator._0475_ accumulator._0478_ accumulator._0055_
+ VGND VGND VPWR VPWR accumulator._0495_ sky130_fd_sc_hd__a22o_1
XscaleAdd._396_ scaleAdd._089_ scaleAdd._099_ VGND VGND VPWR VPWR scaleAdd._100_ sky130_fd_sc_hd__xnor2_2
Xaccumulator._1331_ accumulator._0425_ VGND VGND VPWR VPWR accumulator._0426_ sky130_fd_sc_hd__buf_2
XFILLER_0_62_307 VGND VGND VPWR VPWR sky130_fd_sc_hd__fill_1
XFILLER_0_59_164 VGND VGND VPWR VPWR sky130_fd_sc_hd__decap_4
Xaccumulator._1262_ accumulator.io_accOut\[26\] accumulator._0358_ VGND VGND VPWR
+ VPWR accumulator._0359_ sky130_fd_sc_hd__or2_1
Xaccumulator._1193_ accumulator.io_inMant\[7\] accumulator.io_inMant\[6\] accumulator._0144_
+ accumulator._0154_ VGND VGND VPWR VPWR accumulator._0164_ sky130_fd_sc_hd__o31a_1
XFILLER_0_15_245 VGND VGND VPWR VPWR sky130_fd_sc_hd__fill_1
XFILLER_0_15_267 VGND VGND VPWR VPWR sky130_fd_sc_hd__decap_6
XTAP_TAPCELL_ROW_58_549 VGND VPWR sky130_fd_sc_hd__tapvpwrvgnd_1
Xaccumulator._1529_ accumulator._0504_ accumulator._0509_ accumulator._0500_ VGND
+ VGND VPWR VPWR accumulator._0624_ sky130_fd_sc_hd__a21o_1
XFILLER_0_3_81 VPWR VGND VPWR VGND sky130_ef_sc_hd__decap_12
XFILLER_0_38_315 VGND VGND VPWR VPWR sky130_fd_sc_hd__decap_3
XFILLER_0_61_373 VPWR VGND VPWR VGND sky130_ef_sc_hd__decap_12
XFILLER_0_0_109 VGND VGND VPWR VPWR sky130_fd_sc_hd__decap_3
XFILLER_0_28_38 VGND VGND VPWR VPWR sky130_fd_sc_hd__decap_8
XscaleAdd._250_ scaleAdd._189_ scaleAdd._193_ scaleAdd._194_ VGND VGND VPWR VPWR scaleAdd._195_
+ sky130_fd_sc_hd__nor3_2
XFILLER_0_29_348 VPWR VGND VPWR VGND sky130_ef_sc_hd__decap_12
Xaccumulator._1880_ accumulator._0918_ accumulator._0973_ accumulator._0974_ VGND
+ VGND VPWR VPWR accumulator._0975_ sky130_fd_sc_hd__or3_1
XFILLER_0_37_381 VGND VGND VPWR VPWR sky130_fd_sc_hd__fill_2
XFILLER_0_8_15 VPWR VGND VPWR VGND sky130_ef_sc_hd__decap_12
XscaleAdd._448_ net77 scaleAdd._146_ VGND VGND VPWR VPWR accumulator.io_inMant\[14\]
+ sky130_fd_sc_hd__xor2_2
XscaleAdd._379_ scaleAdd._081_ scaleAdd._082_ scaleAdd._069_ VGND VGND VPWR VPWR scaleAdd._084_
+ sky130_fd_sc_hd__o21ai_1
Xaccumulator._2294_ accumulator.io_accOut\[24\] accumulator._0147_ accumulator._0381_
+ accumulator._0245_ VGND VGND VPWR VPWR accumulator._0026_ sky130_fd_sc_hd__o211a_1
Xaccumulator._2363_ clknet_2_0__leaf_clock accumulator._0008_ VGND VGND VPWR VPWR
+ accumulator.io_accOut\[6\] sky130_fd_sc_hd__dfxtp_2
Xaccumulator._1245_ accumulator.io_accOut\[27\] accumulator._0341_ VGND VGND VPWR
+ VPWR accumulator._0342_ sky130_fd_sc_hd__or2_1
X_19_ accumulator.io_accOut\[19\] VGND VGND VPWR VPWR net33 sky130_fd_sc_hd__buf_1
Xaccumulator._1314_ accumulator._0405_ accumulator._0408_ VGND VGND VPWR VPWR accumulator._0409_
+ sky130_fd_sc_hd__nand2b_2
XTAP_TAPCELL_ROW_63_585 VGND VPWR sky130_fd_sc_hd__tapvpwrvgnd_1
XFILLER_0_50_80 VGND VGND VPWR VPWR sky130_fd_sc_hd__decap_4
XFILLER_0_14_29 VGND VGND VPWR VPWR sky130_fd_sc_hd__decap_8
XFILLER_0_38_167 VPWR VGND VPWR VGND sky130_ef_sc_hd__decap_12
XFILLER_0_38_156 VGND VGND VPWR VPWR sky130_fd_sc_hd__fill_1
XFILLER_0_34_395 VGND VGND VPWR VPWR sky130_fd_sc_hd__fill_2
XscaleAdd._302_ scaleAdd._192_ scaleAdd._224_ VGND VGND VPWR VPWR scaleAdd._009_ sky130_fd_sc_hd__nand2_1
XFILLER_0_55_69 VGND VGND VPWR VPWR sky130_fd_sc_hd__decap_8
XTAP_TAPCELL_ROW_60_566 VGND VPWR sky130_fd_sc_hd__tapvpwrvgnd_1
XFILLER_0_29_156 VPWR VGND VPWR VGND sky130_ef_sc_hd__decap_12
XTAP_TAPCELL_ROW_17_265 VGND VPWR sky130_fd_sc_hd__tapvpwrvgnd_1
Xaccumulator._1932_ accumulator._0978_ accumulator._0983_ accumulator._0946_ VGND
+ VGND VPWR VPWR accumulator._1027_ sky130_fd_sc_hd__a21oi_1
XFILLER_0_40_365 VPWR VGND VPWR VGND sky130_ef_sc_hd__decap_12
Xaccumulator._1863_ accumulator._0956_ accumulator._0957_ VGND VGND VPWR VPWR accumulator._0958_
+ sky130_fd_sc_hd__nand2_1
XFILLER_0_25_373 VGND VGND VPWR VPWR sky130_fd_sc_hd__decap_3
XFILLER_0_4_256 VGND VGND VPWR VPWR sky130_fd_sc_hd__decap_4
XFILLER_0_4_212 VGND VGND VPWR VPWR sky130_fd_sc_hd__decap_6
XFILLER_0_20_72 VGND VGND VPWR VPWR sky130_fd_sc_hd__fill_2
XFILLER_0_31_3 VGND VGND VPWR VPWR sky130_fd_sc_hd__fill_2
Xaccumulator._1794_ accumulator._0887_ accumulator._0888_ VGND VGND VPWR VPWR accumulator._0889_
+ sky130_fd_sc_hd__nor2_1
Xaccumulator._2277_ accumulator._1081_ accumulator._1090_ accumulator._0060_ accumulator._0199_
+ accumulator._0228_ VGND VGND VPWR VPWR accumulator._0229_ sky130_fd_sc_hd__a221o_1
XTAP_TAPCELL_ROW_51_500 VGND VPWR sky130_fd_sc_hd__tapvpwrvgnd_1
Xaccumulator._2346_ accumulator._1093_ accumulator._0290_ accumulator.io_accOut\[30\]
+ accumulator._0375_ VGND VGND VPWR VPWR accumulator._0297_ sky130_fd_sc_hd__o211a_1
XTAP_TAPCELL_ROW_0_144 VGND VPWR sky130_fd_sc_hd__tapvpwrvgnd_1
Xaccumulator._1228_ accumulator._0317_ accumulator._0316_ accumulator._0321_ accumulator._0324_
+ VGND VGND VPWR VPWR accumulator._0325_ sky130_fd_sc_hd__a211o_1
XFILLER_0_61_90 VGND VGND VPWR VPWR sky130_fd_sc_hd__decap_4
XFILLER_0_50_118 VGND VGND VPWR VPWR sky130_fd_sc_hd__fill_1
XFILLER_0_35_137 VGND VGND VPWR VPWR sky130_fd_sc_hd__decap_6
XTAP_TAPCELL_ROW_8_200 VGND VPWR sky130_fd_sc_hd__tapvpwrvgnd_1
XFILLER_0_25_28 VGND VGND VPWR VPWR sky130_fd_sc_hd__decap_3
XTAP_TAPCELL_ROW_14_246 VGND VPWR sky130_fd_sc_hd__tapvpwrvgnd_1
XFILLER_0_41_118 VGND VGND VPWR VPWR sky130_fd_sc_hd__decap_8
XFILLER_0_5_27 VPWR VGND VPWR VGND sky130_ef_sc_hd__decap_12
XTAP_TAPCELL_ROW_65_603 VGND VPWR sky130_fd_sc_hd__tapvpwrvgnd_1
Xaccumulator._2200_ accumulator._0150_ accumulator._0153_ accumulator._1128_ VGND
+ VGND VPWR VPWR accumulator._0155_ sky130_fd_sc_hd__mux2_4
Xaccumulator._2131_ accumulator._0066_ accumulator._0086_ accumulator._0042_ VGND
+ VGND VPWR VPWR accumulator._0087_ sky130_fd_sc_hd__mux2_2
Xaccumulator._2062_ accumulator._1157_ accumulator._1148_ accumulator._1117_ VGND
+ VGND VPWR VPWR accumulator._1158_ sky130_fd_sc_hd__a21o_1
XFILLER_0_57_273 VGND VGND VPWR VPWR sky130_fd_sc_hd__decap_6
XFILLER_0_57_251 VPWR VGND VPWR VGND sky130_ef_sc_hd__decap_12
XFILLER_0_9_337 VPWR VGND VPWR VGND sky130_ef_sc_hd__decap_12
Xaccumulator._1915_ accumulator._0852_ accumulator._1004_ VGND VGND VPWR VPWR accumulator._1010_
+ sky130_fd_sc_hd__and2b_1
Xaccumulator._1777_ accumulator._0869_ accumulator._0871_ accumulator._0865_ VGND
+ VGND VPWR VPWR accumulator._0872_ sky130_fd_sc_hd__o21ai_1
Xaccumulator._1846_ accumulator._0768_ accumulator._0538_ accumulator._0888_ accumulator._0901_
+ accumulator._0900_ VGND VGND VPWR VPWR accumulator._0941_ sky130_fd_sc_hd__a41o_1
XFILLER_0_0_281 VGND VGND VPWR VPWR sky130_fd_sc_hd__fill_2
XFILLER_0_13_343 VPWR VGND VPWR VGND sky130_ef_sc_hd__decap_12
Xaccumulator._2329_ accumulator.io_accOut\[28\] accumulator._0279_ accumulator._0389_
+ VGND VGND VPWR VPWR accumulator._0280_ sky130_fd_sc_hd__mux2_1
XFILLER_0_8_370 VGND VGND VPWR VPWR sky130_fd_sc_hd__decap_6
XFILLER_0_16_181 VGND VGND VPWR VPWR sky130_fd_sc_hd__fill_1
XFILLER_0_36_27 VGND VGND VPWR VPWR sky130_fd_sc_hd__fill_1
XFILLER_0_31_184 VGND VGND VPWR VPWR sky130_fd_sc_hd__decap_6
XFILLER_0_52_15 VPWR VGND VPWR VGND sky130_ef_sc_hd__decap_12
XFILLER_0_54_298 VGND VGND VPWR VPWR sky130_fd_sc_hd__fill_2
XFILLER_0_54_232 VGND VGND VPWR VPWR sky130_fd_sc_hd__fill_2
Xaccumulator._1700_ accumulator._0773_ accumulator._0786_ accumulator._0791_ accumulator._0793_
+ accumulator._0794_ VGND VGND VPWR VPWR accumulator._0795_ sky130_fd_sc_hd__o221a_1
Xaccumulator._1631_ accumulator._0442_ accumulator._0698_ accumulator._0699_ accumulator._0459_
+ accumulator._0460_ VGND VGND VPWR VPWR accumulator._0726_ sky130_fd_sc_hd__a2111o_1
Xaccumulator._1493_ accumulator._0427_ accumulator._0105_ accumulator._0447_ VGND
+ VGND VPWR VPWR accumulator._0588_ sky130_fd_sc_hd__and3_1
Xaccumulator._1562_ accumulator._0626_ accumulator._0625_ accumulator._0420_ VGND
+ VGND VPWR VPWR accumulator._0657_ sky130_fd_sc_hd__a21o_1
Xoperator._20_ operator._03_ operator._04_ VGND VGND VPWR VPWR operator.io_outExp\[0\]
+ sky130_fd_sc_hd__xor2_1
Xaccumulator._2114_ accumulator._0067_ accumulator._0069_ accumulator._0060_ VGND
+ VGND VPWR VPWR accumulator._0070_ sky130_fd_sc_hd__mux2_1
Xaccumulator._2045_ accumulator._1137_ accumulator._1139_ accumulator._1021_ VGND
+ VGND VPWR VPWR accumulator._1140_ sky130_fd_sc_hd__mux2_4
XTAP_TAPCELL_ROW_25_319 VGND VPWR sky130_fd_sc_hd__tapvpwrvgnd_1
XFILLER_0_9_167 VGND VGND VPWR VPWR sky130_fd_sc_hd__fill_1
XFILLER_0_45_254 VGND VGND VPWR VPWR sky130_fd_sc_hd__decap_4
XFILLER_0_45_232 VGND VGND VPWR VPWR sky130_fd_sc_hd__decap_6
XTAP_TAPCELL_ROW_33_374 VGND VPWR sky130_fd_sc_hd__tapvpwrvgnd_1
Xaccumulator._1829_ accumulator._0881_ accumulator._0886_ VGND VGND VPWR VPWR accumulator._0924_
+ sky130_fd_sc_hd__nand2_1
XFILLER_0_22_18 VGND VGND VPWR VPWR sky130_fd_sc_hd__decap_8
XFILLER_0_51_268 VGND VGND VPWR VPWR sky130_fd_sc_hd__decap_8
XscaleAdd._481_ net57 scaleAdd._174_ VGND VGND VPWR VPWR scaleAdd._175_ sky130_fd_sc_hd__or2_1
XFILLER_0_47_37 VPWR VGND VPWR VGND sky130_ef_sc_hd__decap_12
XTAP_TAPCELL_ROW_47_477 VGND VPWR sky130_fd_sc_hd__tapvpwrvgnd_1
XTAP_TAPCELL_ROW_30_355 VGND VPWR sky130_fd_sc_hd__tapvpwrvgnd_1
Xaccumulator._1614_ accumulator._0608_ accumulator._0707_ accumulator._0708_ accumulator._0536_
+ VGND VGND VPWR VPWR accumulator._0709_ sky130_fd_sc_hd__o211a_1
XTAP_TAPCELL_ROW_38_411 VGND VPWR sky130_fd_sc_hd__tapvpwrvgnd_1
Xaccumulator._1545_ accumulator.io_accOut\[7\] net107 accumulator._0414_ accumulator._0571_
+ VGND VGND VPWR VPWR accumulator._0640_ sky130_fd_sc_hd__and4_1
Xaccumulator._1476_ accumulator._0424_ VGND VGND VPWR VPWR accumulator._0571_ sky130_fd_sc_hd__clkbuf_2
XFILLER_0_65_349 VPWR VGND VPWR VGND sky130_ef_sc_hd__decap_12
XFILLER_0_65_305 VPWR VGND VPWR VGND sky130_ef_sc_hd__decap_12
Xaccumulator._2028_ accumulator._1111_ accumulator._1113_ VGND VGND VPWR VPWR accumulator._1123_
+ sky130_fd_sc_hd__nor2_1
XFILLER_0_18_221 VGND VGND VPWR VPWR sky130_fd_sc_hd__fill_1
Xinput15 io_inScaleA[6] VGND VGND VPWR VPWR net15 sky130_fd_sc_hd__buf_1
XscaleAdd._395_ scaleAdd._098_ scaleAdd._097_ VGND VGND VPWR VPWR scaleAdd._099_ sky130_fd_sc_hd__xnor2_2
XscaleAdd._464_ scaleAdd._158_ scaleAdd._159_ VGND VGND VPWR VPWR scaleAdd._160_ sky130_fd_sc_hd__nand2_1
Xaccumulator._1261_ accumulator._0326_ accumulator._0357_ accumulator._0340_ VGND
+ VGND VPWR VPWR accumulator._0358_ sky130_fd_sc_hd__o21bai_2
Xaccumulator._1330_ accumulator._0423_ accumulator._0424_ accumulator._0386_ VGND
+ VGND VPWR VPWR accumulator._0425_ sky130_fd_sc_hd__mux2_4
Xaccumulator._1192_ accumulator.io_inMant\[9\] accumulator.io_inMant\[8\] VGND VGND
+ VPWR VPWR accumulator._0154_ sky130_fd_sc_hd__nor2_1
XFILLER_0_23_94 VPWR VGND VPWR VGND sky130_ef_sc_hd__decap_12
XFILLER_0_23_50 VGND VGND VPWR VPWR sky130_fd_sc_hd__decap_6
XFILLER_0_61_3 VPWR VGND VPWR VGND sky130_ef_sc_hd__decap_12
XFILLER_0_55_393 VGND VGND VPWR VPWR sky130_fd_sc_hd__decap_4
XFILLER_0_30_227 VGND VGND VPWR VPWR sky130_fd_sc_hd__decap_6
XFILLER_0_15_279 VGND VGND VPWR VPWR sky130_fd_sc_hd__fill_1
XFILLER_0_2_195 VGND VGND VPWR VPWR sky130_fd_sc_hd__fill_1
XFILLER_0_3_93 VPWR VGND VPWR VGND sky130_ef_sc_hd__decap_12
Xaccumulator._1528_ accumulator._0514_ accumulator._0617_ accumulator._0622_ VGND
+ VGND VPWR VPWR accumulator._0623_ sky130_fd_sc_hd__and3_1
Xaccumulator._1459_ accumulator._0511_ VGND VGND VPWR VPWR accumulator._0554_ sky130_fd_sc_hd__buf_2
XFILLER_0_61_385 VGND VGND VPWR VPWR sky130_fd_sc_hd__decap_6
XFILLER_0_44_27 VGND VGND VPWR VPWR sky130_fd_sc_hd__fill_1
XFILLER_0_60_15 VPWR VGND VPWR VGND sky130_ef_sc_hd__decap_12
XFILLER_0_52_363 VGND VGND VPWR VPWR sky130_fd_sc_hd__fill_1
XFILLER_0_37_393 VGND VGND VPWR VPWR sky130_fd_sc_hd__decap_4
XFILLER_0_8_27 VGND VGND VPWR VPWR sky130_fd_sc_hd__fill_1
XscaleAdd._447_ scaleAdd._145_ scaleAdd._142_ scaleAdd._141_ VGND VGND VPWR VPWR scaleAdd._147_
+ sky130_fd_sc_hd__a21o_1
XscaleAdd._378_ scaleAdd._069_ scaleAdd._081_ scaleAdd._082_ VGND VGND VPWR VPWR scaleAdd._083_
+ sky130_fd_sc_hd__or3_4
Xaccumulator._2293_ accumulator._0243_ accumulator._0244_ accumulator._0147_ VGND
+ VGND VPWR VPWR accumulator._0245_ sky130_fd_sc_hd__o21ai_1
X_18_ accumulator.io_accOut\[18\] VGND VGND VPWR VPWR net32 sky130_fd_sc_hd__clkbuf_1
Xaccumulator._2362_ clknet_2_0__leaf_clock accumulator._0007_ VGND VGND VPWR VPWR
+ accumulator.io_accOut\[5\] sky130_fd_sc_hd__dfxtp_1
Xaccumulator._1244_ net63 accumulator._0327_ accumulator._0340_ VGND VGND VPWR VPWR
+ accumulator._0341_ sky130_fd_sc_hd__a21o_1
XFILLER_0_18_83 VGND VGND VPWR VPWR sky130_fd_sc_hd__fill_1
Xaccumulator._1313_ accumulator._0396_ accumulator._0407_ VGND VGND VPWR VPWR accumulator._0408_
+ sky130_fd_sc_hd__xor2_2
XTAP_TAPCELL_ROW_63_586 VGND VPWR sky130_fd_sc_hd__tapvpwrvgnd_1
XFILLER_0_7_232 VPWR VGND VPWR VGND sky130_ef_sc_hd__decap_12
XTAP_TAPCELL_ROW_3_164 VGND VPWR sky130_fd_sc_hd__tapvpwrvgnd_1
XFILLER_0_38_179 VGND VGND VPWR VPWR sky130_fd_sc_hd__fill_1
XPHY_EDGE_ROW_9_Left_77 VGND VGND VPWR VPWR sky130_fd_sc_hd__decap_3
XFILLER_0_53_149 VGND VGND VPWR VPWR sky130_fd_sc_hd__fill_1
XFILLER_0_55_15 VPWR VGND VPWR VGND sky130_ef_sc_hd__decap_12
XFILLER_0_39_27 VGND VGND VPWR VPWR sky130_fd_sc_hd__decap_4
XscaleAdd._301_ scaleAdd._007_ scaleAdd._006_ VGND VGND VPWR VPWR scaleAdd._008_ sky130_fd_sc_hd__and2b_1
XFILLER_0_29_102 VGND VGND VPWR VPWR sky130_fd_sc_hd__decap_8
XTAP_TAPCELL_ROW_60_567 VGND VPWR sky130_fd_sc_hd__tapvpwrvgnd_1
XFILLER_0_44_127 VPWR VGND VPWR VGND sky130_ef_sc_hd__decap_12
XTAP_TAPCELL_ROW_17_266 VGND VPWR sky130_fd_sc_hd__tapvpwrvgnd_1
Xaccumulator._1931_ accumulator._1009_ accumulator._1017_ accumulator._1025_ VGND
+ VGND VPWR VPWR accumulator._1026_ sky130_fd_sc_hd__or3_1
XFILLER_0_40_377 VPWR VGND VPWR VGND sky130_ef_sc_hd__decap_12
Xaccumulator._1793_ accumulator.io_accOut\[20\] accumulator._0482_ accumulator._0389_
+ VGND VGND VPWR VPWR accumulator._0888_ sky130_fd_sc_hd__mux2_2
Xaccumulator._1862_ accumulator._0721_ accumulator._0743_ accumulator._0744_ accumulator._0533_
+ VGND VGND VPWR VPWR accumulator._0957_ sky130_fd_sc_hd__a211o_1
Xaccumulator._2345_ accumulator._1093_ accumulator._0290_ accumulator._0280_ VGND
+ VGND VPWR VPWR accumulator._0296_ sky130_fd_sc_hd__or3b_1
XFILLER_0_24_3 VGND VGND VPWR VPWR sky130_fd_sc_hd__decap_6
Xaccumulator._2276_ accumulator._0080_ accumulator._0213_ VGND VGND VPWR VPWR accumulator._0228_
+ sky130_fd_sc_hd__nor2_1
XTAP_TAPCELL_ROW_51_501 VGND VPWR sky130_fd_sc_hd__tapvpwrvgnd_1
XTAP_TAPCELL_ROW_0_145 VGND VPWR sky130_fd_sc_hd__tapvpwrvgnd_1
Xaccumulator._1227_ accumulator._0322_ accumulator._0323_ VGND VGND VPWR VPWR accumulator._0324_
+ sky130_fd_sc_hd__xor2_1
XFILLER_0_31_333 VGND VGND VPWR VPWR sky130_fd_sc_hd__decap_3
XFILLER_0_31_311 VGND VGND VPWR VPWR sky130_fd_sc_hd__fill_1
XPHY_EDGE_ROW_17_Right_17 VGND VGND VPWR VPWR sky130_fd_sc_hd__decap_3
XPHY_EDGE_ROW_26_Right_26 VGND VGND VPWR VPWR sky130_fd_sc_hd__decap_3
XTAP_TAPCELL_ROW_8_201 VGND VPWR sky130_fd_sc_hd__tapvpwrvgnd_1
XFILLER_0_66_241 VGND VGND VPWR VPWR sky130_fd_sc_hd__decap_8
XPHY_EDGE_ROW_35_Right_35 VGND VGND VPWR VPWR sky130_fd_sc_hd__decap_3
XTAP_TAPCELL_ROW_14_247 VGND VPWR sky130_fd_sc_hd__tapvpwrvgnd_1
XFILLER_0_41_108 VGND VGND VPWR VPWR sky130_fd_sc_hd__decap_4
XFILLER_0_34_193 VGND VGND VPWR VPWR sky130_fd_sc_hd__decap_3
XFILLER_0_22_377 VGND VGND VPWR VPWR sky130_fd_sc_hd__fill_2
XFILLER_0_1_205 VPWR VGND VPWR VGND sky130_ef_sc_hd__decap_12
XTAP_TAPCELL_ROW_65_604 VGND VPWR sky130_fd_sc_hd__tapvpwrvgnd_1
XPHY_EDGE_ROW_44_Right_44 VGND VGND VPWR VPWR sky130_fd_sc_hd__decap_3
XFILLER_0_5_39 VPWR VGND VPWR VGND sky130_ef_sc_hd__decap_12
XPHY_EDGE_ROW_59_Left_127 VGND VGND VPWR VPWR sky130_fd_sc_hd__decap_3
XFILLER_0_57_263 VGND VGND VPWR VPWR sky130_fd_sc_hd__decap_6
XFILLER_0_57_241 VGND VGND VPWR VPWR sky130_fd_sc_hd__fill_1
Xaccumulator._2130_ accumulator._0078_ accumulator._1148_ accumulator._1171_ VGND
+ VGND VPWR VPWR accumulator._0086_ sky130_fd_sc_hd__mux2_2
Xaccumulator._2061_ accumulator._1156_ accumulator._1149_ accumulator._1107_ VGND
+ VGND VPWR VPWR accumulator._1157_ sky130_fd_sc_hd__a21o_1
XPHY_EDGE_ROW_53_Right_53 VGND VGND VPWR VPWR sky130_fd_sc_hd__decap_3
XFILLER_0_9_349 VGND VGND VPWR VPWR sky130_fd_sc_hd__decap_3
Xaccumulator._1914_ accumulator._1006_ accumulator._1008_ VGND VGND VPWR VPWR accumulator._1009_
+ sky130_fd_sc_hd__or2_1
XPHY_EDGE_ROW_62_Right_62 VGND VGND VPWR VPWR sky130_fd_sc_hd__decap_3
XFILLER_0_40_141 VGND VGND VPWR VPWR sky130_fd_sc_hd__fill_1
Xaccumulator._1776_ accumulator._0864_ accumulator._0870_ VGND VGND VPWR VPWR accumulator._0871_
+ sky130_fd_sc_hd__nor2_1
Xaccumulator._1845_ accumulator._0873_ accumulator._0874_ accumulator._0939_ VGND
+ VGND VPWR VPWR accumulator._0940_ sky130_fd_sc_hd__o21a_1
XFILLER_0_0_293 VGND VGND VPWR VPWR sky130_fd_sc_hd__decap_4
XFILLER_0_13_355 VGND VGND VPWR VPWR sky130_fd_sc_hd__decap_8
XFILLER_0_13_366 VPWR VGND VPWR VGND sky130_ef_sc_hd__decap_12
Xaccumulator._2328_ accumulator._0366_ VGND VGND VPWR VPWR accumulator._0279_ sky130_fd_sc_hd__inv_2
XTAP_TAPCELL_ROW_28_339 VGND VPWR sky130_fd_sc_hd__tapvpwrvgnd_1
Xaccumulator._2259_ accumulator._1065_ VGND VGND VPWR VPWR accumulator._0211_ sky130_fd_sc_hd__inv_2
XFILLER_0_63_233 VGND VGND VPWR VPWR sky130_fd_sc_hd__decap_3
XFILLER_0_63_200 VPWR VGND VPWR VGND sky130_ef_sc_hd__decap_12
XFILLER_0_52_27 VGND VGND VPWR VPWR sky130_fd_sc_hd__fill_1
XFILLER_0_39_241 VGND VGND VPWR VPWR sky130_fd_sc_hd__fill_1
XFILLER_0_39_285 VGND VGND VPWR VPWR sky130_fd_sc_hd__fill_1
XFILLER_0_22_130 VGND VGND VPWR VPWR sky130_fd_sc_hd__decap_4
Xaccumulator._1561_ accumulator._0551_ accumulator._0655_ VGND VGND VPWR VPWR accumulator._0656_
+ sky130_fd_sc_hd__or2_1
Xaccumulator._1630_ accumulator.io_accOut\[2\] accumulator._0457_ accumulator._0653_
+ accumulator._0724_ VGND VGND VPWR VPWR accumulator._0725_ sky130_fd_sc_hd__a31o_1
XFILLER_0_26_83 VGND VGND VPWR VPWR sky130_fd_sc_hd__fill_1
XFILLER_0_26_61 VGND VGND VPWR VPWR sky130_fd_sc_hd__decap_4
Xaccumulator._1492_ accumulator._0547_ accumulator._0550_ accumulator._0500_ VGND
+ VGND VPWR VPWR accumulator._0587_ sky130_fd_sc_hd__a21o_1
Xaccumulator._2113_ accumulator._0068_ accumulator._1172_ accumulator._0042_ VGND
+ VGND VPWR VPWR accumulator._0069_ sky130_fd_sc_hd__mux2_4
Xaccumulator._2044_ accumulator._1132_ accumulator._1137_ accumulator._1138_ VGND
+ VGND VPWR VPWR accumulator._1139_ sky130_fd_sc_hd__o21ai_1
XFILLER_0_42_60 VGND VGND VPWR VPWR sky130_fd_sc_hd__decap_8
XTAP_TAPCELL_ROW_33_375 VGND VPWR sky130_fd_sc_hd__tapvpwrvgnd_1
XFILLER_0_60_236 VGND VGND VPWR VPWR sky130_fd_sc_hd__decap_3
XFILLER_0_13_130 VGND VGND VPWR VPWR sky130_fd_sc_hd__decap_8
XFILLER_0_13_163 VGND VGND VPWR VPWR sky130_fd_sc_hd__decap_4
Xaccumulator._1828_ accumulator._0891_ accumulator._0902_ accumulator._0922_ VGND
+ VGND VPWR VPWR accumulator._0923_ sky130_fd_sc_hd__nand3_1
Xaccumulator._1759_ accumulator.io_accOut\[16\] VGND VGND VPWR VPWR accumulator._0854_
+ sky130_fd_sc_hd__inv_2
XFILLER_0_51_225 VPWR VGND VPWR VGND sky130_ef_sc_hd__decap_12
XscaleAdd._480_ scaleAdd._164_ scaleAdd._173_ VGND VGND VPWR VPWR scaleAdd._174_ sky130_fd_sc_hd__xor2_1
XFILLER_0_63_15 VPWR VGND VPWR VGND sky130_ef_sc_hd__decap_12
XFILLER_0_47_49 VGND VGND VPWR VPWR sky130_fd_sc_hd__decap_6
XFILLER_0_2_29 VPWR VGND VPWR VGND sky130_ef_sc_hd__decap_12
XFILLER_0_59_314 VPWR VGND VPWR VGND sky130_ef_sc_hd__decap_12
XTAP_TAPCELL_ROW_47_478 VGND VPWR sky130_fd_sc_hd__tapvpwrvgnd_1
XFILLER_0_42_225 VGND VGND VPWR VPWR sky130_fd_sc_hd__fill_2
XTAP_TAPCELL_ROW_30_356 VGND VPWR sky130_fd_sc_hd__tapvpwrvgnd_1
XFILLER_0_27_299 VGND VGND VPWR VPWR sky130_fd_sc_hd__fill_1
XFILLER_0_6_138 VGND VGND VPWR VPWR sky130_fd_sc_hd__fill_2
XFILLER_0_6_149 VGND VGND VPWR VPWR sky130_fd_sc_hd__decap_3
XFILLER_0_12_41 VGND VGND VPWR VPWR sky130_fd_sc_hd__decap_4
XFILLER_0_12_63 VGND VGND VPWR VPWR sky130_fd_sc_hd__fill_1
XFILLER_0_12_85 VGND VGND VPWR VPWR sky130_fd_sc_hd__fill_2
XFILLER_0_37_60 VPWR VGND VPWR VGND sky130_ef_sc_hd__decap_12
XFILLER_0_2_388 VPWR VGND VPWR VGND sky130_ef_sc_hd__decap_12
Xaccumulator._1613_ accumulator._0576_ accumulator._0501_ accumulator._0510_ VGND
+ VGND VPWR VPWR accumulator._0708_ sky130_fd_sc_hd__nand3_1
XFILLER_0_10_188 VGND VGND VPWR VPWR sky130_fd_sc_hd__fill_1
Xaccumulator._1544_ accumulator._0590_ accumulator._0593_ accumulator._0421_ VGND
+ VGND VPWR VPWR accumulator._0639_ sky130_fd_sc_hd__a21o_1
XTAP_TAPCELL_ROW_38_412 VGND VPWR sky130_fd_sc_hd__tapvpwrvgnd_1
Xaccumulator._1475_ accumulator._0563_ accumulator._0566_ accumulator._0569_ VGND
+ VGND VPWR VPWR accumulator._0570_ sky130_fd_sc_hd__o21ai_1
XFILLER_0_65_317 VPWR VGND VPWR VGND sky130_ef_sc_hd__decap_12
Xaccumulator._2027_ accumulator._1094_ accumulator._1121_ VGND VGND VPWR VPWR accumulator._1122_
+ sky130_fd_sc_hd__nor2_1
XFILLER_0_33_236 VPWR VGND VPWR VGND sky130_ef_sc_hd__decap_12
XFILLER_0_33_225 VGND VGND VPWR VPWR sky130_fd_sc_hd__decap_4
XFILLER_0_49_391 VGND VGND VPWR VPWR sky130_fd_sc_hd__fill_1
XFILLER_0_24_225 VGND VGND VPWR VPWR sky130_fd_sc_hd__fill_2
XFILLER_0_24_203 VGND VGND VPWR VPWR sky130_fd_sc_hd__fill_1
Xinput16 io_inScaleA[7] VGND VGND VPWR VPWR net16 sky130_fd_sc_hd__clkbuf_2
XFILLER_0_58_15 VPWR VGND VPWR VGND sky130_ef_sc_hd__decap_12
XscaleAdd._463_ operator.io_outExp\[1\] scaleAdd._157_ VGND VGND VPWR VPWR scaleAdd._159_
+ sky130_fd_sc_hd__or2_1
XscaleAdd._394_ scaleAdd._075_ scaleAdd._076_ scaleAdd._078_ VGND VGND VPWR VPWR scaleAdd._098_
+ sky130_fd_sc_hd__o21a_1
XFILLER_0_59_111 VGND VGND VPWR VPWR sky130_fd_sc_hd__fill_1
Xaccumulator._1191_ accumulator.io_inMant\[3\] accumulator.io_inMant\[2\] accumulator._0134_
+ VGND VGND VPWR VPWR accumulator._0144_ sky130_fd_sc_hd__o21a_1
Xaccumulator._1260_ accumulator._0321_ accumulator._0324_ VGND VGND VPWR VPWR accumulator._0357_
+ sky130_fd_sc_hd__and2_1
XFILLER_0_62_309 VPWR VGND VPWR VGND sky130_ef_sc_hd__decap_12
XFILLER_0_55_361 VPWR VGND VPWR VGND sky130_ef_sc_hd__decap_12
XFILLER_0_15_225 VPWR VGND VPWR VGND sky130_ef_sc_hd__decap_12
XFILLER_0_2_141 VPWR VGND VPWR VGND sky130_ef_sc_hd__decap_12
XFILLER_0_54_3 VPWR VGND VPWR VGND sky130_ef_sc_hd__decap_12
XFILLER_0_48_81 VGND VGND VPWR VPWR sky130_fd_sc_hd__decap_3
Xaccumulator._1527_ accumulator._0618_ accumulator._0621_ accumulator._0462_ VGND
+ VGND VPWR VPWR accumulator._0622_ sky130_fd_sc_hd__a21o_1
XFILLER_0_65_136 VGND VGND VPWR VPWR sky130_fd_sc_hd__fill_2
XFILLER_0_65_125 VGND VGND VPWR VPWR sky130_fd_sc_hd__fill_2
XFILLER_0_38_306 VGND VGND VPWR VPWR sky130_fd_sc_hd__fill_2
XscaleAdd._482__58 VGND VGND VPWR VPWR scaleAdd._482__58/HI net58 sky130_fd_sc_hd__conb_1
Xaccumulator._1458_ accumulator._0544_ accumulator._0552_ VGND VGND VPWR VPWR accumulator._0553_
+ sky130_fd_sc_hd__and2_1
Xaccumulator._1389_ accumulator._0425_ accumulator._0483_ accumulator._0418_ VGND
+ VGND VPWR VPWR accumulator._0484_ sky130_fd_sc_hd__a21o_1
XFILLER_0_60_27 VGND VGND VPWR VPWR sky130_fd_sc_hd__fill_1
XFILLER_0_44_309 VGND VGND VPWR VPWR sky130_fd_sc_hd__decap_4
XFILLER_0_37_361 VPWR VGND VPWR VGND sky130_ef_sc_hd__decap_12
Xaccumulator._2361_ clknet_2_0__leaf_clock accumulator._0006_ VGND VGND VPWR VPWR
+ accumulator.io_accOut\[4\] sky130_fd_sc_hd__dfxtp_1
XscaleAdd._446_ scaleAdd._181_ scaleAdd._106_ scaleAdd._124_ scaleAdd._136_ scaleAdd._139_
+ VGND VGND VPWR VPWR scaleAdd._146_ sky130_fd_sc_hd__a32o_1
XscaleAdd._377_ scaleAdd._078_ scaleAdd._079_ scaleAdd._080_ VGND VGND VPWR VPWR scaleAdd._082_
+ sky130_fd_sc_hd__a21oi_1
XFILLER_0_20_261 VGND VGND VPWR VPWR sky130_fd_sc_hd__fill_2
XTAP_TAPCELL_ROW_63_587 VGND VPWR sky130_fd_sc_hd__tapvpwrvgnd_1
Xaccumulator._2292_ accumulator._0047_ accumulator._0234_ accumulator._0242_ VGND
+ VGND VPWR VPWR accumulator._0244_ sky130_fd_sc_hd__and3_1
XPHY_EDGE_ROW_40_Left_108 VGND VGND VPWR VPWR sky130_fd_sc_hd__decap_3
X_17_ accumulator.io_accOut\[17\] VGND VGND VPWR VPWR net31 sky130_fd_sc_hd__buf_1
XFILLER_0_34_94 VPWR VGND VPWR VGND sky130_ef_sc_hd__decap_12
XFILLER_0_34_50 VGND VGND VPWR VPWR sky130_fd_sc_hd__decap_8
XPHY_EDGE_ROW_25_Left_93 VGND VGND VPWR VPWR sky130_fd_sc_hd__decap_3
Xaccumulator._1243_ accumulator._0339_ VGND VGND VPWR VPWR accumulator._0340_ sky130_fd_sc_hd__buf_4
Xaccumulator._1312_ accumulator._0406_ accumulator._0402_ VGND VGND VPWR VPWR accumulator._0407_
+ sky130_fd_sc_hd__nand2_1
XFILLER_0_62_139 VGND VGND VPWR VPWR sky130_fd_sc_hd__fill_1
XFILLER_0_47_158 VGND VGND VPWR VPWR sky130_fd_sc_hd__decap_8
XFILLER_0_28_350 VGND VGND VPWR VPWR sky130_fd_sc_hd__fill_1
XFILLER_0_7_244 VGND VGND VPWR VPWR sky130_fd_sc_hd__fill_1
XFILLER_0_7_277 VGND VGND VPWR VPWR sky130_fd_sc_hd__decap_3
XTAP_TAPCELL_ROW_54_521 VGND VPWR sky130_fd_sc_hd__tapvpwrvgnd_1
Xclone1 accumulator._0376_ VGND VGND VPWR VPWR net59 sky130_fd_sc_hd__buf_6
XTAP_TAPCELL_ROW_3_165 VGND VPWR sky130_fd_sc_hd__tapvpwrvgnd_1
XFILLER_0_53_117 VPWR VGND VPWR VGND sky130_ef_sc_hd__decap_12
XFILLER_0_26_309 VGND VGND VPWR VPWR sky130_fd_sc_hd__decap_6
XFILLER_0_61_194 VGND VGND VPWR VPWR sky130_fd_sc_hd__fill_1
XscaleAdd._300_ scaleAdd._006_ scaleAdd._007_ VGND VGND VPWR VPWR accumulator.io_inMant\[6\]
+ sky130_fd_sc_hd__xnor2_2
XFILLER_0_55_27 VGND VGND VPWR VPWR sky130_fd_sc_hd__decap_4
XTAP_TAPCELL_ROW_17_267 VGND VPWR sky130_fd_sc_hd__tapvpwrvgnd_1
XTAP_TAPCELL_ROW_60_568 VGND VPWR sky130_fd_sc_hd__tapvpwrvgnd_1
Xaccumulator._1930_ accumulator._1020_ accumulator._1024_ VGND VGND VPWR VPWR accumulator._1025_
+ sky130_fd_sc_hd__xor2_2
XFILLER_0_44_139 VGND VGND VPWR VPWR sky130_fd_sc_hd__fill_1
XFILLER_0_29_169 VGND VGND VPWR VPWR sky130_fd_sc_hd__decap_3
XFILLER_0_29_147 VGND VGND VPWR VPWR sky130_fd_sc_hd__fill_2
XFILLER_0_4_225 VGND VGND VPWR VPWR sky130_fd_sc_hd__decap_8
XFILLER_0_40_389 VGND VGND VPWR VPWR sky130_fd_sc_hd__decap_8
XFILLER_0_40_356 VGND VGND VPWR VPWR sky130_fd_sc_hd__decap_8
XscaleAdd._429_ scaleAdd._190_ scaleAdd._092_ scaleAdd._114_ scaleAdd._130_ VGND VGND
+ VPWR VPWR scaleAdd._131_ sky130_fd_sc_hd__a31oi_2
Xaccumulator._1792_ accumulator._0768_ accumulator._0538_ VGND VGND VPWR VPWR accumulator._0887_
+ sky130_fd_sc_hd__nand2_1
Xaccumulator._1861_ accumulator._0833_ accumulator._0835_ accumulator._0917_ accumulator._0838_
+ VGND VGND VPWR VPWR accumulator._0956_ sky130_fd_sc_hd__a211o_1
XFILLER_0_20_85 VGND VGND VPWR VPWR sky130_fd_sc_hd__fill_1
Xaccumulator._2344_ accumulator._0274_ accumulator._0278_ accumulator._0287_ accumulator._0288_
+ accumulator._0292_ VGND VGND VPWR VPWR accumulator._0295_ sky130_fd_sc_hd__a311o_1
XFILLER_0_17_3 VPWR VGND VPWR VGND sky130_ef_sc_hd__decap_12
XFILLER_0_67_209 VPWR VGND VPWR VGND sky130_ef_sc_hd__decap_12
XTAP_TAPCELL_ROW_51_502 VGND VPWR sky130_fd_sc_hd__tapvpwrvgnd_1
Xaccumulator._2275_ accumulator.io_accOut\[22\] VGND VGND VPWR VPWR accumulator._0227_
+ sky130_fd_sc_hd__inv_2
XTAP_TAPCELL_ROW_0_146 VGND VPWR sky130_fd_sc_hd__tapvpwrvgnd_1
Xaccumulator._1226_ accumulator._0212_ accumulator._0281_ accumulator._0313_ accumulator._0251_
+ VGND VGND VPWR VPWR accumulator._0323_ sky130_fd_sc_hd__a31o_1
XFILLER_0_43_183 VPWR VGND VPWR VGND sky130_ef_sc_hd__decap_12
XTAP_TAPCELL_ROW_8_202 VGND VPWR sky130_fd_sc_hd__tapvpwrvgnd_1
XFILLER_0_9_93 VPWR VGND VPWR VGND sky130_ef_sc_hd__decap_12
XFILLER_0_58_209 VGND VGND VPWR VPWR sky130_fd_sc_hd__decap_4
XFILLER_0_66_253 VPWR VGND VPWR VGND sky130_ef_sc_hd__decap_12
XFILLER_0_41_18 VPWR VGND VPWR VGND sky130_ef_sc_hd__decap_12
XFILLER_0_66_15 VPWR VGND VPWR VGND sky130_ef_sc_hd__decap_12
XFILLER_0_22_389 VPWR VGND VPWR VGND sky130_ef_sc_hd__decap_12
Xaccumulator._2060_ accumulator._1155_ accumulator._1099_ accumulator._1097_ VGND
+ VGND VPWR VPWR accumulator._1156_ sky130_fd_sc_hd__o21ai_1
XFILLER_0_17_106 VGND VGND VPWR VPWR sky130_fd_sc_hd__decap_6
Xaccumulator._1913_ accumulator._1003_ accumulator._1007_ VGND VGND VPWR VPWR accumulator._1008_
+ sky130_fd_sc_hd__xnor2_1
XFILLER_0_31_95 VGND VGND VPWR VPWR sky130_fd_sc_hd__decap_8
XFILLER_0_25_183 VGND VGND VPWR VPWR sky130_fd_sc_hd__decap_8
Xaccumulator._1844_ accumulator._0873_ accumulator._0874_ accumulator._0938_ VGND
+ VGND VPWR VPWR accumulator._0939_ sky130_fd_sc_hd__a21bo_1
Xaccumulator._1775_ accumulator._0530_ accumulator._0850_ accumulator._0531_ VGND
+ VGND VPWR VPWR accumulator._0870_ sky130_fd_sc_hd__o21ai_1
XFILLER_0_0_272 VGND VGND VPWR VPWR sky130_fd_sc_hd__decap_4
XFILLER_0_13_378 VPWR VGND VPWR VGND sky130_ef_sc_hd__decap_12
Xaccumulator._2258_ accumulator._1128_ accumulator._0185_ VGND VGND VPWR VPWR accumulator._0210_
+ sky130_fd_sc_hd__nor2_1
Xaccumulator._2327_ accumulator._0266_ accumulator._0272_ VGND VGND VPWR VPWR accumulator._0278_
+ sky130_fd_sc_hd__or2_1
XFILLER_0_63_212 VPWR VGND VPWR VGND sky130_ef_sc_hd__decap_12
Xaccumulator._2189_ accumulator._0110_ accumulator._0142_ accumulator._0107_ VGND
+ VGND VPWR VPWR accumulator._0143_ sky130_fd_sc_hd__mux2_4
XFILLER_0_48_253 VPWR VGND VPWR VGND sky130_ef_sc_hd__decap_12
XTAP_TAPCELL_ROW_36_395 VGND VPWR sky130_fd_sc_hd__tapvpwrvgnd_1
Xaccumulator._1209_ accumulator.io_inMant\[5\] accumulator._0305_ accumulator.io_inMant\[6\]
+ VGND VGND VPWR VPWR accumulator._0306_ sky130_fd_sc_hd__o21ba_1
XFILLER_0_31_131 VGND VGND VPWR VPWR sky130_fd_sc_hd__decap_4
XFILLER_0_6_3 VPWR VGND VPWR VGND sky130_ef_sc_hd__decap_12
XPHY_EDGE_ROW_12_Left_80 VGND VGND VPWR VPWR sky130_fd_sc_hd__decap_3
XFILLER_0_36_29 VGND VGND VPWR VPWR sky130_fd_sc_hd__decap_6
XFILLER_0_54_256 VGND VGND VPWR VPWR sky130_fd_sc_hd__fill_2
XFILLER_0_6_309 VGND VGND VPWR VPWR sky130_fd_sc_hd__decap_8
XFILLER_0_22_164 VPWR VGND VPWR VGND sky130_ef_sc_hd__decap_12
Xaccumulator._1560_ accumulator.io_accOut\[7\] accumulator._0498_ accumulator._0653_
+ accumulator._0654_ VGND VGND VPWR VPWR accumulator._0655_ sky130_fd_sc_hd__a31o_1
Xaccumulator._2112_ net56 net103 VGND VGND VPWR VPWR accumulator._0068_ sky130_fd_sc_hd__nand2_1
XFILLER_0_26_40 VGND VGND VPWR VPWR sky130_fd_sc_hd__decap_6
Xaccumulator._1491_ accumulator._0578_ accumulator._0536_ VGND VGND VPWR VPWR accumulator._0586_
+ sky130_fd_sc_hd__or2_2
Xaccumulator._2043_ accumulator._0816_ net56 accumulator._0830_ VGND VGND VPWR VPWR
+ accumulator._1138_ sky130_fd_sc_hd__or3_1
XFILLER_0_42_83 VGND VGND VPWR VPWR sky130_fd_sc_hd__fill_1
XTAP_TAPCELL_ROW_33_376 VGND VPWR sky130_fd_sc_hd__tapvpwrvgnd_1
Xaccumulator._1827_ accumulator._0921_ accumulator._0907_ VGND VGND VPWR VPWR accumulator._0922_
+ sky130_fd_sc_hd__nor2_1
XFILLER_0_45_289 VGND VGND VPWR VPWR sky130_fd_sc_hd__decap_3
Xaccumulator._1758_ accumulator._0787_ accumulator._0614_ VGND VGND VPWR VPWR accumulator._0853_
+ sky130_fd_sc_hd__nor2_1
Xaccumulator._1689_ accumulator._0771_ accumulator._0780_ accumulator._0779_ VGND
+ VGND VPWR VPWR accumulator._0784_ sky130_fd_sc_hd__a21oi_1
XFILLER_0_6_83 VGND VGND VPWR VPWR sky130_fd_sc_hd__fill_1
XFILLER_0_6_94 VPWR VGND VPWR VGND sky130_ef_sc_hd__decap_12
XFILLER_0_51_237 VGND VGND VPWR VPWR sky130_fd_sc_hd__decap_4
XFILLER_0_63_27 VPWR VGND VPWR VGND sky130_ef_sc_hd__decap_12
XFILLER_0_59_337 VPWR VGND VPWR VGND sky130_ef_sc_hd__decap_12
XFILLER_0_59_326 VGND VGND VPWR VPWR sky130_fd_sc_hd__decap_8
XFILLER_0_27_201 VGND VGND VPWR VPWR sky130_fd_sc_hd__fill_2
XFILLER_0_6_106 VPWR VGND VPWR VGND sky130_ef_sc_hd__decap_12
XTAP_TAPCELL_ROW_30_357 VGND VPWR sky130_fd_sc_hd__tapvpwrvgnd_1
XFILLER_0_2_345 VGND VGND VPWR VPWR sky130_fd_sc_hd__fill_2
XFILLER_0_10_123 VGND VGND VPWR VPWR sky130_fd_sc_hd__fill_1
XFILLER_0_37_72 VGND VGND VPWR VPWR sky130_fd_sc_hd__decap_4
Xaccumulator._1612_ accumulator._0657_ accumulator._0658_ VGND VGND VPWR VPWR accumulator._0707_
+ sky130_fd_sc_hd__nand2_1
XFILLER_0_10_167 VGND VGND VPWR VPWR sky130_fd_sc_hd__decap_8
Xaccumulator._1543_ accumulator._0544_ accumulator._0552_ accumulator._0539_ VGND
+ VGND VPWR VPWR accumulator._0638_ sky130_fd_sc_hd__a21o_1
Xaccumulator._1474_ accumulator._0500_ accumulator._0567_ accumulator._0568_ VGND
+ VGND VPWR VPWR accumulator._0569_ sky130_fd_sc_hd__or3_1
XFILLER_0_65_329 VGND VGND VPWR VPWR sky130_fd_sc_hd__decap_6
XFILLER_0_53_93 VGND VGND VPWR VPWR sky130_fd_sc_hd__decap_4
XTAP_TAPCELL_ROW_38_413 VGND VPWR sky130_fd_sc_hd__tapvpwrvgnd_1
Xaccumulator._2026_ accumulator._1120_ VGND VGND VPWR VPWR accumulator._1121_ sky130_fd_sc_hd__buf_2
XFILLER_0_33_248 VGND VGND VPWR VPWR sky130_fd_sc_hd__fill_1
XFILLER_0_56_307 VGND VGND VPWR VPWR sky130_fd_sc_hd__fill_1
XFILLER_0_58_27 VGND VGND VPWR VPWR sky130_fd_sc_hd__fill_1
XscaleAdd._462_ operator.io_outExp\[1\] scaleAdd._157_ VGND VGND VPWR VPWR scaleAdd._158_
+ sky130_fd_sc_hd__nand2_1
Xinput17 io_inScaleB[5] VGND VGND VPWR VPWR net17 sky130_fd_sc_hd__clkbuf_1
XscaleAdd._393_ scaleAdd._093_ scaleAdd._096_ VGND VGND VPWR VPWR scaleAdd._097_ sky130_fd_sc_hd__xnor2_2
Xaccumulator._1190_ accumulator.io_inMant\[5\] accumulator.io_inMant\[4\] VGND VGND
+ VPWR VPWR accumulator._0134_ sky130_fd_sc_hd__nor2_1
XFILLER_0_55_373 VPWR VGND VPWR VGND sky130_ef_sc_hd__decap_12
XFILLER_0_23_63 VPWR VGND VPWR VGND sky130_ef_sc_hd__decap_12
XFILLER_0_15_237 VGND VGND VPWR VPWR sky130_fd_sc_hd__decap_8
XFILLER_0_30_207 VGND VGND VPWR VPWR sky130_fd_sc_hd__decap_8
XFILLER_0_2_197 VPWR VGND VPWR VGND sky130_ef_sc_hd__decap_12
XFILLER_0_2_153 VPWR VGND VPWR VGND sky130_ef_sc_hd__decap_12
XFILLER_0_64_81 VGND VGND VPWR VPWR sky130_fd_sc_hd__decap_3
XFILLER_0_47_3 VGND VGND VPWR VPWR sky130_fd_sc_hd__decap_6
XFILLER_0_3_51 VGND VGND VPWR VPWR sky130_fd_sc_hd__decap_4
Xaccumulator._1526_ net96 accumulator._0620_ accumulator._0498_ VGND VGND VPWR VPWR
+ accumulator._0621_ sky130_fd_sc_hd__a21o_1
Xaccumulator._1457_ accumulator._0547_ accumulator._0550_ accumulator._0551_ VGND
+ VGND VPWR VPWR accumulator._0552_ sky130_fd_sc_hd__a21o_1
XFILLER_0_46_340 VPWR VGND VPWR VGND sky130_ef_sc_hd__decap_12
Xaccumulator._1388_ accumulator.io_accOut\[20\] accumulator._0482_ accumulator._0376_
+ VGND VGND VPWR VPWR accumulator._0483_ sky130_fd_sc_hd__mux2_4
Xaccumulator._2009_ accumulator._0963_ VGND VGND VPWR VPWR accumulator._1104_ sky130_fd_sc_hd__inv_2
XTAP_TAPCELL_ROW_6_185 VGND VPWR sky130_fd_sc_hd__tapvpwrvgnd_1
XFILLER_0_44_29 VPWR VGND VPWR VGND sky130_ef_sc_hd__decap_12
XFILLER_0_56_126 VGND VGND VPWR VPWR sky130_fd_sc_hd__fill_1
XFILLER_0_52_321 VPWR VGND VPWR VGND sky130_ef_sc_hd__decap_12
XFILLER_0_37_373 VGND VGND VPWR VPWR sky130_fd_sc_hd__decap_8
XFILLER_0_8_29 VPWR VGND VPWR VGND sky130_ef_sc_hd__decap_12
XFILLER_0_52_365 VPWR VGND VPWR VGND sky130_ef_sc_hd__decap_12
XscaleAdd._445_ scaleAdd._143_ net97 VGND VGND VPWR VPWR accumulator.io_inMant\[13\]
+ sky130_fd_sc_hd__xnor2_1
Xaccumulator._2291_ accumulator._0047_ accumulator._0234_ accumulator._0242_ VGND
+ VGND VPWR VPWR accumulator._0243_ sky130_fd_sc_hd__a21oi_1
Xaccumulator._2360_ clknet_2_0__leaf_clock accumulator._0005_ VGND VGND VPWR VPWR
+ accumulator.io_accOut\[3\] sky130_fd_sc_hd__dfxtp_1
X_16_ accumulator.io_accOut\[16\] VGND VGND VPWR VPWR net30 sky130_fd_sc_hd__buf_1
XscaleAdd._376_ scaleAdd._078_ scaleAdd._079_ scaleAdd._080_ VGND VGND VPWR VPWR scaleAdd._081_
+ sky130_fd_sc_hd__and3_1
Xaccumulator._1311_ accumulator._0386_ VGND VGND VPWR VPWR accumulator._0406_ sky130_fd_sc_hd__buf_6
XFILLER_0_18_85 VPWR VGND VPWR VGND sky130_ef_sc_hd__decap_12
XTAP_TAPCELL_ROW_63_588 VGND VPWR sky130_fd_sc_hd__tapvpwrvgnd_1
Xaccumulator._1242_ accumulator._0333_ accumulator._0325_ accumulator._0337_ accumulator._0338_
+ VGND VGND VPWR VPWR accumulator._0339_ sky130_fd_sc_hd__o22a_1
XFILLER_0_43_354 VPWR VGND VPWR VGND sky130_ef_sc_hd__decap_12
XFILLER_0_7_289 VGND VGND VPWR VPWR sky130_fd_sc_hd__decap_3
XTAP_TAPCELL_ROW_54_522 VGND VPWR sky130_fd_sc_hd__tapvpwrvgnd_1
XTAP_TAPCELL_ROW_3_166 VGND VPWR sky130_fd_sc_hd__tapvpwrvgnd_1
Xclone2 accumulator._0386_ VGND VGND VPWR VPWR net107 sky130_fd_sc_hd__buf_2
Xaccumulator._1509_ accumulator._0514_ accumulator._0600_ accumulator._0601_ accumulator._0603_
+ VGND VGND VPWR VPWR accumulator._0604_ sky130_fd_sc_hd__a31o_2
XFILLER_0_53_129 VPWR VGND VPWR VGND sky130_ef_sc_hd__decap_12
XFILLER_0_46_181 VPWR VGND VPWR VGND sky130_ef_sc_hd__decap_12
XFILLER_0_38_126 VPWR VGND VPWR VGND sky130_ef_sc_hd__decap_12
XFILLER_0_38_115 VGND VGND VPWR VPWR sky130_fd_sc_hd__fill_1
XFILLER_0_34_321 VPWR VGND VPWR VGND sky130_ef_sc_hd__decap_12
XFILLER_0_19_351 VGND VGND VPWR VPWR sky130_fd_sc_hd__fill_2
XFILLER_0_34_354 VGND VGND VPWR VPWR sky130_fd_sc_hd__decap_4
XTAP_TAPCELL_ROW_17_268 VGND VPWR sky130_fd_sc_hd__tapvpwrvgnd_1
XTAP_TAPCELL_ROW_60_569 VGND VPWR sky130_fd_sc_hd__tapvpwrvgnd_1
XFILLER_0_52_162 VGND VGND VPWR VPWR sky130_fd_sc_hd__fill_1
Xaccumulator._1860_ accumulator._0951_ accumulator._0954_ VGND VGND VPWR VPWR accumulator._0955_
+ sky130_fd_sc_hd__or2_1
XscaleAdd._428_ scaleAdd._113_ scaleAdd._111_ VGND VGND VPWR VPWR scaleAdd._130_ sky130_fd_sc_hd__and2b_1
Xaccumulator._1791_ accumulator._0884_ accumulator._0885_ VGND VGND VPWR VPWR accumulator._0886_
+ sky130_fd_sc_hd__nor2b_2
XscaleAdd._359_ scaleAdd._061_ scaleAdd._062_ scaleAdd._063_ VGND VGND VPWR VPWR scaleAdd._065_
+ sky130_fd_sc_hd__a21o_1
Xaccumulator._2274_ accumulator._0104_ accumulator._0218_ VGND VGND VPWR VPWR accumulator._0226_
+ sky130_fd_sc_hd__or2_1
Xaccumulator._2343_ accumulator._0034_ accumulator._0293_ accumulator._0294_ accumulator._0118_
+ VGND VGND VPWR VPWR accumulator._0031_ sky130_fd_sc_hd__o211a_1
XTAP_TAPCELL_ROW_0_147 VGND VPWR sky130_fd_sc_hd__tapvpwrvgnd_1
XTAP_TAPCELL_ROW_0_136 VGND VPWR sky130_fd_sc_hd__tapvpwrvgnd_1
XTAP_TAPCELL_ROW_51_503 VGND VPWR sky130_fd_sc_hd__tapvpwrvgnd_1
XFILLER_0_28_181 VPWR VGND VPWR VGND sky130_ef_sc_hd__decap_12
XPHY_EDGE_ROW_3_Right_3 VGND VGND VPWR VPWR sky130_fd_sc_hd__decap_3
XFILLER_0_0_41 VPWR VGND VPWR VGND sky130_ef_sc_hd__decap_12
XFILLER_0_0_85 VPWR VGND VPWR VGND sky130_ef_sc_hd__decap_12
Xaccumulator._1225_ accumulator._0314_ accumulator._0085_ VGND VGND VPWR VPWR accumulator._0322_
+ sky130_fd_sc_hd__and2b_1
Xaccumulator._1989_ accumulator._1083_ VGND VGND VPWR VPWR accumulator._1084_ sky130_fd_sc_hd__inv_2
XFILLER_0_43_195 VGND VGND VPWR VPWR sky130_fd_sc_hd__decap_8
XFILLER_0_31_368 VGND VGND VPWR VPWR sky130_fd_sc_hd__decap_8
XFILLER_0_3_281 VGND VGND VPWR VPWR sky130_fd_sc_hd__decap_6
XTAP_TAPCELL_ROW_8_203 VGND VPWR sky130_fd_sc_hd__tapvpwrvgnd_1
XFILLER_0_16_365 VGND VGND VPWR VPWR sky130_fd_sc_hd__decap_4
XFILLER_0_16_398 VGND VGND VPWR VPWR sky130_fd_sc_hd__decap_3
XFILLER_0_66_265 VPWR VGND VPWR VGND sky130_ef_sc_hd__decap_12
XFILLER_0_66_27 VGND VGND VPWR VPWR sky130_fd_sc_hd__fill_1
XFILLER_0_22_346 VGND VGND VPWR VPWR sky130_fd_sc_hd__fill_1
XFILLER_0_9_307 VGND VGND VPWR VPWR sky130_fd_sc_hd__fill_2
XFILLER_0_9_318 VGND VGND VPWR VPWR sky130_fd_sc_hd__fill_1
Xaccumulator._1912_ accumulator._0997_ accumulator._1000_ accumulator._0947_ VGND
+ VGND VPWR VPWR accumulator._1007_ sky130_fd_sc_hd__a21oi_1
Xaccumulator._1843_ accumulator._0787_ accumulator._0614_ accumulator._0856_ VGND
+ VGND VPWR VPWR accumulator._0938_ sky130_fd_sc_hd__or3_1
XFILLER_0_25_173 VGND VGND VPWR VPWR sky130_fd_sc_hd__fill_1
Xaccumulator._1774_ accumulator._0578_ accumulator._0829_ accumulator._0861_ VGND
+ VGND VPWR VPWR accumulator._0869_ sky130_fd_sc_hd__o21ba_1
XFILLER_0_0_251 VGND VGND VPWR VPWR sky130_fd_sc_hd__fill_1
Xaccumulator._2257_ accumulator._0090_ accumulator._1093_ VGND VGND VPWR VPWR accumulator._0209_
+ sky130_fd_sc_hd__and2b_1
Xaccumulator._2326_ accumulator._0276_ accumulator._0277_ VGND VGND VPWR VPWR accumulator._0029_
+ sky130_fd_sc_hd__nor2_1
XTAP_TAPCELL_ROW_36_396 VGND VPWR sky130_fd_sc_hd__tapvpwrvgnd_1
Xaccumulator._1208_ accumulator.io_inMant\[3\] accumulator._0301_ accumulator.io_inMant\[4\]
+ VGND VGND VPWR VPWR accumulator._0305_ sky130_fd_sc_hd__o21ba_1
Xaccumulator._2188_ accumulator._0130_ accumulator._0141_ accumulator._0080_ VGND
+ VGND VPWR VPWR accumulator._0142_ sky130_fd_sc_hd__mux2_2
XFILLER_0_48_265 VPWR VGND VPWR VGND sky130_ef_sc_hd__decap_12
XFILLER_0_52_29 VGND VGND VPWR VPWR sky130_fd_sc_hd__decap_3
XFILLER_0_22_176 VPWR VGND VPWR VGND sky130_ef_sc_hd__decap_12
Xaccumulator._1490_ accumulator._0584_ VGND VGND VPWR VPWR accumulator._0585_ sky130_fd_sc_hd__inv_2
Xaccumulator._2111_ accumulator._1174_ accumulator._0066_ accumulator._0042_ VGND
+ VGND VPWR VPWR accumulator._0067_ sky130_fd_sc_hd__mux2_4
Xaccumulator._2042_ accumulator._0830_ accumulator._1136_ VGND VGND VPWR VPWR accumulator._1137_
+ sky130_fd_sc_hd__xnor2_1
XFILLER_0_26_85 VPWR VGND VPWR VGND sky130_ef_sc_hd__decap_12
XTAP_TAPCELL_ROW_33_377 VGND VPWR sky130_fd_sc_hd__tapvpwrvgnd_1
XFILLER_0_5_310 VGND VGND VPWR VPWR sky130_fd_sc_hd__decap_8
Xaccumulator._1826_ accumulator._0915_ VGND VGND VPWR VPWR accumulator._0921_ sky130_fd_sc_hd__inv_2
Xaccumulator._1757_ accumulator._0532_ accumulator._0851_ VGND VGND VPWR VPWR accumulator._0852_
+ sky130_fd_sc_hd__xnor2_2
XFILLER_0_67_81 VGND VGND VPWR VPWR sky130_fd_sc_hd__decap_3
Xaccumulator._1688_ accumulator._0773_ accumulator._0782_ VGND VGND VPWR VPWR accumulator._0783_
+ sky130_fd_sc_hd__nand2_1
Xaccumulator._2309_ accumulator._0257_ accumulator._0259_ VGND VGND VPWR VPWR accumulator._0260_
+ sky130_fd_sc_hd__or2_1
XFILLER_0_36_224 VGND VGND VPWR VPWR sky130_fd_sc_hd__fill_1
Xrebuffer40 accumulator._0055_ VGND VGND VPWR VPWR net98 sky130_fd_sc_hd__dlygate4sd1_1
XTAP_TAPCELL_ROW_24_311 VGND VPWR sky130_fd_sc_hd__tapvpwrvgnd_1
XFILLER_0_36_257 VGND VGND VPWR VPWR sky130_fd_sc_hd__fill_1
XFILLER_0_63_39 VPWR VGND VPWR VGND sky130_ef_sc_hd__decap_12
XFILLER_0_59_349 VPWR VGND VPWR VGND sky130_ef_sc_hd__decap_12
XFILLER_0_67_393 VGND VGND VPWR VPWR sky130_fd_sc_hd__decap_8
XFILLER_0_42_205 VPWR VGND VPWR VGND sky130_ef_sc_hd__decap_12
XTAP_TAPCELL_ROW_30_358 VGND VPWR sky130_fd_sc_hd__tapvpwrvgnd_1
XFILLER_0_6_118 VPWR VGND VPWR VGND sky130_ef_sc_hd__decap_12
Xaccumulator._1611_ accumulator._0704_ accumulator._0705_ VGND VGND VPWR VPWR accumulator._0706_
+ sky130_fd_sc_hd__nand2_1
XTAP_TAPCELL_ROW_38_414 VGND VPWR sky130_fd_sc_hd__tapvpwrvgnd_1
XFILLER_0_37_40 VPWR VGND VPWR VGND sky130_ef_sc_hd__decap_12
Xaccumulator._1473_ accumulator._0426_ accumulator._0472_ accumulator._0457_ VGND
+ VGND VPWR VPWR accumulator._0568_ sky130_fd_sc_hd__a21oi_1
Xaccumulator._1542_ accumulator._0513_ accumulator._0636_ VGND VGND VPWR VPWR accumulator._0637_
+ sky130_fd_sc_hd__or2_4
Xaccumulator._2025_ accumulator._1095_ accumulator._1119_ accumulator._1092_ VGND
+ VGND VPWR VPWR accumulator._1120_ sky130_fd_sc_hd__a21oi_2
XFILLER_0_18_235 VGND VGND VPWR VPWR sky130_fd_sc_hd__fill_1
XFILLER_0_33_205 VPWR VGND VPWR VGND sky130_ef_sc_hd__decap_12
XFILLER_0_5_173 VGND VGND VPWR VPWR sky130_fd_sc_hd__fill_1
Xaccumulator._1809_ accumulator._0662_ accumulator._0538_ accumulator._0903_ VGND
+ VGND VPWR VPWR accumulator._0904_ sky130_fd_sc_hd__and3_1
XFILLER_0_64_363 VGND VGND VPWR VPWR sky130_fd_sc_hd__fill_1
XFILLER_0_49_393 VGND VGND VPWR VPWR sky130_fd_sc_hd__decap_4
Xinput18 io_inScaleB[6] VGND VGND VPWR VPWR net18 sky130_fd_sc_hd__clkbuf_1
XFILLER_0_58_39 VPWR VGND VPWR VGND sky130_ef_sc_hd__decap_12
XscaleAdd._392_ scaleAdd._094_ scaleAdd._095_ VGND VGND VPWR VPWR scaleAdd._096_ sky130_fd_sc_hd__xor2_1
XscaleAdd._461_ scaleAdd._155_ scaleAdd._156_ VGND VGND VPWR VPWR scaleAdd._157_ sky130_fd_sc_hd__nor2_1
XFILLER_0_20_400 VGND VGND VPWR VPWR sky130_fd_sc_hd__fill_1
XFILLER_0_59_113 VGND VGND VPWR VPWR sky130_fd_sc_hd__decap_6
XTAP_TAPCELL_ROW_43_450 VGND VPWR sky130_fd_sc_hd__tapvpwrvgnd_1
XFILLER_0_55_385 VGND VGND VPWR VPWR sky130_fd_sc_hd__decap_6
XFILLER_0_23_75 VGND VGND VPWR VPWR sky130_fd_sc_hd__decap_4
XFILLER_0_2_121 VPWR VGND VPWR VGND sky130_ef_sc_hd__decap_12
XFILLER_0_2_165 VPWR VGND VPWR VGND sky130_ef_sc_hd__decap_12
Xaccumulator._1525_ accumulator.io_accOut\[8\] accumulator._0619_ net69 VGND VGND
+ VPWR VPWR accumulator._0620_ sky130_fd_sc_hd__mux2_1
Xaccumulator._1387_ accumulator._0335_ accumulator._0477_ accumulator._0481_ VGND
+ VGND VPWR VPWR accumulator._0482_ sky130_fd_sc_hd__a21o_1
Xaccumulator._1456_ accumulator._0461_ VGND VGND VPWR VPWR accumulator._0551_ sky130_fd_sc_hd__buf_2
XFILLER_0_46_352 VPWR VGND VPWR VGND sky130_ef_sc_hd__decap_12
Xaccumulator._2008_ accumulator._0959_ accumulator._1102_ VGND VGND VPWR VPWR accumulator._1103_
+ sky130_fd_sc_hd__xnor2_2
XFILLER_0_14_260 VPWR VGND VPWR VGND sky130_ef_sc_hd__decap_12
XTAP_TAPCELL_ROW_6_186 VGND VPWR sky130_fd_sc_hd__tapvpwrvgnd_1
XTAP_TAPCELL_ROW_57_542 VGND VPWR sky130_fd_sc_hd__tapvpwrvgnd_1
XFILLER_0_60_29 VPWR VGND VPWR VGND sky130_ef_sc_hd__decap_12
XFILLER_0_52_377 VPWR VGND VPWR VGND sky130_ef_sc_hd__decap_12
XFILLER_0_52_333 VPWR VGND VPWR VGND sky130_ef_sc_hd__decap_12
XFILLER_0_12_208 VGND VGND VPWR VPWR sky130_fd_sc_hd__decap_4
XscaleAdd._444_ scaleAdd._134_ scaleAdd._132_ scaleAdd._144_ VGND VGND VPWR VPWR scaleAdd._145_
+ sky130_fd_sc_hd__a21o_1
XscaleAdd._375_ scaleAdd._023_ scaleAdd._042_ scaleAdd._056_ VGND VGND VPWR VPWR scaleAdd._080_
+ sky130_fd_sc_hd__o21ai_1
XFILLER_0_20_285 VPWR VGND VPWR VGND sky130_ef_sc_hd__decap_12
Xaccumulator._2290_ accumulator._0239_ accumulator._0240_ VGND VGND VPWR VPWR accumulator._0242_
+ sky130_fd_sc_hd__nand2_1
X_15_ accumulator.io_accOut\[15\] VGND VGND VPWR VPWR net29 sky130_fd_sc_hd__buf_1
XFILLER_0_26_9 VGND VGND VPWR VPWR sky130_fd_sc_hd__fill_1
Xaccumulator._1310_ accumulator._0404_ accumulator._0394_ VGND VGND VPWR VPWR accumulator._0405_
+ sky130_fd_sc_hd__xnor2_1
Xaccumulator._1241_ accumulator._0329_ accumulator._0334_ accumulator._0336_ VGND
+ VGND VPWR VPWR accumulator._0338_ sky130_fd_sc_hd__a21oi_1
XFILLER_0_18_97 VPWR VGND VPWR VGND sky130_ef_sc_hd__decap_12
XTAP_TAPCELL_ROW_63_589 VGND VPWR sky130_fd_sc_hd__tapvpwrvgnd_1
XFILLER_0_62_108 VGND VGND VPWR VPWR sky130_fd_sc_hd__decap_6
XFILLER_0_50_51 VGND VGND VPWR VPWR sky130_fd_sc_hd__decap_8
XFILLER_0_43_311 VGND VGND VPWR VPWR sky130_fd_sc_hd__decap_8
XFILLER_0_28_363 VGND VGND VPWR VPWR sky130_fd_sc_hd__fill_1
XFILLER_0_43_366 VPWR VGND VPWR VGND sky130_ef_sc_hd__decap_12
XFILLER_0_7_268 VGND VGND VPWR VPWR sky130_fd_sc_hd__fill_1
XFILLER_0_59_93 VGND VGND VPWR VPWR sky130_fd_sc_hd__decap_3
XTAP_TAPCELL_ROW_54_523 VGND VPWR sky130_fd_sc_hd__tapvpwrvgnd_1
Xaccumulator._1439_ accumulator._0533_ VGND VGND VPWR VPWR accumulator._0534_ sky130_fd_sc_hd__buf_2
XTAP_TAPCELL_ROW_3_167 VGND VPWR sky130_fd_sc_hd__tapvpwrvgnd_1
Xaccumulator._1508_ accumulator._0551_ accumulator._0567_ accumulator._0568_ accumulator._0602_
+ accumulator._0511_ VGND VGND VPWR VPWR accumulator._0603_ sky130_fd_sc_hd__o311a_1
XFILLER_0_61_141 VGND VGND VPWR VPWR sky130_fd_sc_hd__decap_3
XFILLER_0_46_193 VGND VGND VPWR VPWR sky130_fd_sc_hd__decap_3
XFILLER_0_38_138 VGND VGND VPWR VPWR sky130_fd_sc_hd__fill_2
XFILLER_0_34_333 VGND VGND VPWR VPWR sky130_fd_sc_hd__fill_2
XFILLER_0_52_141 VPWR VGND VPWR VGND sky130_ef_sc_hd__decap_12
XFILLER_0_25_399 VGND VGND VPWR VPWR sky130_fd_sc_hd__fill_2
Xaccumulator._1790_ accumulator._0538_ accumulator._0577_ accumulator._0883_ VGND
+ VGND VPWR VPWR accumulator._0885_ sky130_fd_sc_hd__a21o_1
XFILLER_0_20_65 VGND VGND VPWR VPWR sky130_fd_sc_hd__fill_2
XscaleAdd._427_ scaleAdd._121_ scaleAdd._128_ VGND VGND VPWR VPWR scaleAdd._129_ sky130_fd_sc_hd__xnor2_2
XscaleAdd._358_ scaleAdd._061_ scaleAdd._062_ scaleAdd._063_ VGND VGND VPWR VPWR scaleAdd._064_
+ sky130_fd_sc_hd__and3_1
Xaccumulator._2273_ accumulator._0219_ accumulator._0225_ accumulator._0118_ VGND
+ VGND VPWR VPWR accumulator._0023_ sky130_fd_sc_hd__o21a_1
XTAP_TAPCELL_ROW_51_504 VGND VPWR sky130_fd_sc_hd__tapvpwrvgnd_1
Xaccumulator._2342_ accumulator.io_accOut\[29\] accumulator._0383_ VGND VGND VPWR
+ VPWR accumulator._0294_ sky130_fd_sc_hd__or2_1
XscaleAdd._289_ scaleAdd._205_ scaleAdd._204_ VGND VGND VPWR VPWR scaleAdd._231_ sky130_fd_sc_hd__and2b_1
XTAP_TAPCELL_ROW_0_148 VGND VPWR sky130_fd_sc_hd__tapvpwrvgnd_1
XTAP_TAPCELL_ROW_0_137 VGND VPWR sky130_fd_sc_hd__tapvpwrvgnd_1
Xaccumulator._1224_ accumulator._0318_ accumulator._0320_ accumulator._0271_ VGND
+ VGND VPWR VPWR accumulator._0321_ sky130_fd_sc_hd__or3_1
XFILLER_0_28_193 VGND VGND VPWR VPWR sky130_fd_sc_hd__decap_3
XFILLER_0_28_171 VGND VGND VPWR VPWR sky130_fd_sc_hd__fill_1
XFILLER_0_0_53 VGND VGND VPWR VPWR sky130_fd_sc_hd__decap_3
XFILLER_0_0_97 VPWR VGND VPWR VGND sky130_ef_sc_hd__decap_12
XFILLER_0_9_51 VGND VGND VPWR VPWR sky130_fd_sc_hd__decap_4
XFILLER_0_16_300 VGND VGND VPWR VPWR sky130_fd_sc_hd__decap_8
Xaccumulator._1988_ accumulator._1082_ accumulator._1078_ VGND VGND VPWR VPWR accumulator._1083_
+ sky130_fd_sc_hd__xor2_4
XTAP_TAPCELL_ROW_8_204 VGND VPWR sky130_fd_sc_hd__tapvpwrvgnd_1
XFILLER_0_66_277 VPWR VGND VPWR VGND sky130_ef_sc_hd__decap_12
XFILLER_0_30_380 VGND VGND VPWR VPWR sky130_fd_sc_hd__fill_2
XFILLER_0_57_200 VGND VGND VPWR VPWR sky130_fd_sc_hd__decap_4
XPHY_EDGE_ROW_13_Right_13 VGND VGND VPWR VPWR sky130_fd_sc_hd__decap_3
XFILLER_0_31_64 VPWR VGND VPWR VGND sky130_ef_sc_hd__decap_12
XPHY_EDGE_ROW_22_Right_22 VGND VGND VPWR VPWR sky130_fd_sc_hd__decap_3
Xaccumulator._1911_ accumulator._0852_ accumulator._1005_ VGND VGND VPWR VPWR accumulator._1006_
+ sky130_fd_sc_hd__xnor2_2
Xaccumulator._1842_ accumulator._0914_ VGND VGND VPWR VPWR accumulator._0937_ sky130_fd_sc_hd__inv_2
XFILLER_0_40_188 VGND VGND VPWR VPWR sky130_fd_sc_hd__fill_2
Xaccumulator._1773_ accumulator._0846_ accumulator._0795_ accumulator._0867_ VGND
+ VGND VPWR VPWR accumulator._0868_ sky130_fd_sc_hd__a21o_1
XFILLER_0_21_391 VGND VGND VPWR VPWR sky130_fd_sc_hd__fill_1
XFILLER_0_13_314 VGND VGND VPWR VPWR sky130_fd_sc_hd__fill_1
XFILLER_0_56_61 VPWR VGND VPWR VGND sky130_ef_sc_hd__decap_12
XPHY_EDGE_ROW_37_Left_105 VGND VGND VPWR VPWR sky130_fd_sc_hd__decap_3
XPHY_EDGE_ROW_31_Right_31 VGND VGND VPWR VPWR sky130_fd_sc_hd__decap_3
XFILLER_0_22_3 VGND VGND VPWR VPWR sky130_fd_sc_hd__decap_8
Xaccumulator._2187_ accumulator._1035_ accumulator._1033_ net103 VGND VGND VPWR VPWR
+ accumulator._0141_ sky130_fd_sc_hd__mux2_4
XFILLER_0_48_277 VGND VGND VPWR VPWR sky130_fd_sc_hd__fill_2
XFILLER_0_48_233 VPWR VGND VPWR VGND sky130_ef_sc_hd__decap_12
XPHY_EDGE_ROW_46_Left_114 VGND VGND VPWR VPWR sky130_fd_sc_hd__decap_3
Xaccumulator._2256_ net108 accumulator._0147_ accumulator._0207_ accumulator._0208_
+ accumulator._0118_ VGND VGND VPWR VPWR accumulator._0021_ sky130_fd_sc_hd__o221a_1
Xaccumulator._2325_ net111 accumulator._0384_ accumulator._0381_ VGND VGND VPWR VPWR
+ accumulator._0277_ sky130_fd_sc_hd__o21ai_1
XTAP_TAPCELL_ROW_36_397 VGND VPWR sky130_fd_sc_hd__tapvpwrvgnd_1
Xaccumulator._1207_ accumulator.io_inMant\[2\] accumulator.io_inMant\[1\] VGND VGND
+ VPWR VPWR accumulator._0301_ sky130_fd_sc_hd__and2b_1
XPHY_EDGE_ROW_40_Right_40 VGND VGND VPWR VPWR sky130_fd_sc_hd__decap_3
XFILLER_0_8_363 VGND VGND VPWR VPWR sky130_fd_sc_hd__fill_1
XPHY_EDGE_ROW_55_Left_123 VGND VGND VPWR VPWR sky130_fd_sc_hd__decap_3
XPHY_EDGE_ROW_64_Left_132 VGND VGND VPWR VPWR sky130_fd_sc_hd__decap_3
XFILLER_0_22_188 VGND VGND VPWR VPWR sky130_fd_sc_hd__decap_8
XFILLER_0_22_144 VGND VGND VPWR VPWR sky130_fd_sc_hd__decap_8
Xaccumulator._2110_ accumulator._1097_ accumulator._1149_ net100 VGND VGND VPWR VPWR
+ accumulator._0066_ sky130_fd_sc_hd__mux2_2
Xaccumulator._2041_ accumulator._0919_ accumulator._1132_ VGND VGND VPWR VPWR accumulator._1136_
+ sky130_fd_sc_hd__nor2_1
XFILLER_0_26_97 VPWR VGND VPWR VGND sky130_ef_sc_hd__decap_12
XFILLER_0_9_105 VGND VGND VPWR VPWR sky130_fd_sc_hd__decap_6
XFILLER_0_9_149 VPWR VGND VPWR VGND sky130_ef_sc_hd__decap_12
XFILLER_0_60_228 VGND VGND VPWR VPWR sky130_fd_sc_hd__decap_8
XFILLER_0_60_217 VGND VGND VPWR VPWR sky130_fd_sc_hd__decap_3
XFILLER_0_42_85 VPWR VGND VPWR VGND sky130_ef_sc_hd__decap_12
XTAP_TAPCELL_ROW_33_378 VGND VPWR sky130_fd_sc_hd__tapvpwrvgnd_1
XFILLER_0_5_322 VPWR VGND VPWR VGND sky130_ef_sc_hd__decap_12
XFILLER_0_5_355 VGND VGND VPWR VPWR sky130_fd_sc_hd__decap_6
XFILLER_0_13_111 VGND VGND VPWR VPWR sky130_fd_sc_hd__fill_1
Xaccumulator._1825_ accumulator._0915_ accumulator._0909_ accumulator._0912_ accumulator._0919_
+ VGND VGND VPWR VPWR accumulator._0920_ sky130_fd_sc_hd__a31oi_4
Xaccumulator._1756_ accumulator._0535_ accumulator._0785_ accumulator._0849_ accumulator._0850_
+ VGND VGND VPWR VPWR accumulator._0851_ sky130_fd_sc_hd__o22a_1
XFILLER_0_6_41 VPWR VGND VPWR VGND sky130_ef_sc_hd__decap_12
XFILLER_0_6_85 VGND VGND VPWR VPWR sky130_fd_sc_hd__decap_4
XFILLER_0_13_155 VGND VGND VPWR VPWR sky130_fd_sc_hd__fill_2
Xaccumulator._2308_ accumulator._0249_ accumulator._0234_ accumulator._0242_ net103
+ accumulator._0258_ VGND VGND VPWR VPWR accumulator._0259_ sky130_fd_sc_hd__a41o_1
Xrebuffer41 scaleAdd._147_ VGND VGND VPWR VPWR net99 sky130_fd_sc_hd__dlymetal6s2s_1
Xaccumulator._1687_ accumulator._0781_ VGND VGND VPWR VPWR accumulator._0782_ sky130_fd_sc_hd__inv_2
Xrebuffer30 accumulator._0055_ VGND VGND VPWR VPWR net88 sky130_fd_sc_hd__dlygate4sd1_1
Xaccumulator._2239_ accumulator._0163_ accumulator._0191_ accumulator._0107_ VGND
+ VGND VPWR VPWR accumulator._0192_ sky130_fd_sc_hd__mux2_2
XTAP_TAPCELL_ROW_24_312 VGND VPWR sky130_fd_sc_hd__tapvpwrvgnd_1
XFILLER_0_67_361 VGND VGND VPWR VPWR sky130_fd_sc_hd__decap_3
XFILLER_0_42_217 VGND VGND VPWR VPWR sky130_fd_sc_hd__decap_8
XTAP_TAPCELL_ROW_30_359 VGND VPWR sky130_fd_sc_hd__tapvpwrvgnd_1
XFILLER_0_27_236 VGND VGND VPWR VPWR sky130_fd_sc_hd__fill_1
XFILLER_0_27_225 VGND VGND VPWR VPWR sky130_fd_sc_hd__decap_6
Xaccumulator._1610_ accumulator.io_accOut\[3\] accumulator._0378_ VGND VGND VPWR VPWR
+ accumulator._0705_ sky130_fd_sc_hd__nand2_1
XTAP_TAPCELL_ROW_38_415 VGND VPWR sky130_fd_sc_hd__tapvpwrvgnd_1
XFILLER_0_37_52 VGND VGND VPWR VPWR sky130_fd_sc_hd__decap_4
Xaccumulator._1472_ accumulator._0426_ accumulator._0523_ accumulator._0442_ VGND
+ VGND VPWR VPWR accumulator._0567_ sky130_fd_sc_hd__a21oi_1
Xaccumulator._1541_ accumulator._0408_ accumulator._0405_ VGND VGND VPWR VPWR accumulator._0636_
+ sky130_fd_sc_hd__or2_4
Xaccumulator._2024_ accumulator._1109_ accumulator._1111_ accumulator._1113_ accumulator._1118_
+ VGND VGND VPWR VPWR accumulator._1119_ sky130_fd_sc_hd__or4b_2
XTAP_TAPCELL_ROW_46_470 VGND VPWR sky130_fd_sc_hd__tapvpwrvgnd_1
XFILLER_0_33_217 VGND VGND VPWR VPWR sky130_fd_sc_hd__decap_6
Xaccumulator._1739_ accumulator._0722_ accumulator._0729_ VGND VGND VPWR VPWR accumulator._0834_
+ sky130_fd_sc_hd__nand2_1
Xaccumulator._1808_ accumulator.io_accOut\[22\] accumulator._0522_ accumulator._0388_
+ VGND VGND VPWR VPWR accumulator._0903_ sky130_fd_sc_hd__mux2_1
XFILLER_0_56_309 VGND VGND VPWR VPWR sky130_fd_sc_hd__fill_2
XFILLER_0_49_361 VPWR VGND VPWR VGND sky130_ef_sc_hd__decap_12
Xinput19 io_inScaleB[7] VGND VGND VPWR VPWR net19 sky130_fd_sc_hd__buf_1
XFILLER_0_58_29 VGND VGND VPWR VPWR sky130_fd_sc_hd__decap_6
XFILLER_0_32_283 VPWR VGND VPWR VGND sky130_ef_sc_hd__decap_12
XscaleAdd._391_ scaleAdd._191_ scaleAdd._055_ VGND VGND VPWR VPWR scaleAdd._095_ sky130_fd_sc_hd__nand2_1
XscaleAdd._460_ scaleAdd._148_ scaleAdd._153_ scaleAdd._154_ VGND VGND VPWR VPWR scaleAdd._156_
+ sky130_fd_sc_hd__and3_1
X_31_ accumulator.io_accOut\[31\] VGND VGND VPWR VPWR net47 sky130_fd_sc_hd__buf_1
XFILLER_0_67_191 VGND VGND VPWR VPWR sky130_fd_sc_hd__decap_4
XFILLER_0_59_169 VGND VGND VPWR VPWR sky130_fd_sc_hd__decap_3
XFILLER_0_47_309 VGND VGND VPWR VPWR sky130_fd_sc_hd__fill_1
XFILLER_0_55_397 VGND VGND VPWR VPWR sky130_fd_sc_hd__fill_1
XFILLER_0_2_133 VGND VGND VPWR VPWR sky130_fd_sc_hd__decap_6
Xaccumulator._1524_ accumulator._0427_ accumulator._0105_ accumulator._0476_ VGND
+ VGND VPWR VPWR accumulator._0619_ sky130_fd_sc_hd__and3_1
XFILLER_0_2_177 VPWR VGND VPWR VGND sky130_ef_sc_hd__decap_12
Xaccumulator._1386_ accumulator._0055_ accumulator._0478_ accumulator._0480_ accumulator._0463_
+ VGND VGND VPWR VPWR accumulator._0481_ sky130_fd_sc_hd__o22a_1
Xaccumulator._1455_ accumulator._0490_ accumulator._0549_ accumulator._0457_ VGND
+ VGND VPWR VPWR accumulator._0550_ sky130_fd_sc_hd__a21o_1
Xaccumulator._2007_ accumulator._1022_ accumulator._0955_ VGND VGND VPWR VPWR accumulator._1102_
+ sky130_fd_sc_hd__nand2_1
XFILLER_0_14_272 VGND VGND VPWR VPWR sky130_fd_sc_hd__fill_2
XFILLER_0_14_283 VPWR VGND VPWR VGND sky130_ef_sc_hd__decap_12
XTAP_TAPCELL_ROW_57_543 VGND VPWR sky130_fd_sc_hd__tapvpwrvgnd_1
XTAP_TAPCELL_ROW_6_187 VGND VPWR sky130_fd_sc_hd__tapvpwrvgnd_1
XFILLER_0_56_139 VGND VGND VPWR VPWR sky130_fd_sc_hd__fill_1
XFILLER_0_29_309 VGND VGND VPWR VPWR sky130_fd_sc_hd__fill_2
XFILLER_0_64_172 VPWR VGND VPWR VGND sky130_ef_sc_hd__decap_12
XFILLER_0_52_389 VPWR VGND VPWR VGND sky130_ef_sc_hd__decap_12
XFILLER_0_52_345 VPWR VGND VPWR VGND sky130_ef_sc_hd__decap_12
XscaleAdd._443_ scaleAdd._131_ scaleAdd._129_ VGND VGND VPWR VPWR scaleAdd._144_ sky130_fd_sc_hd__and2b_1
XFILLER_0_20_253 VGND VGND VPWR VPWR sky130_fd_sc_hd__decap_8
XFILLER_0_20_297 VGND VGND VPWR VPWR sky130_fd_sc_hd__decap_8
XscaleAdd._374_ scaleAdd._074_ scaleAdd._029_ scaleAdd._077_ VGND VGND VPWR VPWR scaleAdd._079_
+ sky130_fd_sc_hd__a21o_1
X_14_ accumulator.io_accOut\[14\] VGND VGND VPWR VPWR net28 sky130_fd_sc_hd__buf_1
Xaccumulator._1240_ accumulator._0334_ accumulator._0329_ accumulator._0336_ VGND
+ VGND VPWR VPWR accumulator._0337_ sky130_fd_sc_hd__and3_1
XFILLER_0_18_54 VGND VGND VPWR VPWR sky130_fd_sc_hd__decap_3
XFILLER_0_55_194 VGND VGND VPWR VPWR sky130_fd_sc_hd__decap_4
XFILLER_0_55_150 VGND VGND VPWR VPWR sky130_fd_sc_hd__decap_4
XFILLER_0_50_85 VGND VGND VPWR VPWR sky130_fd_sc_hd__decap_4
XFILLER_0_7_203 VPWR VGND VPWR VGND sky130_ef_sc_hd__decap_12
XFILLER_0_43_378 VPWR VGND VPWR VGND sky130_ef_sc_hd__decap_12
XFILLER_0_52_3 VPWR VGND VPWR VGND sky130_ef_sc_hd__decap_12
XTAP_TAPCELL_ROW_3_168 VGND VPWR sky130_fd_sc_hd__tapvpwrvgnd_1
XFILLER_0_11_286 VPWR VGND VPWR VGND sky130_ef_sc_hd__decap_12
Xaccumulator._1507_ accumulator._0498_ accumulator._0518_ accumulator._0415_ accumulator._0490_
+ VGND VGND VPWR VPWR accumulator._0602_ sky130_fd_sc_hd__or4bb_1
XTAP_TAPCELL_ROW_54_524 VGND VPWR sky130_fd_sc_hd__tapvpwrvgnd_1
Xaccumulator._1438_ accumulator.io_accOut\[31\] accumulator.io_inSign VGND VGND VPWR
+ VPWR accumulator._0533_ sky130_fd_sc_hd__xor2_4
Xaccumulator._1369_ accumulator._0434_ accumulator._0436_ accumulator._0431_ VGND
+ VGND VPWR VPWR accumulator._0464_ sky130_fd_sc_hd__mux2_1
XFILLER_0_53_109 VGND VGND VPWR VPWR sky130_fd_sc_hd__decap_3
XFILLER_0_34_378 VGND VGND VPWR VPWR sky130_fd_sc_hd__fill_1
XFILLER_0_19_364 VGND VGND VPWR VPWR sky130_fd_sc_hd__fill_2
XFILLER_0_29_139 VGND VGND VPWR VPWR sky130_fd_sc_hd__fill_1
XFILLER_0_25_323 VPWR VGND VPWR VGND sky130_ef_sc_hd__decap_12
XFILLER_0_52_186 VGND VGND VPWR VPWR sky130_fd_sc_hd__fill_2
XFILLER_0_52_153 VGND VGND VPWR VPWR sky130_fd_sc_hd__fill_2
XFILLER_0_40_304 VGND VGND VPWR VPWR sky130_fd_sc_hd__decap_4
XPHY_EDGE_ROW_29_Left_97 VGND VGND VPWR VPWR sky130_fd_sc_hd__decap_3
Xaccumulator._2341_ accumulator._0289_ accumulator._0292_ VGND VGND VPWR VPWR accumulator._0293_
+ sky130_fd_sc_hd__xor2_1
XscaleAdd._426_ scaleAdd._126_ scaleAdd._127_ VGND VGND VPWR VPWR scaleAdd._128_ sky130_fd_sc_hd__nor2_1
XscaleAdd._288_ scaleAdd._229_ net81 VGND VGND VPWR VPWR scaleAdd._230_ sky130_fd_sc_hd__xnor2_2
XscaleAdd._357_ scaleAdd._032_ scaleAdd._035_ VGND VGND VPWR VPWR scaleAdd._063_ sky130_fd_sc_hd__or2b_1
XFILLER_0_61_51 VGND VGND VPWR VPWR sky130_fd_sc_hd__decap_4
Xaccumulator._2272_ accumulator.io_accOut\[21\] accumulator._0392_ accumulator._0116_
+ accumulator._0165_ accumulator._0224_ VGND VGND VPWR VPWR accumulator._0225_ sky130_fd_sc_hd__a221o_1
XTAP_TAPCELL_ROW_51_505 VGND VPWR sky130_fd_sc_hd__tapvpwrvgnd_1
XTAP_TAPCELL_ROW_0_149 VGND VPWR sky130_fd_sc_hd__tapvpwrvgnd_1
XTAP_TAPCELL_ROW_0_138 VGND VPWR sky130_fd_sc_hd__tapvpwrvgnd_1
Xaccumulator._1223_ accumulator.io_inExp\[0\] accumulator._0311_ accumulator._0319_
+ VGND VGND VPWR VPWR accumulator._0320_ sky130_fd_sc_hd__o21ai_1
XFILLER_0_43_131 VGND VGND VPWR VPWR sky130_fd_sc_hd__fill_2
XFILLER_0_35_109 VGND VGND VPWR VPWR sky130_fd_sc_hd__decap_3
XFILLER_0_16_378 VPWR VGND VPWR VGND sky130_ef_sc_hd__decap_12
Xaccumulator._1987_ accumulator._1057_ accumulator._1063_ accumulator._0947_ VGND
+ VGND VPWR VPWR accumulator._1082_ sky130_fd_sc_hd__a21o_1
XFILLER_0_31_348 VPWR VGND VPWR VGND sky130_ef_sc_hd__decap_12
XFILLER_0_3_261 VGND VGND VPWR VPWR sky130_fd_sc_hd__decap_3
XTAP_TAPCELL_ROW_8_205 VGND VPWR sky130_fd_sc_hd__tapvpwrvgnd_1
XFILLER_0_66_289 VPWR VGND VPWR VGND sky130_ef_sc_hd__decap_12
XFILLER_0_26_109 VPWR VGND VPWR VGND sky130_ef_sc_hd__decap_12
XFILLER_0_34_197 VGND VGND VPWR VPWR sky130_fd_sc_hd__decap_8
XFILLER_0_19_194 VPWR VGND VPWR VGND sky130_ef_sc_hd__decap_12
XFILLER_0_66_29 VPWR VGND VPWR VGND sky130_ef_sc_hd__decap_12
Xaccumulator._1910_ accumulator._0947_ accumulator._1004_ VGND VGND VPWR VPWR accumulator._1005_
+ sky130_fd_sc_hd__or2_1
XFILLER_0_31_76 VGND VGND VPWR VPWR sky130_fd_sc_hd__decap_4
XFILLER_0_31_54 VGND VGND VPWR VPWR sky130_fd_sc_hd__fill_2
XTAP_TAPCELL_ROW_13_240 VGND VPWR sky130_fd_sc_hd__tapvpwrvgnd_1
Xaccumulator._1841_ accumulator._0923_ accumulator._0935_ VGND VGND VPWR VPWR accumulator._0936_
+ sky130_fd_sc_hd__nor2_1
XFILLER_0_40_156 VGND VGND VPWR VPWR sky130_fd_sc_hd__fill_2
Xaccumulator._1772_ accumulator._0532_ accumulator._0782_ accumulator._0864_ accumulator._0866_
+ VGND VGND VPWR VPWR accumulator._0867_ sky130_fd_sc_hd__or4_1
XscaleAdd._409_ scaleAdd._029_ scaleAdd._092_ scaleAdd._096_ VGND VGND VPWR VPWR scaleAdd._112_
+ sky130_fd_sc_hd__and3_1
XFILLER_0_21_370 VGND VGND VPWR VPWR sky130_fd_sc_hd__fill_2
XFILLER_0_0_286 VGND VGND VPWR VPWR sky130_fd_sc_hd__decap_4
XFILLER_0_0_231 VGND VGND VPWR VPWR sky130_fd_sc_hd__decap_8
XFILLER_0_0_253 VGND VGND VPWR VPWR sky130_fd_sc_hd__fill_2
XFILLER_0_56_73 VGND VGND VPWR VPWR sky130_fd_sc_hd__decap_4
Xaccumulator._2324_ accumulator._0274_ accumulator._0275_ accumulator._0034_ VGND
+ VGND VPWR VPWR accumulator._0276_ sky130_fd_sc_hd__a21oi_1
XFILLER_0_15_3 VPWR VGND VPWR VGND sky130_ef_sc_hd__decap_12
Xaccumulator._2186_ accumulator._0074_ accumulator._0140_ VGND VGND VPWR VPWR accumulator._0012_
+ sky130_fd_sc_hd__nor2_1
XFILLER_0_48_245 VGND VGND VPWR VPWR sky130_fd_sc_hd__fill_2
Xaccumulator._2255_ accumulator._0083_ accumulator._0158_ accumulator._0384_ VGND
+ VGND VPWR VPWR accumulator._0208_ sky130_fd_sc_hd__o21ai_1
XTAP_TAPCELL_ROW_36_398 VGND VPWR sky130_fd_sc_hd__tapvpwrvgnd_1
Xaccumulator._1206_ accumulator.io_inMant\[14\] VGND VGND VPWR VPWR accumulator._0291_
+ sky130_fd_sc_hd__inv_2
XFILLER_0_63_248 VPWR VGND VPWR VGND sky130_ef_sc_hd__decap_12
XFILLER_0_31_156 VGND VGND VPWR VPWR sky130_fd_sc_hd__fill_2
XFILLER_0_39_223 VGND VGND VPWR VPWR sky130_fd_sc_hd__fill_1
XTAP_TAPCELL_ROW_27_332 VGND VPWR sky130_fd_sc_hd__tapvpwrvgnd_1
XFILLER_0_10_307 VGND VGND VPWR VPWR sky130_fd_sc_hd__fill_1
Xaccumulator._2040_ accumulator._1134_ VGND VGND VPWR VPWR accumulator._1135_ sky130_fd_sc_hd__inv_2
XFILLER_0_42_75 VGND VGND VPWR VPWR sky130_fd_sc_hd__decap_8
XFILLER_0_9_139 VGND VGND VPWR VPWR sky130_fd_sc_hd__fill_1
XFILLER_0_53_281 VPWR VGND VPWR VGND sky130_ef_sc_hd__decap_12
XFILLER_0_42_97 VPWR VGND VPWR VGND sky130_ef_sc_hd__decap_12
XTAP_TAPCELL_ROW_33_379 VGND VPWR sky130_fd_sc_hd__tapvpwrvgnd_1
XFILLER_0_5_334 VGND VGND VPWR VPWR sky130_fd_sc_hd__fill_2
XFILLER_0_5_378 VGND VGND VPWR VPWR sky130_fd_sc_hd__fill_1
XFILLER_0_13_167 VGND VGND VPWR VPWR sky130_fd_sc_hd__fill_1
Xaccumulator._1824_ accumulator._0918_ VGND VGND VPWR VPWR accumulator._0919_ sky130_fd_sc_hd__clkbuf_4
Xaccumulator._1686_ accumulator._0779_ accumulator._0780_ VGND VGND VPWR VPWR accumulator._0781_
+ sky130_fd_sc_hd__or2b_1
Xaccumulator._1755_ accumulator._0578_ accumulator._0776_ accumulator._0778_ VGND
+ VGND VPWR VPWR accumulator._0850_ sky130_fd_sc_hd__o21a_1
XFILLER_0_6_53 VPWR VGND VPWR VGND sky130_ef_sc_hd__decap_12
Xaccumulator._2238_ accumulator._0176_ accumulator._0190_ accumulator._0080_ VGND
+ VGND VPWR VPWR accumulator._0191_ sky130_fd_sc_hd__mux2_2
Xaccumulator._2307_ accumulator._0239_ accumulator._0248_ VGND VGND VPWR VPWR accumulator._0258_
+ sky130_fd_sc_hd__and2_1
XTAP_TAPCELL_ROW_49_490 VGND VPWR sky130_fd_sc_hd__tapvpwrvgnd_1
Xrebuffer20 accumulator._0375_ VGND VGND VPWR VPWR net78 sky130_fd_sc_hd__buf_8
Xrebuffer31 accumulator._0241_ VGND VGND VPWR VPWR net89 sky130_fd_sc_hd__clkbuf_2
XPHY_EDGE_ROW_16_Left_84 VGND VGND VPWR VPWR sky130_fd_sc_hd__decap_3
Xaccumulator._2169_ accumulator.io_accOut\[8\] accumulator._1166_ accumulator._0050_
+ accumulator._0116_ accumulator._0123_ VGND VGND VPWR VPWR accumulator._0124_ sky130_fd_sc_hd__a221o_1
XTAP_TAPCELL_ROW_24_313 VGND VPWR sky130_fd_sc_hd__tapvpwrvgnd_1
XFILLER_0_4_3 VPWR VGND VPWR VGND sky130_ef_sc_hd__decap_12
XFILLER_0_12_78 VGND VGND VPWR VPWR sky130_fd_sc_hd__fill_2
XFILLER_0_10_137 VGND VGND VPWR VPWR sky130_fd_sc_hd__decap_3
Xaccumulator._1540_ accumulator._0554_ accumulator._0574_ VGND VGND VPWR VPWR accumulator._0635_
+ sky130_fd_sc_hd__or2_1
Xaccumulator._1471_ accumulator._0564_ accumulator._0565_ VGND VGND VPWR VPWR accumulator._0566_
+ sky130_fd_sc_hd__nand2_1
Xaccumulator._2023_ accumulator._1115_ accumulator._1117_ VGND VGND VPWR VPWR accumulator._1118_
+ sky130_fd_sc_hd__nor2_1
XTAP_TAPCELL_ROW_46_471 VGND VPWR sky130_fd_sc_hd__tapvpwrvgnd_1
XFILLER_0_18_248 VGND VGND VPWR VPWR sky130_fd_sc_hd__decap_4
XFILLER_0_41_251 VGND VGND VPWR VPWR sky130_fd_sc_hd__decap_4
XFILLER_0_33_229 VGND VGND VPWR VPWR sky130_fd_sc_hd__fill_1
Xaccumulator._1807_ accumulator._0900_ accumulator._0901_ VGND VGND VPWR VPWR accumulator._0902_
+ sky130_fd_sc_hd__nor2b_4
Xaccumulator._1669_ accumulator._0583_ accumulator._0763_ VGND VGND VPWR VPWR accumulator._0764_
+ sky130_fd_sc_hd__or2_1
Xaccumulator._1738_ accumulator._0831_ accumulator._0810_ accumulator._0832_ VGND
+ VGND VPWR VPWR accumulator._0833_ sky130_fd_sc_hd__a21o_1
XFILLER_0_49_373 VPWR VGND VPWR VGND sky130_ef_sc_hd__decap_12
XPHY_EDGE_ROW_1_Left_69 VGND VGND VPWR VPWR sky130_fd_sc_hd__decap_3
XFILLER_0_64_365 VPWR VGND VPWR VGND sky130_ef_sc_hd__decap_12
XFILLER_0_64_321 VPWR VGND VPWR VGND sky130_ef_sc_hd__decap_12
XFILLER_0_32_295 VPWR VGND VPWR VGND sky130_ef_sc_hd__decap_12
XscaleAdd._390_ scaleAdd._181_ scaleAdd._022_ VGND VGND VPWR VPWR scaleAdd._094_ sky130_fd_sc_hd__nand2_1
X_30_ accumulator.io_accOut\[30\] VGND VGND VPWR VPWR net46 sky130_fd_sc_hd__clkbuf_1
XFILLER_0_67_181 VGND VGND VPWR VPWR sky130_fd_sc_hd__decap_4
XFILLER_0_55_310 VPWR VGND VPWR VGND sky130_ef_sc_hd__decap_12
XFILLER_0_2_189 VGND VGND VPWR VPWR sky130_fd_sc_hd__decap_6
XFILLER_0_48_96 VPWR VGND VPWR VGND sky130_ef_sc_hd__decap_12
XFILLER_0_48_85 VGND VGND VPWR VPWR sky130_fd_sc_hd__decap_6
Xaccumulator._1454_ accumulator.io_accOut\[11\] accumulator._0548_ net69 VGND VGND
+ VPWR VPWR accumulator._0549_ sky130_fd_sc_hd__mux2_1
Xaccumulator._1523_ net96 accumulator._0592_ accumulator._0473_ VGND VGND VPWR VPWR
+ accumulator._0618_ sky130_fd_sc_hd__a21o_1
XFILLER_0_64_95 VGND VGND VPWR VPWR sky130_fd_sc_hd__decap_3
XFILLER_0_64_73 VGND VGND VPWR VPWR sky130_fd_sc_hd__decap_8
Xaccumulator._1385_ accumulator._0452_ accumulator._0479_ accumulator._0431_ VGND
+ VGND VPWR VPWR accumulator._0480_ sky130_fd_sc_hd__mux2_1
XFILLER_0_61_335 VGND VGND VPWR VPWR sky130_fd_sc_hd__fill_1
Xaccumulator._2006_ accumulator._1097_ accumulator._1100_ VGND VGND VPWR VPWR accumulator._1101_
+ sky130_fd_sc_hd__and2_1
XFILLER_0_46_365 VPWR VGND VPWR VGND sky130_ef_sc_hd__decap_12
XFILLER_0_14_251 VGND VGND VPWR VPWR sky130_fd_sc_hd__fill_1
XTAP_TAPCELL_ROW_57_544 VGND VPWR sky130_fd_sc_hd__tapvpwrvgnd_1
XTAP_TAPCELL_ROW_6_188 VGND VPWR sky130_fd_sc_hd__tapvpwrvgnd_1
XFILLER_0_52_302 VGND VGND VPWR VPWR sky130_fd_sc_hd__fill_2
XFILLER_0_49_181 VGND VGND VPWR VPWR sky130_fd_sc_hd__fill_1
XFILLER_0_64_184 VPWR VGND VPWR VGND sky130_ef_sc_hd__decap_12
XFILLER_0_52_357 VGND VGND VPWR VPWR sky130_fd_sc_hd__decap_6
XscaleAdd._442_ scaleAdd._141_ scaleAdd._142_ VGND VGND VPWR VPWR scaleAdd._143_ sky130_fd_sc_hd__or2b_1
XscaleAdd._373_ scaleAdd._077_ scaleAdd._074_ scaleAdd._029_ VGND VGND VPWR VPWR scaleAdd._078_
+ sky130_fd_sc_hd__nand3_2
XFILLER_0_34_76 VGND VGND VPWR VPWR sky130_fd_sc_hd__decap_3
X_13_ accumulator.io_accOut\[13\] VGND VGND VPWR VPWR net27 sky130_fd_sc_hd__buf_1
XFILLER_0_43_335 VGND VGND VPWR VPWR sky130_fd_sc_hd__fill_1
XFILLER_0_28_365 VPWR VGND VPWR VGND sky130_ef_sc_hd__decap_12
XFILLER_0_28_321 VGND VGND VPWR VPWR sky130_fd_sc_hd__decap_8
XFILLER_0_7_215 VGND VGND VPWR VPWR sky130_fd_sc_hd__decap_4
XFILLER_0_59_73 VPWR VGND VPWR VGND sky130_ef_sc_hd__decap_12
XFILLER_0_11_243 VGND VGND VPWR VPWR sky130_fd_sc_hd__fill_2
XFILLER_0_11_254 VPWR VGND VPWR VGND sky130_ef_sc_hd__decap_12
XFILLER_0_11_298 VGND VGND VPWR VPWR sky130_fd_sc_hd__fill_2
XFILLER_0_45_3 VPWR VGND VPWR VGND sky130_ef_sc_hd__decap_12
Xaccumulator._1437_ accumulator._0530_ accumulator._0531_ VGND VGND VPWR VPWR accumulator._0532_
+ sky130_fd_sc_hd__or2b_2
Xaccumulator._1506_ accumulator._0563_ accumulator._0564_ accumulator._0565_ VGND
+ VGND VPWR VPWR accumulator._0601_ sky130_fd_sc_hd__nand3_1
XTAP_TAPCELL_ROW_3_169 VGND VPWR sky130_fd_sc_hd__tapvpwrvgnd_1
XTAP_TAPCELL_ROW_62_580 VGND VPWR sky130_fd_sc_hd__tapvpwrvgnd_1
XTAP_TAPCELL_ROW_54_525 VGND VPWR sky130_fd_sc_hd__tapvpwrvgnd_1
Xaccumulator._1299_ net71 accumulator._0393_ VGND VGND VPWR VPWR accumulator._0394_
+ sky130_fd_sc_hd__xor2_2
Xaccumulator._1368_ net87 accumulator._0222_ net60 VGND VGND VPWR VPWR accumulator._0463_
+ sky130_fd_sc_hd__o21bai_2
XFILLER_0_19_343 VGND VGND VPWR VPWR sky130_fd_sc_hd__decap_8
XFILLER_0_61_176 VGND VGND VPWR VPWR sky130_fd_sc_hd__fill_2
XFILLER_0_19_376 VGND VGND VPWR VPWR sky130_fd_sc_hd__decap_4
XFILLER_0_25_335 VGND VGND VPWR VPWR sky130_fd_sc_hd__fill_1
XPHY_EDGE_ROW_4_Left_72 VGND VGND VPWR VPWR sky130_fd_sc_hd__decap_3
XscaleAdd._425_ scaleAdd._122_ scaleAdd._123_ scaleAdd._125_ VGND VGND VPWR VPWR scaleAdd._127_
+ sky130_fd_sc_hd__nor3_1
Xaccumulator._2271_ accumulator._0062_ accumulator._0223_ VGND VGND VPWR VPWR accumulator._0224_
+ sky130_fd_sc_hd__nor2_1
Xaccumulator._2340_ accumulator._0286_ accumulator._0290_ VGND VGND VPWR VPWR accumulator._0292_
+ sky130_fd_sc_hd__xnor2_1
XFILLER_0_45_53 VGND VGND VPWR VPWR sky130_fd_sc_hd__decap_3
XscaleAdd._287_ scaleAdd._226_ scaleAdd._228_ VGND VGND VPWR VPWR scaleAdd._229_ sky130_fd_sc_hd__xnor2_2
XscaleAdd._356_ scaleAdd._059_ scaleAdd._060_ scaleAdd._041_ VGND VGND VPWR VPWR scaleAdd._062_
+ sky130_fd_sc_hd__o21ai_1
XTAP_TAPCELL_ROW_51_506 VGND VPWR sky130_fd_sc_hd__tapvpwrvgnd_1
XFILLER_0_45_75 VPWR VGND VPWR VGND sky130_ef_sc_hd__decap_12
XTAP_TAPCELL_ROW_0_139 VGND VPWR sky130_fd_sc_hd__tapvpwrvgnd_1
Xaccumulator._1222_ accumulator._0312_ accumulator._0212_ VGND VGND VPWR VPWR accumulator._0319_
+ sky130_fd_sc_hd__and2_1
XTAP_TAPCELL_ROW_16_260 VGND VPWR sky130_fd_sc_hd__tapvpwrvgnd_1
Xaccumulator._1986_ accumulator._1074_ accumulator._1080_ VGND VGND VPWR VPWR accumulator._1081_
+ sky130_fd_sc_hd__xnor2_4
XFILLER_0_31_305 VGND VGND VPWR VPWR sky130_fd_sc_hd__decap_6
XFILLER_0_9_75 VGND VGND VPWR VPWR sky130_fd_sc_hd__fill_1
XFILLER_0_34_187 VGND VGND VPWR VPWR sky130_fd_sc_hd__decap_3
XFILLER_0_34_176 VGND VGND VPWR VPWR sky130_fd_sc_hd__decap_4
XFILLER_0_30_360 VGND VGND VPWR VPWR sky130_fd_sc_hd__decap_4
XPHY_EDGE_ROW_30_Left_98 VGND VGND VPWR VPWR sky130_fd_sc_hd__decap_3
XFILLER_0_15_390 VGND VGND VPWR VPWR sky130_fd_sc_hd__fill_2
XFILLER_0_57_279 VGND VGND VPWR VPWR sky130_fd_sc_hd__fill_1
XFILLER_0_40_113 VPWR VGND VPWR VGND sky130_ef_sc_hd__decap_12
XFILLER_0_25_165 VGND VGND VPWR VPWR sky130_fd_sc_hd__decap_3
Xaccumulator._1840_ accumulator._0884_ accumulator._0934_ accumulator._0885_ VGND
+ VGND VPWR VPWR accumulator._0935_ sky130_fd_sc_hd__o21ai_1
XscaleAdd._408_ scaleAdd._107_ scaleAdd._110_ VGND VGND VPWR VPWR scaleAdd._111_ sky130_fd_sc_hd__xnor2_2
Xaccumulator._1771_ accumulator._0857_ accumulator._0865_ VGND VGND VPWR VPWR accumulator._0866_
+ sky130_fd_sc_hd__nand2_2
XscaleAdd._339_ net11 scaleAdd._011_ scaleAdd._044_ VGND VGND VPWR VPWR scaleAdd._045_
+ sky130_fd_sc_hd__a21oi_1
XPHY_EDGE_ROW_7_Right_7 VGND VGND VPWR VPWR sky130_fd_sc_hd__decap_3
Xaccumulator._2254_ accumulator._1092_ accumulator._0143_ accumulator._1121_ accumulator._0206_
+ VGND VGND VPWR VPWR accumulator._0207_ sky130_fd_sc_hd__o22a_1
Xaccumulator._2323_ accumulator._0265_ accumulator._0262_ accumulator._0273_ VGND
+ VGND VPWR VPWR accumulator._0275_ sky130_fd_sc_hd__nand3_1
Xaccumulator._2185_ accumulator._0070_ accumulator._0114_ accumulator._0138_ accumulator._0062_
+ accumulator._0139_ VGND VGND VPWR VPWR accumulator._0140_ sky130_fd_sc_hd__o221a_1
XFILLER_0_48_213 VGND VGND VPWR VPWR sky130_fd_sc_hd__fill_1
XTAP_TAPCELL_ROW_36_399 VGND VPWR sky130_fd_sc_hd__tapvpwrvgnd_1
XFILLER_0_8_365 VGND VGND VPWR VPWR sky130_fd_sc_hd__fill_2
Xaccumulator._1205_ accumulator._0271_ VGND VGND VPWR VPWR accumulator._0281_ sky130_fd_sc_hd__inv_2
Xaccumulator._1969_ accumulator._0947_ accumulator._1063_ VGND VGND VPWR VPWR accumulator._1064_
+ sky130_fd_sc_hd__nor2_2
XFILLER_0_31_135 VGND VGND VPWR VPWR sky130_fd_sc_hd__fill_1
XFILLER_0_12_371 VGND VGND VPWR VPWR sky130_fd_sc_hd__decap_6
XFILLER_0_12_382 VPWR VGND VPWR VGND sky130_ef_sc_hd__decap_12
XTAP_TAPCELL_ROW_27_333 VGND VPWR sky130_fd_sc_hd__tapvpwrvgnd_1
XFILLER_0_30_190 VGND VGND VPWR VPWR sky130_fd_sc_hd__decap_6
XFILLER_0_53_293 VPWR VGND VPWR VGND sky130_ef_sc_hd__decap_12
XFILLER_0_53_260 VGND VGND VPWR VPWR sky130_fd_sc_hd__decap_8
Xaccumulator._1823_ accumulator._0917_ VGND VGND VPWR VPWR accumulator._0918_ sky130_fd_sc_hd__buf_2
Xaccumulator._1754_ accumulator._0535_ accumulator._0848_ VGND VGND VPWR VPWR accumulator._0849_
+ sky130_fd_sc_hd__nand2_1
Xaccumulator._1685_ accumulator._0777_ accumulator._0778_ VGND VGND VPWR VPWR accumulator._0780_
+ sky130_fd_sc_hd__or2_1
XFILLER_0_6_65 VPWR VGND VPWR VGND sky130_ef_sc_hd__decap_12
Xaccumulator._2237_ accumulator._1052_ accumulator._1050_ accumulator._0047_ VGND
+ VGND VPWR VPWR accumulator._0190_ sky130_fd_sc_hd__mux2_2
Xaccumulator._2306_ accumulator._0253_ accumulator._0256_ VGND VGND VPWR VPWR accumulator._0257_
+ sky130_fd_sc_hd__xor2_1
XTAP_TAPCELL_ROW_49_491 VGND VPWR sky130_fd_sc_hd__tapvpwrvgnd_1
Xrebuffer21 accumulator._0375_ VGND VGND VPWR VPWR net79 sky130_fd_sc_hd__buf_6
XTAP_TAPCELL_ROW_24_314 VGND VPWR sky130_fd_sc_hd__tapvpwrvgnd_1
Xrebuffer32 accumulator._0241_ VGND VGND VPWR VPWR net90 sky130_fd_sc_hd__dlygate4sd1_1
Xrebuffer10 net83 VGND VGND VPWR VPWR net68 sky130_fd_sc_hd__clkbuf_2
Xaccumulator._2168_ accumulator._0062_ accumulator._0122_ VGND VGND VPWR VPWR accumulator._0123_
+ sky130_fd_sc_hd__nor2_1
Xaccumulator._2099_ accumulator._1100_ accumulator._1097_ net100 VGND VGND VPWR VPWR
+ accumulator._0054_ sky130_fd_sc_hd__mux2_2
XFILLER_0_36_249 VGND VGND VPWR VPWR sky130_fd_sc_hd__decap_3
XFILLER_0_36_216 VGND VGND VPWR VPWR sky130_fd_sc_hd__decap_8
XFILLER_0_29_290 VGND VGND VPWR VPWR sky130_fd_sc_hd__fill_2
XFILLER_0_8_184 VPWR VGND VPWR VGND sky130_ef_sc_hd__decap_12
XFILLER_0_12_190 VGND VGND VPWR VPWR sky130_fd_sc_hd__decap_6
XFILLER_0_23_400 VGND VGND VPWR VPWR sky130_fd_sc_hd__fill_1
Xaccumulator._1470_ accumulator._0426_ accumulator._0441_ accumulator._0457_ VGND
+ VGND VPWR VPWR accumulator._0565_ sky130_fd_sc_hd__a21o_1
Xaccumulator._2022_ accumulator._0972_ accumulator._1116_ VGND VGND VPWR VPWR accumulator._1117_
+ sky130_fd_sc_hd__xnor2_2
XFILLER_0_58_363 VGND VGND VPWR VPWR sky130_fd_sc_hd__fill_1
XFILLER_0_41_274 VGND VGND VPWR VPWR sky130_fd_sc_hd__decap_6
Xaccumulator._1806_ accumulator._0678_ accumulator._0538_ accumulator._0899_ VGND
+ VGND VPWR VPWR accumulator._0901_ sky130_fd_sc_hd__a21o_1
XFILLER_0_1_393 VGND VGND VPWR VPWR sky130_fd_sc_hd__decap_8
Xaccumulator._1668_ accumulator._0761_ accumulator._0762_ VGND VGND VPWR VPWR accumulator._0763_
+ sky130_fd_sc_hd__nand2_1
Xaccumulator._1737_ accumulator._0742_ accumulator._0731_ VGND VGND VPWR VPWR accumulator._0832_
+ sky130_fd_sc_hd__nor2_1
Xaccumulator._1599_ accumulator._0408_ accumulator._0686_ accumulator._0692_ accumulator._0578_
+ accumulator._0693_ VGND VGND VPWR VPWR accumulator._0694_ sky130_fd_sc_hd__a32o_2
XFILLER_0_64_333 VPWR VGND VPWR VGND sky130_ef_sc_hd__decap_12
XFILLER_0_49_385 VGND VGND VPWR VPWR sky130_fd_sc_hd__decap_6
XFILLER_0_64_377 VPWR VGND VPWR VGND sky130_ef_sc_hd__decap_12
XFILLER_0_55_333 VGND VGND VPWR VPWR sky130_fd_sc_hd__decap_3
XFILLER_0_55_322 VGND VGND VPWR VPWR sky130_fd_sc_hd__fill_2
XFILLER_0_23_34 VGND VGND VPWR VPWR sky130_fd_sc_hd__fill_2
XFILLER_0_64_41 VPWR VGND VPWR VGND sky130_ef_sc_hd__decap_12
Xaccumulator._1453_ accumulator._0427_ accumulator._0105_ accumulator._0432_ VGND
+ VGND VPWR VPWR accumulator._0548_ sky130_fd_sc_hd__and3_1
Xaccumulator._1522_ accumulator._0615_ accumulator._0616_ accumulator._0420_ VGND
+ VGND VPWR VPWR accumulator._0617_ sky130_fd_sc_hd__a21o_1
XFILLER_0_3_55 VGND VGND VPWR VPWR sky130_fd_sc_hd__fill_1
XFILLER_0_64_85 VGND VGND VPWR VPWR sky130_fd_sc_hd__fill_1
Xaccumulator._2005_ accumulator._1099_ VGND VGND VPWR VPWR accumulator._1100_ sky130_fd_sc_hd__inv_2
Xaccumulator._1384_ accumulator.io_inMant\[11\] accumulator.io_inMant\[12\] accumulator._0428_
+ VGND VGND VPWR VPWR accumulator._0479_ sky130_fd_sc_hd__mux2_1
XFILLER_0_46_377 VPWR VGND VPWR VGND sky130_ef_sc_hd__decap_12
XTAP_TAPCELL_ROW_57_545 VGND VPWR sky130_fd_sc_hd__tapvpwrvgnd_1
XTAP_TAPCELL_ROW_6_189 VGND VPWR sky130_fd_sc_hd__tapvpwrvgnd_1
XFILLER_0_64_141 VGND VGND VPWR VPWR sky130_fd_sc_hd__fill_1
XFILLER_0_64_130 VGND VGND VPWR VPWR sky130_fd_sc_hd__fill_1
XTAP_TAPCELL_ROW_40_423 VGND VPWR sky130_fd_sc_hd__tapvpwrvgnd_1
XscaleAdd._441_ scaleAdd._126_ scaleAdd._135_ scaleAdd._140_ VGND VGND VPWR VPWR scaleAdd._142_
+ sky130_fd_sc_hd__or3b_1
XscaleAdd._372_ scaleAdd._076_ scaleAdd._075_ VGND VGND VPWR VPWR scaleAdd._077_ sky130_fd_sc_hd__xor2_1
X_12_ accumulator.io_accOut\[12\] VGND VGND VPWR VPWR net26 sky130_fd_sc_hd__buf_1
XFILLER_0_28_377 VPWR VGND VPWR VGND sky130_ef_sc_hd__decap_12
XFILLER_0_59_85 VGND VGND VPWR VPWR sky130_fd_sc_hd__decap_8
Xclkbuf_2_0__f_clock clknet_0_clock VGND VGND VPWR VPWR clknet_2_0__leaf_clock sky130_fd_sc_hd__clkbuf_16
XFILLER_0_11_266 VPWR VGND VPWR VGND sky130_ef_sc_hd__decap_12
XTAP_TAPCELL_ROW_54_526 VGND VPWR sky130_fd_sc_hd__tapvpwrvgnd_1
XFILLER_0_38_3 VPWR VGND VPWR VGND sky130_ef_sc_hd__decap_12
Xaccumulator._1436_ accumulator._0528_ accumulator._0529_ VGND VGND VPWR VPWR accumulator._0531_
+ sky130_fd_sc_hd__or2_1
Xaccumulator._1367_ accumulator._0461_ VGND VGND VPWR VPWR accumulator._0462_ sky130_fd_sc_hd__buf_2
Xaccumulator._1505_ accumulator._0421_ accumulator._0555_ accumulator._0556_ VGND
+ VGND VPWR VPWR accumulator._0600_ sky130_fd_sc_hd__nand3_1
XTAP_TAPCELL_ROW_62_581 VGND VPWR sky130_fd_sc_hd__tapvpwrvgnd_1
Xaccumulator._1298_ accumulator._0368_ accumulator._0367_ VGND VGND VPWR VPWR accumulator._0393_
+ sky130_fd_sc_hd__or2b_1
XFILLER_0_34_303 VGND VGND VPWR VPWR sky130_fd_sc_hd__decap_4
XTAP_TAPCELL_ROW_19_280 VGND VPWR sky130_fd_sc_hd__tapvpwrvgnd_1
XFILLER_0_19_333 VGND VGND VPWR VPWR sky130_fd_sc_hd__decap_3
XFILLER_0_19_399 VGND VGND VPWR VPWR sky130_fd_sc_hd__fill_2
XFILLER_0_61_166 VGND VGND VPWR VPWR sky130_fd_sc_hd__fill_2
XFILLER_0_61_133 VGND VGND VPWR VPWR sky130_fd_sc_hd__decap_8
XFILLER_0_34_358 VGND VGND VPWR VPWR sky130_fd_sc_hd__fill_1
XFILLER_0_37_141 VGND VGND VPWR VPWR sky130_fd_sc_hd__decap_3
XscaleAdd._424_ scaleAdd._122_ scaleAdd._123_ scaleAdd._125_ VGND VGND VPWR VPWR scaleAdd._126_
+ sky130_fd_sc_hd__o21a_1
XscaleAdd._355_ scaleAdd._041_ scaleAdd._059_ scaleAdd._060_ VGND VGND VPWR VPWR scaleAdd._061_
+ sky130_fd_sc_hd__or3_4
Xaccumulator._2270_ accumulator._0060_ accumulator._0191_ accumulator._0221_ VGND
+ VGND VPWR VPWR accumulator._0223_ sky130_fd_sc_hd__a21oi_1
XFILLER_0_45_87 VPWR VGND VPWR VGND sky130_ef_sc_hd__decap_12
XFILLER_0_45_65 VGND VGND VPWR VPWR sky130_fd_sc_hd__decap_3
XFILLER_0_24_9 VGND VGND VPWR VPWR sky130_fd_sc_hd__fill_1
XscaleAdd._286_ net93 scaleAdd._227_ VGND VGND VPWR VPWR scaleAdd._228_ sky130_fd_sc_hd__xnor2_4
Xaccumulator._1221_ accumulator.io_inExp\[0\] accumulator._0311_ VGND VGND VPWR VPWR
+ accumulator._0318_ sky130_fd_sc_hd__and2_1
XFILLER_0_61_97 VGND VGND VPWR VPWR sky130_fd_sc_hd__decap_3
XFILLER_0_61_75 VGND VGND VPWR VPWR sky130_fd_sc_hd__fill_1
XFILLER_0_28_141 VGND VGND VPWR VPWR sky130_fd_sc_hd__decap_4
XTAP_TAPCELL_ROW_16_261 VGND VPWR sky130_fd_sc_hd__tapvpwrvgnd_1
Xaccumulator._1985_ accumulator._0947_ accumulator._1079_ VGND VGND VPWR VPWR accumulator._1080_
+ sky130_fd_sc_hd__nor2_2
XFILLER_0_43_177 VGND VGND VPWR VPWR sky130_fd_sc_hd__decap_3
XFILLER_0_24_391 VGND VGND VPWR VPWR sky130_fd_sc_hd__fill_2
Xaccumulator._1419_ accumulator._0488_ VGND VGND VPWR VPWR accumulator._0514_ sky130_fd_sc_hd__clkbuf_2
XTAP_TAPCELL_ROW_22_297 VGND VPWR sky130_fd_sc_hd__tapvpwrvgnd_1
XFILLER_0_19_130 VGND VGND VPWR VPWR sky130_fd_sc_hd__decap_8
XFILLER_0_30_372 VGND VGND VPWR VPWR sky130_fd_sc_hd__fill_1
XFILLER_0_22_328 VPWR VGND VPWR VGND sky130_ef_sc_hd__decap_12
XFILLER_0_15_79 VGND VGND VPWR VPWR sky130_fd_sc_hd__fill_2
Xaccumulator._1770_ accumulator._0853_ accumulator._0856_ VGND VGND VPWR VPWR accumulator._0865_
+ sky130_fd_sc_hd__nand2_1
XscaleAdd._407_ scaleAdd._095_ scaleAdd._108_ scaleAdd._109_ VGND VGND VPWR VPWR scaleAdd._110_
+ sky130_fd_sc_hd__o21ba_1
XFILLER_0_21_350 VPWR VGND VPWR VGND sky130_ef_sc_hd__decap_12
XFILLER_0_0_266 VGND VGND VPWR VPWR sky130_fd_sc_hd__decap_3
XscaleAdd._338_ scaleAdd._192_ net13 VGND VGND VPWR VPWR scaleAdd._044_ sky130_fd_sc_hd__and2b_1
Xaccumulator._2253_ accumulator._0177_ accumulator._0205_ accumulator._0107_ VGND
+ VGND VPWR VPWR accumulator._0206_ sky130_fd_sc_hd__mux2_2
Xaccumulator._2322_ accumulator._0265_ accumulator._0262_ accumulator._0273_ VGND
+ VGND VPWR VPWR accumulator._0274_ sky130_fd_sc_hd__a21o_1
Xaccumulator._2184_ accumulator.io_accOut\[10\] accumulator._0392_ VGND VGND VPWR
+ VPWR accumulator._0139_ sky130_fd_sc_hd__nand2_1
Xaccumulator._1204_ accumulator._0261_ accumulator._0251_ VGND VGND VPWR VPWR accumulator._0271_
+ sky130_fd_sc_hd__or2_4
XscaleAdd._269_ operator.io_outMant\[1\] scaleAdd._195_ scaleAdd._211_ VGND VGND VPWR
+ VPWR scaleAdd._212_ sky130_fd_sc_hd__and3_1
XFILLER_0_8_388 VGND VGND VPWR VPWR sky130_fd_sc_hd__decap_4
Xaccumulator._1968_ accumulator._1062_ accumulator._1058_ VGND VGND VPWR VPWR accumulator._1063_
+ sky130_fd_sc_hd__nor2_4
Xaccumulator._1899_ accumulator._0765_ accumulator._0989_ accumulator._0534_ VGND
+ VGND VPWR VPWR accumulator._0994_ sky130_fd_sc_hd__a21oi_1
XFILLER_0_31_169 VGND VGND VPWR VPWR sky130_fd_sc_hd__decap_3
XFILLER_0_12_394 VGND VGND VPWR VPWR sky130_fd_sc_hd__decap_6
XFILLER_0_39_258 VPWR VGND VPWR VGND sky130_ef_sc_hd__decap_12
XFILLER_0_39_225 VPWR VGND VPWR VGND sky130_ef_sc_hd__decap_12
XTAP_TAPCELL_ROW_27_334 VGND VPWR sky130_fd_sc_hd__tapvpwrvgnd_1
XPHY_EDGE_ROW_33_Left_101 VGND VGND VPWR VPWR sky130_fd_sc_hd__decap_3
XPHY_EDGE_ROW_42_Left_110 VGND VGND VPWR VPWR sky130_fd_sc_hd__decap_3
XFILLER_0_10_309 VGND VGND VPWR VPWR sky130_fd_sc_hd__fill_2
XFILLER_0_60_209 VGND VGND VPWR VPWR sky130_fd_sc_hd__decap_8
XFILLER_0_67_41 VPWR VGND VPWR VGND sky130_ef_sc_hd__decap_12
XFILLER_0_53_272 VGND VGND VPWR VPWR sky130_fd_sc_hd__decap_8
Xaccumulator._1753_ accumulator._0847_ accumulator._0782_ VGND VGND VPWR VPWR accumulator._0848_
+ sky130_fd_sc_hd__or2_4
Xaccumulator._1822_ accumulator.io_accOut\[31\] accumulator.io_inSign VGND VGND VPWR
+ VPWR accumulator._0917_ sky130_fd_sc_hd__xnor2_2
XFILLER_0_13_147 VGND VGND VPWR VPWR sky130_fd_sc_hd__decap_8
XFILLER_0_13_169 VGND VGND VPWR VPWR sky130_fd_sc_hd__decap_6
XFILLER_0_67_85 VPWR VGND VPWR VGND sky130_ef_sc_hd__decap_12
Xaccumulator._1684_ accumulator._0777_ accumulator._0778_ VGND VGND VPWR VPWR accumulator._0779_
+ sky130_fd_sc_hd__and2_1
XFILLER_0_6_77 VGND VGND VPWR VPWR sky130_fd_sc_hd__decap_6
XFILLER_0_20_3 VPWR VGND VPWR VGND sky130_ef_sc_hd__decap_12
Xaccumulator._2305_ accumulator._1120_ accumulator._0255_ VGND VGND VPWR VPWR accumulator._0256_
+ sky130_fd_sc_hd__xor2_1
Xaccumulator._2167_ accumulator._0087_ accumulator._0121_ net104 VGND VGND VPWR VPWR
+ accumulator._0122_ sky130_fd_sc_hd__mux2_1
XTAP_TAPCELL_ROW_49_492 VGND VPWR sky130_fd_sc_hd__tapvpwrvgnd_1
Xaccumulator._2236_ accumulator._0187_ accumulator._0189_ accumulator._0074_ VGND
+ VGND VPWR VPWR accumulator._0018_ sky130_fd_sc_hd__a21oi_1
Xrebuffer44 accumulator.io_inMant\[14\] VGND VGND VPWR VPWR net102 sky130_fd_sc_hd__dlygate4sd1_1
Xrebuffer33 net90 VGND VGND VPWR VPWR net91 sky130_fd_sc_hd__buf_2
XTAP_TAPCELL_ROW_24_315 VGND VPWR sky130_fd_sc_hd__tapvpwrvgnd_1
Xrebuffer22 scaleAdd._073_ VGND VGND VPWR VPWR net80 sky130_fd_sc_hd__buf_2
Xaccumulator._2098_ accumulator._1140_ accumulator._1173_ accumulator._1171_ VGND
+ VGND VPWR VPWR accumulator._0053_ sky130_fd_sc_hd__mux2_2
XFILLER_0_44_261 VGND VGND VPWR VPWR sky130_fd_sc_hd__decap_8
XTAP_TAPCELL_ROW_32_370 VGND VPWR sky130_fd_sc_hd__tapvpwrvgnd_1
XFILLER_0_8_141 VGND VGND VPWR VPWR sky130_fd_sc_hd__decap_3
XFILLER_0_35_250 VPWR VGND VPWR VGND sky130_ef_sc_hd__decap_12
XFILLER_0_50_253 VPWR VGND VPWR VGND sky130_ef_sc_hd__decap_12
XFILLER_0_2_317 VGND VGND VPWR VPWR sky130_fd_sc_hd__fill_1
XFILLER_0_2_306 VGND VGND VPWR VPWR sky130_fd_sc_hd__fill_2
XFILLER_0_37_99 VGND VGND VPWR VPWR sky130_fd_sc_hd__decap_8
XFILLER_0_37_11 VGND VGND VPWR VPWR sky130_fd_sc_hd__decap_3
Xaccumulator._2021_ accumulator._1022_ accumulator._0968_ VGND VGND VPWR VPWR accumulator._1116_
+ sky130_fd_sc_hd__nand2_1
XFILLER_0_18_217 VGND VGND VPWR VPWR sky130_fd_sc_hd__fill_1
XFILLER_0_26_294 VGND VGND VPWR VPWR sky130_fd_sc_hd__decap_4
Xaccumulator._1736_ accumulator._0811_ accumulator._0741_ accumulator._0830_ accumulator._0822_
+ accumulator._0816_ VGND VGND VPWR VPWR accumulator._0831_ sky130_fd_sc_hd__a2111o_4
Xaccumulator._1805_ accumulator._0678_ accumulator._0538_ accumulator._0899_ VGND
+ VGND VPWR VPWR accumulator._0900_ sky130_fd_sc_hd__and3_1
XFILLER_0_5_199 VPWR VGND VPWR VGND sky130_ef_sc_hd__decap_12
Xaccumulator._1667_ accumulator.io_accOut\[10\] accumulator._0588_ accumulator._0387_
+ VGND VGND VPWR VPWR accumulator._0762_ sky130_fd_sc_hd__mux2_1
Xaccumulator._1598_ accumulator._0405_ accumulator._0536_ accumulator._0608_ accumulator._0610_
+ VGND VGND VPWR VPWR accumulator._0693_ sky130_fd_sc_hd__or4_1
XFILLER_0_64_345 VPWR VGND VPWR VGND sky130_ef_sc_hd__decap_12
XFILLER_0_64_301 VGND VGND VPWR VPWR sky130_fd_sc_hd__decap_6
Xaccumulator._2219_ accumulator._0172_ accumulator._0102_ accumulator._1121_ VGND
+ VGND VPWR VPWR accumulator._0173_ sky130_fd_sc_hd__mux2_1
XFILLER_0_64_389 VPWR VGND VPWR VGND sky130_ef_sc_hd__decap_12
XFILLER_0_32_253 VGND VGND VPWR VPWR sky130_fd_sc_hd__decap_8
Xrebuffer2 net95 VGND VGND VPWR VPWR net60 sky130_fd_sc_hd__dlygate4sd1_1
XFILLER_0_23_220 VGND VGND VPWR VPWR sky130_fd_sc_hd__decap_4
XFILLER_0_23_79 VGND VGND VPWR VPWR sky130_fd_sc_hd__fill_1
XFILLER_0_23_57 VGND VGND VPWR VPWR sky130_fd_sc_hd__decap_3
XFILLER_0_15_209 VPWR VGND VPWR VGND sky130_ef_sc_hd__decap_12
XFILLER_0_23_275 VGND VGND VPWR VPWR sky130_fd_sc_hd__decap_4
XFILLER_0_23_242 VGND VGND VPWR VPWR sky130_fd_sc_hd__fill_1
XFILLER_0_64_53 VGND VGND VPWR VPWR sky130_fd_sc_hd__decap_6
Xaccumulator._1383_ accumulator._0449_ accumulator._0451_ accumulator._0431_ VGND
+ VGND VPWR VPWR accumulator._0478_ sky130_fd_sc_hd__mux2_1
Xaccumulator._1521_ accumulator._0505_ accumulator._0589_ accumulator._0498_ VGND
+ VGND VPWR VPWR accumulator._0616_ sky130_fd_sc_hd__a21o_1
Xaccumulator._1452_ accumulator._0426_ accumulator._0546_ accumulator._0442_ VGND
+ VGND VPWR VPWR accumulator._0547_ sky130_fd_sc_hd__a21o_1
Xaccumulator._2004_ accumulator._0950_ accumulator._1098_ VGND VGND VPWR VPWR accumulator._1099_
+ sky130_fd_sc_hd__xor2_1
XFILLER_0_61_337 VPWR VGND VPWR VGND sky130_ef_sc_hd__decap_12
XFILLER_0_46_389 VGND VGND VPWR VPWR sky130_fd_sc_hd__decap_8
XFILLER_0_14_242 VGND VGND VPWR VPWR sky130_fd_sc_hd__fill_1
Xaccumulator._1719_ accumulator._0576_ accumulator._0713_ accumulator._0813_ VGND
+ VGND VPWR VPWR accumulator._0814_ sky130_fd_sc_hd__a21o_1
XTAP_TAPCELL_ROW_57_546 VGND VPWR sky130_fd_sc_hd__tapvpwrvgnd_1
XPHY_EDGE_ROW_29_Right_29 VGND VGND VPWR VPWR sky130_fd_sc_hd__decap_3
XTAP_TAPCELL_ROW_40_424 VGND VPWR sky130_fd_sc_hd__tapvpwrvgnd_1
XPHY_EDGE_ROW_38_Right_38 VGND VGND VPWR VPWR sky130_fd_sc_hd__decap_3
XFILLER_0_37_389 VGND VGND VPWR VPWR sky130_fd_sc_hd__decap_3
XscaleAdd._440_ scaleAdd._126_ scaleAdd._135_ scaleAdd._140_ VGND VGND VPWR VPWR scaleAdd._141_
+ sky130_fd_sc_hd__o21ba_1
XscaleAdd._371_ scaleAdd._191_ scaleAdd._022_ VGND VGND VPWR VPWR scaleAdd._076_ sky130_fd_sc_hd__nand2_1
XPHY_EDGE_ROW_47_Right_47 VGND VGND VPWR VPWR sky130_fd_sc_hd__decap_3
X_11_ accumulator.io_accOut\[11\] VGND VGND VPWR VPWR net25 sky130_fd_sc_hd__buf_1
XFILLER_0_18_46 VGND VGND VPWR VPWR sky130_fd_sc_hd__decap_8
XFILLER_0_18_79 VGND VGND VPWR VPWR sky130_fd_sc_hd__decap_4
XPHY_EDGE_ROW_56_Right_56 VGND VGND VPWR VPWR sky130_fd_sc_hd__decap_3
XFILLER_0_34_34 VGND VGND VPWR VPWR sky130_fd_sc_hd__decap_3
XFILLER_0_28_389 VGND VGND VPWR VPWR sky130_fd_sc_hd__decap_8
XFILLER_0_11_201 VGND VGND VPWR VPWR sky130_fd_sc_hd__fill_1
XFILLER_0_11_223 VGND VGND VPWR VPWR sky130_fd_sc_hd__fill_1
XPHY_EDGE_ROW_65_Right_65 VGND VGND VPWR VPWR sky130_fd_sc_hd__decap_3
XFILLER_0_11_278 VGND VGND VPWR VPWR sky130_fd_sc_hd__fill_2
Xaccumulator._1504_ accumulator._0595_ accumulator._0598_ VGND VGND VPWR VPWR accumulator._0599_
+ sky130_fd_sc_hd__and2_1
XTAP_TAPCELL_ROW_54_527 VGND VPWR sky130_fd_sc_hd__tapvpwrvgnd_1
XFILLER_0_38_109 VGND VGND VPWR VPWR sky130_fd_sc_hd__decap_6
Xaccumulator._1435_ accumulator._0528_ accumulator._0529_ VGND VGND VPWR VPWR accumulator._0530_
+ sky130_fd_sc_hd__and2_1
Xaccumulator._1366_ accumulator._0459_ accumulator._0460_ VGND VGND VPWR VPWR accumulator._0461_
+ sky130_fd_sc_hd__nor2_1
XTAP_TAPCELL_ROW_19_281 VGND VPWR sky130_fd_sc_hd__tapvpwrvgnd_1
XTAP_TAPCELL_ROW_62_582 VGND VPWR sky130_fd_sc_hd__tapvpwrvgnd_1
Xaccumulator._1297_ accumulator._1166_ VGND VGND VPWR VPWR accumulator._0392_ sky130_fd_sc_hd__buf_2
XFILLER_0_46_197 VGND VGND VPWR VPWR sky130_fd_sc_hd__decap_6
XFILLER_0_37_120 VGND VGND VPWR VPWR sky130_fd_sc_hd__decap_3
XTAP_TAPCELL_ROW_2_160 VGND VPWR sky130_fd_sc_hd__tapvpwrvgnd_1
XFILLER_0_52_178 VGND VGND VPWR VPWR sky130_fd_sc_hd__decap_8
XFILLER_0_40_318 VGND VGND VPWR VPWR sky130_fd_sc_hd__decap_6
XFILLER_0_33_381 VGND VGND VPWR VPWR sky130_fd_sc_hd__fill_1
XFILLER_0_25_337 VPWR VGND VPWR VGND sky130_ef_sc_hd__decap_12
XFILLER_0_20_47 VPWR VGND VPWR VGND sky130_ef_sc_hd__decap_12
XscaleAdd._423_ scaleAdd._108_ scaleAdd._124_ VGND VGND VPWR VPWR scaleAdd._125_ sky130_fd_sc_hd__xor2_1
XFILLER_0_29_78 VPWR VGND VPWR VGND sky130_ef_sc_hd__decap_12
XscaleAdd._285_ scaleAdd._223_ scaleAdd._221_ VGND VGND VPWR VPWR scaleAdd._227_ sky130_fd_sc_hd__or2b_4
XscaleAdd._354_ scaleAdd._056_ scaleAdd._057_ scaleAdd._058_ VGND VGND VPWR VPWR scaleAdd._060_
+ sky130_fd_sc_hd__a21oi_1
XFILLER_0_45_99 VPWR VGND VPWR VGND sky130_ef_sc_hd__decap_12
XFILLER_0_45_33 VGND VGND VPWR VPWR sky130_fd_sc_hd__fill_1
Xaccumulator._1220_ net65 accumulator._0085_ accumulator._0125_ VGND VGND VPWR VPWR
+ accumulator._0317_ sky130_fd_sc_hd__a21o_1
XFILLER_0_43_123 VGND VGND VPWR VPWR sky130_fd_sc_hd__decap_8
XFILLER_0_28_153 VPWR VGND VPWR VGND sky130_ef_sc_hd__decap_12
XFILLER_0_0_57 VPWR VGND VPWR VGND sky130_ef_sc_hd__decap_12
XFILLER_0_16_348 VPWR VGND VPWR VGND sky130_ef_sc_hd__decap_12
Xaccumulator._1984_ accumulator._1078_ accumulator._1063_ accumulator._1057_ VGND
+ VGND VPWR VPWR accumulator._1079_ sky130_fd_sc_hd__and3b_1
XFILLER_0_3_220 VGND VGND VPWR VPWR sky130_fd_sc_hd__decap_4
XFILLER_0_9_55 VGND VGND VPWR VPWR sky130_fd_sc_hd__fill_1
XFILLER_0_50_3 VPWR VGND VPWR VGND sky130_ef_sc_hd__decap_12
Xaccumulator._1349_ accumulator.io_inMant\[1\] accumulator.io_inMant\[2\] accumulator._0311_
+ VGND VGND VPWR VPWR accumulator._0444_ sky130_fd_sc_hd__mux2_1
Xaccumulator._1418_ accumulator._0398_ accumulator._0411_ VGND VGND VPWR VPWR accumulator._0513_
+ sky130_fd_sc_hd__xnor2_4
XFILLER_0_34_134 VGND VGND VPWR VPWR sky130_fd_sc_hd__decap_3
XTAP_TAPCELL_ROW_22_298 VGND VPWR sky130_fd_sc_hd__tapvpwrvgnd_1
XFILLER_0_19_153 VPWR VGND VPWR VGND sky130_ef_sc_hd__decap_12
XFILLER_0_19_175 VGND VGND VPWR VPWR sky130_fd_sc_hd__fill_1
XFILLER_0_65_281 VPWR VGND VPWR VGND sky130_ef_sc_hd__decap_12
XFILLER_0_57_237 VGND VGND VPWR VPWR sky130_fd_sc_hd__decap_4
XFILLER_0_31_46 VGND VGND VPWR VPWR sky130_fd_sc_hd__decap_8
XFILLER_0_40_148 VGND VGND VPWR VPWR sky130_fd_sc_hd__decap_8
XFILLER_0_21_362 VGND VGND VPWR VPWR sky130_fd_sc_hd__decap_8
XFILLER_0_0_223 VGND VGND VPWR VPWR sky130_fd_sc_hd__fill_1
XFILLER_0_0_245 VGND VGND VPWR VPWR sky130_fd_sc_hd__decap_3
XFILLER_0_13_318 VPWR VGND VPWR VGND sky130_ef_sc_hd__decap_12
XFILLER_0_56_98 VPWR VGND VPWR VGND sky130_ef_sc_hd__decap_12
Xaccumulator._2321_ accumulator._0266_ accumulator._0272_ VGND VGND VPWR VPWR accumulator._0273_
+ sky130_fd_sc_hd__xnor2_1
XscaleAdd._406_ scaleAdd._181_ scaleAdd._055_ scaleAdd._074_ scaleAdd._191_ VGND VGND
+ VPWR VPWR scaleAdd._109_ sky130_fd_sc_hd__a22oi_1
XscaleAdd._268_ scaleAdd._209_ scaleAdd._210_ VGND VGND VPWR VPWR scaleAdd._211_ sky130_fd_sc_hd__nor2_1
XscaleAdd._337_ scaleAdd._023_ scaleAdd._042_ VGND VGND VPWR VPWR scaleAdd._043_ sky130_fd_sc_hd__xor2_1
Xaccumulator._2252_ accumulator._0190_ accumulator._0204_ accumulator._0080_ VGND
+ VGND VPWR VPWR accumulator._0205_ sky130_fd_sc_hd__mux2_1
Xaccumulator._2183_ accumulator._0101_ accumulator._0137_ accumulator._1127_ VGND
+ VGND VPWR VPWR accumulator._0138_ sky130_fd_sc_hd__mux2_1
Xaccumulator._1203_ net89 accumulator.io_inExp\[2\] VGND VGND VPWR VPWR accumulator._0261_
+ sky130_fd_sc_hd__nor2_1
XFILLER_0_8_323 VPWR VGND VPWR VGND sky130_ef_sc_hd__decap_12
XFILLER_0_16_101 VPWR VGND VPWR VGND sky130_ef_sc_hd__decap_12
XFILLER_0_16_123 VPWR VGND VPWR VGND sky130_ef_sc_hd__decap_12
Xaccumulator._1967_ accumulator._0886_ accumulator._1061_ VGND VGND VPWR VPWR accumulator._1062_
+ sky130_fd_sc_hd__xnor2_2
Xaccumulator._1898_ accumulator._0752_ accumulator._0844_ accumulator._0984_ accumulator._0791_
+ VGND VGND VPWR VPWR accumulator._0993_ sky130_fd_sc_hd__o31a_1
XFILLER_0_39_237 VGND VGND VPWR VPWR sky130_fd_sc_hd__decap_4
XFILLER_0_39_204 VGND VGND VPWR VPWR sky130_fd_sc_hd__fill_2
XTAP_TAPCELL_ROW_35_390 VGND VPWR sky130_fd_sc_hd__tapvpwrvgnd_1
XTAP_TAPCELL_ROW_27_335 VGND VPWR sky130_fd_sc_hd__tapvpwrvgnd_1
XFILLER_0_62_251 VGND VGND VPWR VPWR sky130_fd_sc_hd__fill_1
XFILLER_0_22_104 VGND VGND VPWR VPWR sky130_fd_sc_hd__decap_8
XTAP_TAPCELL_ROW_10_213 VGND VPWR sky130_fd_sc_hd__tapvpwrvgnd_1
XFILLER_0_26_79 VGND VGND VPWR VPWR sky130_fd_sc_hd__decap_4
XFILLER_0_26_46 VGND VGND VPWR VPWR sky130_fd_sc_hd__fill_1
XFILLER_0_67_53 VGND VGND VPWR VPWR sky130_fd_sc_hd__decap_3
Xaccumulator._1821_ accumulator._0912_ accumulator._0909_ accumulator._0915_ VGND
+ VGND VPWR VPWR accumulator._0916_ sky130_fd_sc_hd__a21o_1
Xaccumulator._1752_ accumulator._0795_ accumulator._0846_ VGND VGND VPWR VPWR accumulator._0847_
+ sky130_fd_sc_hd__and2_4
Xaccumulator._1683_ accumulator.io_accOut\[13\] accumulator._0541_ accumulator._0387_
+ VGND VGND VPWR VPWR accumulator._0778_ sky130_fd_sc_hd__mux2_1
XFILLER_0_6_89 VGND VGND VPWR VPWR sky130_fd_sc_hd__fill_1
XFILLER_0_67_97 VPWR VGND VPWR VGND sky130_ef_sc_hd__decap_12
Xaccumulator._2304_ accumulator.io_accOut\[26\] accumulator._0254_ accumulator._0389_
+ VGND VGND VPWR VPWR accumulator._0255_ sky130_fd_sc_hd__mux2_1
Xrebuffer34 accumulator._0055_ VGND VGND VPWR VPWR net92 sky130_fd_sc_hd__dlygate4sd1_1
Xrebuffer23 scaleAdd._224_ VGND VGND VPWR VPWR net81 sky130_fd_sc_hd__dlymetal6s2s_1
XFILLER_0_13_3 VPWR VGND VPWR VGND sky130_ef_sc_hd__decap_12
Xrebuffer12 accumulator._0325_ VGND VGND VPWR VPWR net70 sky130_fd_sc_hd__dlygate4sd1_1
Xaccumulator._2166_ accumulator._0100_ accumulator._0120_ accumulator._0042_ VGND
+ VGND VPWR VPWR accumulator._0121_ sky130_fd_sc_hd__mux2_1
Xaccumulator._2235_ accumulator._0854_ accumulator._0383_ accumulator._0114_ accumulator._0122_
+ accumulator._0188_ VGND VGND VPWR VPWR accumulator._0189_ sky130_fd_sc_hd__o221a_1
Xaccumulator._2097_ accumulator._0052_ VGND VGND VPWR VPWR accumulator._0002_ sky130_fd_sc_hd__clkbuf_1
XFILLER_0_29_281 VGND VGND VPWR VPWR sky130_fd_sc_hd__decap_4
XTAP_TAPCELL_ROW_24_316 VGND VPWR sky130_fd_sc_hd__tapvpwrvgnd_1
XTAP_TAPCELL_ROW_32_371 VGND VPWR sky130_fd_sc_hd__tapvpwrvgnd_1
XFILLER_0_8_175 VGND VGND VPWR VPWR sky130_fd_sc_hd__decap_3
XFILLER_0_8_197 VGND VGND VPWR VPWR sky130_fd_sc_hd__decap_6
XFILLER_0_67_321 VPWR VGND VPWR VGND sky130_ef_sc_hd__decap_12
XFILLER_0_67_365 VPWR VGND VPWR VGND sky130_ef_sc_hd__decap_12
XFILLER_0_35_262 VPWR VGND VPWR VGND sky130_ef_sc_hd__decap_12
XFILLER_0_12_15 VPWR VGND VPWR VGND sky130_ef_sc_hd__decap_12
XFILLER_0_50_265 VPWR VGND VPWR VGND sky130_ef_sc_hd__decap_12
XFILLER_0_58_365 VPWR VGND VPWR VGND sky130_ef_sc_hd__decap_12
XFILLER_0_58_321 VPWR VGND VPWR VGND sky130_ef_sc_hd__decap_12
XFILLER_0_53_77 VGND VGND VPWR VPWR sky130_fd_sc_hd__decap_3
Xaccumulator._2020_ accumulator._0967_ accumulator._1114_ VGND VGND VPWR VPWR accumulator._1115_
+ sky130_fd_sc_hd__xor2_2
XFILLER_0_41_210 VPWR VGND VPWR VGND sky130_ef_sc_hd__decap_12
Xaccumulator._1804_ accumulator.io_accOut\[21\] accumulator._0471_ accumulator._0388_
+ VGND VGND VPWR VPWR accumulator._0899_ sky130_fd_sc_hd__mux2_1
Xaccumulator._1666_ accumulator._0586_ accumulator._0760_ accumulator._0718_ accumulator._0605_
+ VGND VGND VPWR VPWR accumulator._0761_ sky130_fd_sc_hd__o22ai_1
Xaccumulator._1735_ accumulator._0578_ accumulator._0827_ accumulator._0823_ accumulator._0636_
+ accumulator._0829_ VGND VGND VPWR VPWR accumulator._0830_ sky130_fd_sc_hd__o32ai_4
Xaccumulator._2218_ accumulator._0137_ accumulator._0171_ accumulator._1128_ VGND
+ VGND VPWR VPWR accumulator._0172_ sky130_fd_sc_hd__mux2_2
XPHY_EDGE_ROW_61_Left_129 VGND VGND VPWR VPWR sky130_fd_sc_hd__decap_3
Xaccumulator._1597_ accumulator._0608_ accumulator._0690_ accumulator._0691_ accumulator._0579_
+ VGND VGND VPWR VPWR accumulator._0692_ sky130_fd_sc_hd__o211ai_1
XFILLER_0_64_357 VGND VGND VPWR VPWR sky130_fd_sc_hd__decap_6
Xaccumulator._2149_ accumulator._0102_ accumulator._0103_ accumulator._1121_ VGND
+ VGND VPWR VPWR accumulator._0104_ sky130_fd_sc_hd__mux2_4
XFILLER_0_32_232 VGND VGND VPWR VPWR sky130_fd_sc_hd__decap_3
XFILLER_0_2_3 VPWR VGND VPWR VGND sky130_ef_sc_hd__decap_12
XFILLER_0_67_195 VGND VGND VPWR VPWR sky130_fd_sc_hd__fill_1
XTAP_TAPCELL_ROW_43_444 VGND VPWR sky130_fd_sc_hd__tapvpwrvgnd_1
XFILLER_0_23_25 VGND VGND VPWR VPWR sky130_fd_sc_hd__decap_3
Xrebuffer3 net60 VGND VGND VPWR VPWR net61 sky130_fd_sc_hd__dlygate4sd1_1
XFILLER_0_48_33 VGND VGND VPWR VPWR sky130_fd_sc_hd__fill_1
XFILLER_0_48_11 VGND VGND VPWR VPWR sky130_fd_sc_hd__fill_2
XFILLER_0_47_9 VGND VGND VPWR VPWR sky130_fd_sc_hd__fill_1
Xaccumulator._1520_ accumulator._0505_ accumulator._0549_ accumulator._0473_ VGND
+ VGND VPWR VPWR accumulator._0615_ sky130_fd_sc_hd__a21o_1
Xaccumulator._1382_ accumulator._0475_ accumulator._0476_ accumulator._0463_ VGND
+ VGND VPWR VPWR accumulator._0477_ sky130_fd_sc_hd__mux2_1
Xaccumulator._1451_ accumulator.io_accOut\[12\] accumulator._0545_ accumulator._0376_
+ VGND VGND VPWR VPWR accumulator._0546_ sky130_fd_sc_hd__mux2_2
XFILLER_0_3_57 VPWR VGND VPWR VGND sky130_ef_sc_hd__decap_12
XFILLER_0_61_305 VPWR VGND VPWR VGND sky130_ef_sc_hd__decap_12
Xaccumulator._2003_ accumulator._0831_ accumulator._1022_ VGND VGND VPWR VPWR accumulator._1098_
+ sky130_fd_sc_hd__nand2_1
XFILLER_0_61_349 VPWR VGND VPWR VGND sky130_ef_sc_hd__decap_12
XFILLER_0_14_210 VGND VGND VPWR VPWR sky130_fd_sc_hd__decap_3
Xaccumulator._1649_ accumulator.io_accOut\[2\] accumulator._0378_ accumulator._0719_
+ VGND VGND VPWR VPWR accumulator._0744_ sky130_fd_sc_hd__and3_1
XFILLER_0_1_181 VPWR VGND VPWR VGND sky130_ef_sc_hd__decap_12
Xaccumulator._1718_ accumulator._0514_ accumulator._0563_ accumulator._0735_ accumulator._0513_
+ VGND VGND VPWR VPWR accumulator._0813_ sky130_fd_sc_hd__a31o_1
XTAP_TAPCELL_ROW_57_547 VGND VPWR sky130_fd_sc_hd__tapvpwrvgnd_1
XFILLER_0_64_154 VGND VGND VPWR VPWR sky130_fd_sc_hd__decap_3
XTAP_TAPCELL_ROW_40_425 VGND VPWR sky130_fd_sc_hd__tapvpwrvgnd_1
XFILLER_0_37_335 VGND VGND VPWR VPWR sky130_fd_sc_hd__fill_1
XscaleAdd._370_ scaleAdd._181_ scaleAdd._233_ VGND VGND VPWR VPWR scaleAdd._075_ sky130_fd_sc_hd__nand2_1
XFILLER_0_20_213 VGND VGND VPWR VPWR sky130_fd_sc_hd__fill_1
X_10_ accumulator.io_accOut\[10\] VGND VGND VPWR VPWR net24 sky130_fd_sc_hd__clkbuf_1
XFILLER_0_34_46 VGND VGND VPWR VPWR sky130_fd_sc_hd__fill_1
XFILLER_0_34_13 VGND VGND VPWR VPWR sky130_fd_sc_hd__fill_1
XTAP_TAPCELL_ROW_5_180 VGND VPWR sky130_fd_sc_hd__tapvpwrvgnd_1
XFILLER_0_55_154 VGND VGND VPWR VPWR sky130_fd_sc_hd__fill_1
XFILLER_0_55_110 VGND VGND VPWR VPWR sky130_fd_sc_hd__fill_2
XFILLER_0_34_68 VGND VGND VPWR VPWR sky130_fd_sc_hd__decap_8
XFILLER_0_51_393 VGND VGND VPWR VPWR sky130_fd_sc_hd__decap_4
XFILLER_0_43_327 VGND VGND VPWR VPWR sky130_fd_sc_hd__fill_1
XFILLER_0_11_235 VGND VGND VPWR VPWR sky130_fd_sc_hd__decap_8
Xaccumulator._1434_ accumulator.io_accOut\[14\] accumulator._0507_ accumulator._0388_
+ VGND VGND VPWR VPWR accumulator._0529_ sky130_fd_sc_hd__mux2_1
Xaccumulator._1503_ accumulator._0576_ accumulator._0596_ accumulator._0597_ VGND
+ VGND VPWR VPWR accumulator._0598_ sky130_fd_sc_hd__nand3_1
Xaccumulator._1296_ accumulator._0391_ VGND VGND VPWR VPWR accumulator._0001_ sky130_fd_sc_hd__clkbuf_1
Xaccumulator._1365_ accumulator._0386_ accumulator._0418_ accumulator._0415_ VGND
+ VGND VPWR VPWR accumulator._0460_ sky130_fd_sc_hd__a21oi_1
XFILLER_0_19_302 VGND VGND VPWR VPWR sky130_fd_sc_hd__decap_4
XFILLER_0_19_313 VPWR VGND VPWR VGND sky130_ef_sc_hd__decap_12
XTAP_TAPCELL_ROW_19_282 VGND VPWR sky130_fd_sc_hd__tapvpwrvgnd_1
XTAP_TAPCELL_ROW_62_583 VGND VPWR sky130_fd_sc_hd__tapvpwrvgnd_1
XFILLER_0_61_113 VPWR VGND VPWR VGND sky130_ef_sc_hd__decap_12
XFILLER_0_46_110 VGND VGND VPWR VPWR sky130_fd_sc_hd__decap_3
XTAP_TAPCELL_ROW_2_161 VGND VPWR sky130_fd_sc_hd__tapvpwrvgnd_1
XFILLER_0_52_102 VGND VGND VPWR VPWR sky130_fd_sc_hd__fill_1
XFILLER_0_37_165 VGND VGND VPWR VPWR sky130_fd_sc_hd__decap_3
XFILLER_0_52_113 VPWR VGND VPWR VGND sky130_ef_sc_hd__decap_12
XFILLER_0_33_393 VGND VGND VPWR VPWR sky130_fd_sc_hd__decap_8
XscaleAdd._422_ scaleAdd._191_ scaleAdd._092_ VGND VGND VPWR VPWR scaleAdd._124_ sky130_fd_sc_hd__nand2_1
XFILLER_0_25_349 VPWR VGND VPWR VGND sky130_ef_sc_hd__decap_12
XFILLER_0_20_15 VPWR VGND VPWR VGND sky130_ef_sc_hd__decap_12
XFILLER_0_29_57 VPWR VGND VPWR VGND sky130_ef_sc_hd__decap_12
XscaleAdd._284_ scaleAdd._224_ scaleAdd._192_ scaleAdd._225_ VGND VGND VPWR VPWR scaleAdd._226_
+ sky130_fd_sc_hd__a21oi_4
XscaleAdd._353_ scaleAdd._057_ scaleAdd._056_ scaleAdd._058_ VGND VGND VPWR VPWR scaleAdd._059_
+ sky130_fd_sc_hd__and3_1
XFILLER_0_45_45 VGND VGND VPWR VPWR sky130_fd_sc_hd__decap_8
XFILLER_0_61_55 VGND VGND VPWR VPWR sky130_fd_sc_hd__fill_1
XFILLER_0_43_113 VGND VGND VPWR VPWR sky130_fd_sc_hd__decap_6
XFILLER_0_28_165 VGND VGND VPWR VPWR sky130_fd_sc_hd__decap_6
XFILLER_0_0_69 VPWR VGND VPWR VGND sky130_ef_sc_hd__decap_12
Xaccumulator._1983_ accumulator._0902_ accumulator._1077_ VGND VGND VPWR VPWR accumulator._1078_
+ sky130_fd_sc_hd__xor2_4
XFILLER_0_3_243 VPWR VGND VPWR VGND sky130_ef_sc_hd__decap_12
XTAP_TAPCELL_ROW_67_620 VGND VPWR sky130_fd_sc_hd__tapvpwrvgnd_1
XFILLER_0_43_3 VGND VGND VPWR VPWR sky130_fd_sc_hd__decap_4
Xaccumulator._1417_ accumulator._0501_ accumulator._0510_ accumulator._0511_ VGND
+ VGND VPWR VPWR accumulator._0512_ sky130_fd_sc_hd__a21o_1
XFILLER_0_19_90 VPWR VGND VPWR VGND sky130_ef_sc_hd__decap_12
XFILLER_0_66_249 VGND VGND VPWR VPWR sky130_fd_sc_hd__decap_3
Xaccumulator._1279_ accumulator.io_accOut\[30\] net78 VGND VGND VPWR VPWR accumulator._0376_
+ sky130_fd_sc_hd__xnor2_4
Xaccumulator._1348_ accumulator._0426_ accumulator._0441_ accumulator._0442_ VGND
+ VGND VPWR VPWR accumulator._0443_ sky130_fd_sc_hd__a21o_1
XFILLER_0_19_143 VGND VGND VPWR VPWR sky130_fd_sc_hd__decap_4
XFILLER_0_19_165 VGND VGND VPWR VPWR sky130_fd_sc_hd__decap_3
XFILLER_0_34_157 VGND VGND VPWR VPWR sky130_fd_sc_hd__decap_3
XTAP_TAPCELL_ROW_22_299 VGND VPWR sky130_fd_sc_hd__tapvpwrvgnd_1
XPHY_EDGE_ROW_8_Left_76 VGND VGND VPWR VPWR sky130_fd_sc_hd__decap_3
XFILLER_0_15_15 VPWR VGND VPWR VGND sky130_ef_sc_hd__decap_12
XFILLER_0_65_293 VPWR VGND VPWR VGND sky130_ef_sc_hd__decap_12
XFILLER_0_31_36 VGND VGND VPWR VPWR sky130_fd_sc_hd__fill_2
XFILLER_0_13_308 VGND VGND VPWR VPWR sky130_fd_sc_hd__decap_6
XFILLER_0_40_138 VGND VGND VPWR VPWR sky130_fd_sc_hd__fill_2
XFILLER_0_40_105 VGND VGND VPWR VPWR sky130_fd_sc_hd__fill_1
XscaleAdd._405_ scaleAdd._181_ scaleAdd._074_ VGND VGND VPWR VPWR scaleAdd._108_ sky130_fd_sc_hd__nand2_1
XFILLER_0_21_385 VGND VGND VPWR VPWR sky130_fd_sc_hd__fill_1
XFILLER_0_0_279 VGND VGND VPWR VPWR sky130_fd_sc_hd__fill_1
Xaccumulator._2251_ accumulator._1068_ accumulator._1065_ accumulator._0047_ VGND
+ VGND VPWR VPWR accumulator._0204_ sky130_fd_sc_hd__mux2_2
XFILLER_0_56_77 VGND VGND VPWR VPWR sky130_fd_sc_hd__fill_1
Xaccumulator._2320_ accumulator._0269_ accumulator._0270_ VGND VGND VPWR VPWR accumulator._0272_
+ sky130_fd_sc_hd__and2_1
XscaleAdd._267_ operator.io_outMant\[0\] scaleAdd._207_ scaleAdd._208_ VGND VGND VPWR
+ VPWR scaleAdd._210_ sky130_fd_sc_hd__a21oi_1
XscaleAdd._336_ scaleAdd._191_ scaleAdd._233_ VGND VGND VPWR VPWR scaleAdd._042_ sky130_fd_sc_hd__nand2_1
Xaccumulator._2182_ accumulator._0120_ accumulator._0136_ accumulator._0041_ VGND
+ VGND VPWR VPWR accumulator._0137_ sky130_fd_sc_hd__mux2_2
Xaccumulator._1202_ accumulator._0241_ accumulator.io_inExp\[2\] VGND VGND VPWR VPWR
+ accumulator._0251_ sky130_fd_sc_hd__and2_4
XFILLER_0_8_335 VPWR VGND VPWR VGND sky130_ef_sc_hd__decap_12
Xaccumulator._1966_ accumulator._0919_ accumulator._1054_ accumulator._1060_ VGND
+ VGND VPWR VPWR accumulator._1061_ sky130_fd_sc_hd__o21ai_1
XFILLER_0_8_379 VGND VGND VPWR VPWR sky130_fd_sc_hd__fill_2
XFILLER_0_16_113 VGND VGND VPWR VPWR sky130_fd_sc_hd__decap_3
XFILLER_0_16_135 VGND VGND VPWR VPWR sky130_fd_sc_hd__decap_4
Xaccumulator._1897_ accumulator._0844_ accumulator._0991_ VGND VGND VPWR VPWR accumulator._0992_
+ sky130_fd_sc_hd__xor2_2
XFILLER_0_12_363 VGND VGND VPWR VPWR sky130_fd_sc_hd__fill_1
XTAP_TAPCELL_ROW_27_336 VGND VPWR sky130_fd_sc_hd__tapvpwrvgnd_1
XFILLER_0_47_271 VGND VGND VPWR VPWR sky130_fd_sc_hd__decap_4
XTAP_TAPCELL_ROW_35_391 VGND VPWR sky130_fd_sc_hd__tapvpwrvgnd_1
XTAP_TAPCELL_ROW_10_214 VGND VPWR sky130_fd_sc_hd__tapvpwrvgnd_1
XFILLER_0_22_138 VGND VGND VPWR VPWR sky130_fd_sc_hd__fill_2
XFILLER_0_42_68 VGND VGND VPWR VPWR sky130_fd_sc_hd__fill_1
Xaccumulator._1820_ accumulator._0913_ accumulator._0914_ VGND VGND VPWR VPWR accumulator._0915_
+ sky130_fd_sc_hd__nor2_1
XANTENNA_1 net26 VGND VGND VPWR VPWR sky130_fd_sc_hd__diode_2
XFILLER_0_13_105 VGND VGND VPWR VPWR sky130_fd_sc_hd__decap_6
XFILLER_0_13_138 VGND VGND VPWR VPWR sky130_fd_sc_hd__decap_3
Xaccumulator._1751_ accumulator._0843_ accumulator._0803_ accumulator._0845_ VGND
+ VGND VPWR VPWR accumulator._0846_ sky130_fd_sc_hd__a21o_1
Xaccumulator._1682_ accumulator._0578_ accumulator._0776_ VGND VGND VPWR VPWR accumulator._0777_
+ sky130_fd_sc_hd__nor2_1
Xaccumulator._2234_ accumulator._1166_ accumulator._0158_ accumulator._0050_ VGND
+ VGND VPWR VPWR accumulator._0188_ sky130_fd_sc_hd__or3b_1
Xaccumulator._2303_ accumulator._0358_ VGND VGND VPWR VPWR accumulator._0254_ sky130_fd_sc_hd__inv_2
Xrebuffer13 accumulator._0363_ VGND VGND VPWR VPWR net71 sky130_fd_sc_hd__dlygate4sd1_1
Xrebuffer24 accumulator._0361_ VGND VGND VPWR VPWR net82 sky130_fd_sc_hd__dlygate4sd1_1
Xrebuffer35 scaleAdd._222_ VGND VGND VPWR VPWR net93 sky130_fd_sc_hd__buf_4
XscaleAdd._319_ scaleAdd._024_ scaleAdd._025_ VGND VGND VPWR VPWR scaleAdd._026_ sky130_fd_sc_hd__nand2_1
Xaccumulator._2165_ accumulator._0119_ accumulator._1146_ net100 VGND VGND VPWR VPWR
+ accumulator._0120_ sky130_fd_sc_hd__mux2_1
Xaccumulator._2096_ accumulator._0381_ accumulator._0051_ VGND VGND VPWR VPWR accumulator._0052_
+ sky130_fd_sc_hd__and2_1
XTAP_TAPCELL_ROW_32_372 VGND VPWR sky130_fd_sc_hd__tapvpwrvgnd_1
XTAP_TAPCELL_ROW_24_317 VGND VPWR sky130_fd_sc_hd__tapvpwrvgnd_1
Xaccumulator._1949_ accumulator._0852_ accumulator._1016_ accumulator._1020_ accumulator._1004_
+ VGND VGND VPWR VPWR accumulator._1044_ sky130_fd_sc_hd__or4b_4
XFILLER_0_67_377 VPWR VGND VPWR VGND sky130_ef_sc_hd__decap_12
XFILLER_0_67_333 VGND VGND VPWR VPWR sky130_fd_sc_hd__decap_3
XFILLER_0_35_274 VGND VGND VPWR VPWR sky130_fd_sc_hd__decap_6
XFILLER_0_12_27 VGND VGND VPWR VPWR sky130_fd_sc_hd__fill_1
XFILLER_0_12_49 VGND VGND VPWR VPWR sky130_fd_sc_hd__fill_1
XFILLER_0_50_288 VGND VGND VPWR VPWR sky130_fd_sc_hd__decap_3
XFILLER_0_50_277 VGND VGND VPWR VPWR sky130_fd_sc_hd__decap_8
XTAP_TAPCELL_ROW_38_409 VGND VPWR sky130_fd_sc_hd__tapvpwrvgnd_1
XFILLER_0_58_377 VPWR VGND VPWR VGND sky130_ef_sc_hd__decap_12
XFILLER_0_58_333 VPWR VGND VPWR VGND sky130_ef_sc_hd__decap_12
XFILLER_0_41_222 VGND VGND VPWR VPWR sky130_fd_sc_hd__fill_2
Xaccumulator._1803_ accumulator._0890_ accumulator._0896_ accumulator._0897_ accumulator._0889_
+ VGND VGND VPWR VPWR accumulator._0898_ sky130_fd_sc_hd__a31o_1
XFILLER_0_5_113 VGND VGND VPWR VPWR sky130_fd_sc_hd__decap_3
XFILLER_0_1_341 VGND VGND VPWR VPWR sky130_fd_sc_hd__fill_1
Xaccumulator._1596_ accumulator._0617_ accumulator._0622_ accumulator._0539_ VGND
+ VGND VPWR VPWR accumulator._0691_ sky130_fd_sc_hd__a21o_1
Xaccumulator._1665_ accumulator._0608_ accumulator._0707_ accumulator._0708_ VGND
+ VGND VPWR VPWR accumulator._0760_ sky130_fd_sc_hd__o21a_1
Xaccumulator._1734_ accumulator._0579_ accumulator._0645_ accumulator._0646_ accumulator._0828_
+ VGND VGND VPWR VPWR accumulator._0829_ sky130_fd_sc_hd__a31oi_4
Xaccumulator._2217_ accumulator._0170_ VGND VGND VPWR VPWR accumulator._0171_ sky130_fd_sc_hd__inv_2
Xaccumulator._2079_ accumulator._1025_ VGND VGND VPWR VPWR accumulator._1176_ sky130_fd_sc_hd__inv_2
Xaccumulator._2148_ accumulator._0060_ accumulator._0069_ VGND VGND VPWR VPWR accumulator._0103_
+ sky130_fd_sc_hd__or2_1
XFILLER_0_32_244 VGND VGND VPWR VPWR sky130_fd_sc_hd__decap_8
XFILLER_0_59_119 VGND VGND VPWR VPWR sky130_fd_sc_hd__fill_1
XFILLER_0_67_141 VPWR VGND VPWR VGND sky130_ef_sc_hd__decap_12
XTAP_TAPCELL_ROW_43_445 VGND VPWR sky130_fd_sc_hd__tapvpwrvgnd_1
XFILLER_0_63_391 VGND VGND VPWR VPWR sky130_fd_sc_hd__fill_1
Xrebuffer4 net61 VGND VGND VPWR VPWR net62 sky130_fd_sc_hd__dlymetal6s2s_1
XFILLER_0_23_233 VGND VGND VPWR VPWR sky130_fd_sc_hd__fill_1
XPHY_EDGE_ROW_21_Left_89 VGND VGND VPWR VPWR sky130_fd_sc_hd__decap_3
Xaccumulator._1450_ accumulator._0105_ accumulator._0477_ VGND VGND VPWR VPWR accumulator._0545_
+ sky130_fd_sc_hd__and2_1
XFILLER_0_58_141 VGND VGND VPWR VPWR sky130_fd_sc_hd__decap_4
Xaccumulator._1381_ accumulator.io_inMant\[0\] accumulator._0428_ accumulator._0203_
+ VGND VGND VPWR VPWR accumulator._0476_ sky130_fd_sc_hd__and3_1
XFILLER_0_3_69 VPWR VGND VPWR VGND sky130_ef_sc_hd__decap_12
XFILLER_0_61_317 VPWR VGND VPWR VGND sky130_ef_sc_hd__decap_12
Xaccumulator._2002_ accumulator._0954_ accumulator._1096_ VGND VGND VPWR VPWR accumulator._1097_
+ sky130_fd_sc_hd__xor2_1
XFILLER_0_13_81 VGND VGND VPWR VPWR sky130_fd_sc_hd__decap_6
XFILLER_0_1_193 VPWR VGND VPWR VGND sky130_ef_sc_hd__decap_12
XTAP_TAPCELL_ROW_57_548 VGND VPWR sky130_fd_sc_hd__tapvpwrvgnd_1
Xaccumulator._1648_ accumulator._0731_ accumulator._0741_ accumulator._0742_ VGND
+ VGND VPWR VPWR accumulator._0743_ sky130_fd_sc_hd__o21bai_1
Xaccumulator._1717_ accumulator._0539_ accumulator._0652_ accumulator._0656_ accumulator._0412_
+ accumulator._0659_ VGND VGND VPWR VPWR accumulator._0812_ sky130_fd_sc_hd__a311o_1
Xaccumulator._1579_ accumulator._0500_ accumulator._0641_ accumulator._0673_ accumulator._0488_
+ VGND VGND VPWR VPWR accumulator._0674_ sky130_fd_sc_hd__o211a_1
XFILLER_0_64_111 VGND VGND VPWR VPWR sky130_fd_sc_hd__fill_1
XTAP_TAPCELL_ROW_40_426 VGND VPWR sky130_fd_sc_hd__tapvpwrvgnd_1
XFILLER_0_9_260 VGND VGND VPWR VPWR sky130_fd_sc_hd__decap_4
XFILLER_0_18_15 VPWR VGND VPWR VGND sky130_ef_sc_hd__decap_12
XFILLER_0_34_58 VGND VGND VPWR VPWR sky130_fd_sc_hd__decap_3
XTAP_TAPCELL_ROW_5_181 VGND VPWR sky130_fd_sc_hd__tapvpwrvgnd_1
XFILLER_0_50_68 VPWR VGND VPWR VGND sky130_ef_sc_hd__decap_12
XFILLER_0_28_303 VGND VGND VPWR VPWR sky130_fd_sc_hd__decap_4
XFILLER_0_7_219 VGND VGND VPWR VPWR sky130_fd_sc_hd__fill_1
XFILLER_0_59_99 VPWR VGND VPWR VGND sky130_ef_sc_hd__decap_12
XFILLER_0_59_55 VGND VGND VPWR VPWR sky130_fd_sc_hd__fill_1
XFILLER_0_11_225 VGND VGND VPWR VPWR sky130_fd_sc_hd__decap_4
Xaccumulator._1433_ accumulator._0410_ accumulator._0527_ VGND VGND VPWR VPWR accumulator._0528_
+ sky130_fd_sc_hd__nand2_1
Xaccumulator._1502_ accumulator._0540_ accumulator._0543_ accumulator._0462_ VGND
+ VGND VPWR VPWR accumulator._0597_ sky130_fd_sc_hd__a21o_1
Xaccumulator._1295_ net22 accumulator.state\[0\] VGND VGND VPWR VPWR accumulator._0391_
+ sky130_fd_sc_hd__and2b_1
Xaccumulator._1364_ accumulator._0386_ accumulator._0417_ accumulator._0415_ VGND
+ VGND VPWR VPWR accumulator._0459_ sky130_fd_sc_hd__and3_1
XFILLER_0_19_325 VGND VGND VPWR VPWR sky130_fd_sc_hd__decap_8
XFILLER_0_46_155 VPWR VGND VPWR VGND sky130_ef_sc_hd__decap_12
XFILLER_0_42_350 VPWR VGND VPWR VGND sky130_ef_sc_hd__decap_12
XFILLER_0_6_241 VGND VGND VPWR VPWR sky130_fd_sc_hd__decap_8
XTAP_TAPCELL_ROW_2_162 VGND VPWR sky130_fd_sc_hd__tapvpwrvgnd_1
XFILLER_0_52_125 VGND VGND VPWR VPWR sky130_fd_sc_hd__decap_3
XFILLER_0_37_177 VGND VGND VPWR VPWR sky130_fd_sc_hd__decap_3
XFILLER_0_37_133 VGND VGND VPWR VPWR sky130_fd_sc_hd__decap_8
XFILLER_0_52_158 VGND VGND VPWR VPWR sky130_fd_sc_hd__decap_4
XscaleAdd._421_ scaleAdd._029_ scaleAdd._106_ scaleAdd._110_ VGND VGND VPWR VPWR scaleAdd._123_
+ sky130_fd_sc_hd__and3_1
XscaleAdd._352_ scaleAdd._024_ scaleAdd._025_ scaleAdd._030_ VGND VGND VPWR VPWR scaleAdd._058_
+ sky130_fd_sc_hd__o21ai_1
XFILLER_0_20_27 VGND VGND VPWR VPWR sky130_fd_sc_hd__fill_1
XFILLER_0_29_69 VGND VGND VPWR VPWR sky130_fd_sc_hd__fill_1
XscaleAdd._283_ scaleAdd._221_ scaleAdd._222_ scaleAdd._192_ VGND VGND VPWR VPWR scaleAdd._225_
+ sky130_fd_sc_hd__a21oi_1
XFILLER_0_45_57 VGND VGND VPWR VPWR sky130_fd_sc_hd__decap_8
XFILLER_0_0_15 VPWR VGND VPWR VGND sky130_ef_sc_hd__decap_12
Xaccumulator._1982_ accumulator._1071_ accumulator._1076_ accumulator._0919_ VGND
+ VGND VPWR VPWR accumulator._1077_ sky130_fd_sc_hd__mux2_2
XFILLER_0_43_169 VGND VGND VPWR VPWR sky130_fd_sc_hd__decap_8
XFILLER_0_3_233 VGND VGND VPWR VPWR sky130_fd_sc_hd__decap_3
XFILLER_0_9_57 VPWR VGND VPWR VGND sky130_ef_sc_hd__decap_12
XFILLER_0_16_328 VPWR VGND VPWR VGND sky130_ef_sc_hd__decap_12
XPHY_EDGE_ROW_24_Left_92 VGND VGND VPWR VPWR sky130_fd_sc_hd__decap_3
XFILLER_0_3_277 VGND VGND VPWR VPWR sky130_fd_sc_hd__decap_3
XFILLER_0_3_255 VGND VGND VPWR VPWR sky130_fd_sc_hd__decap_3
XTAP_TAPCELL_ROW_67_621 VGND VPWR sky130_fd_sc_hd__tapvpwrvgnd_1
XFILLER_0_36_3 VGND VGND VPWR VPWR sky130_fd_sc_hd__decap_4
Xaccumulator._1347_ accumulator._0414_ VGND VGND VPWR VPWR accumulator._0442_ sky130_fd_sc_hd__buf_2
Xaccumulator._1416_ accumulator._0486_ accumulator._0487_ VGND VGND VPWR VPWR accumulator._0511_
+ sky130_fd_sc_hd__xor2_4
XFILLER_0_66_206 VPWR VGND VPWR VGND sky130_ef_sc_hd__decap_12
Xaccumulator._1278_ accumulator._0369_ accumulator._0374_ accumulator._0372_ VGND
+ VGND VPWR VPWR accumulator._0375_ sky130_fd_sc_hd__a21oi_4
XFILLER_0_34_125 VGND VGND VPWR VPWR sky130_fd_sc_hd__fill_1
XFILLER_0_34_114 VGND VGND VPWR VPWR sky130_fd_sc_hd__decap_3
XFILLER_0_19_111 VGND VGND VPWR VPWR sky130_fd_sc_hd__fill_1
XFILLER_0_22_309 VGND VGND VPWR VPWR sky130_fd_sc_hd__fill_2
XFILLER_0_15_27 VPWR VGND VPWR VGND sky130_ef_sc_hd__decap_12
XFILLER_0_65_261 VPWR VGND VPWR VGND sky130_ef_sc_hd__decap_12
XFILLER_0_25_169 VGND VGND VPWR VPWR sky130_fd_sc_hd__decap_4
XTAP_TAPCELL_ROW_13_234 VGND VPWR sky130_fd_sc_hd__tapvpwrvgnd_1
XscaleAdd._404_ scaleAdd._029_ scaleAdd._106_ VGND VGND VPWR VPWR scaleAdd._107_ sky130_fd_sc_hd__nand2_1
XFILLER_0_21_397 VGND VGND VPWR VPWR sky130_fd_sc_hd__decap_4
XFILLER_0_0_225 VGND VGND VPWR VPWR sky130_fd_sc_hd__fill_2
XFILLER_0_0_258 VGND VGND VPWR VPWR sky130_fd_sc_hd__decap_8
XscaleAdd._335_ scaleAdd._190_ scaleAdd._022_ VGND VGND VPWR VPWR scaleAdd._041_ sky130_fd_sc_hd__nand2_1
Xaccumulator._2250_ accumulator.io_accOut\[18\] accumulator._0147_ accumulator._0381_
+ accumulator._0202_ VGND VGND VPWR VPWR accumulator._0020_ sky130_fd_sc_hd__o211a_1
Xaccumulator._1201_ net86 accumulator._0222_ accumulator._0232_ VGND VGND VPWR VPWR
+ accumulator._0241_ sky130_fd_sc_hd__o21ba_4
XscaleAdd._266_ operator.io_outMant\[0\] scaleAdd._207_ scaleAdd._208_ VGND VGND VPWR
+ VPWR scaleAdd._209_ sky130_fd_sc_hd__and3_1
Xaccumulator._2181_ accumulator._0135_ accumulator._1144_ net100 VGND VGND VPWR VPWR
+ accumulator._0136_ sky130_fd_sc_hd__mux2_1
XFILLER_0_8_347 VPWR VGND VPWR VGND sky130_ef_sc_hd__decap_12
Xaccumulator._1965_ accumulator._0881_ accumulator._1059_ accumulator._0934_ accumulator._0535_
+ VGND VGND VPWR VPWR accumulator._1060_ sky130_fd_sc_hd__a211o_1
Xaccumulator._1896_ accumulator._0918_ accumulator._0989_ accumulator._0990_ VGND
+ VGND VPWR VPWR accumulator._0991_ sky130_fd_sc_hd__a21oi_1
Xaccumulator._2379_ clknet_2_3__leaf_clock accumulator._0024_ VGND VGND VPWR VPWR
+ accumulator.io_accOut\[22\] sky130_fd_sc_hd__dfxtp_1
XTAP_TAPCELL_ROW_27_337 VGND VPWR sky130_fd_sc_hd__tapvpwrvgnd_1
XFILLER_0_62_253 VPWR VGND VPWR VGND sky130_ef_sc_hd__decap_12
XFILLER_0_54_209 VGND VGND VPWR VPWR sky130_fd_sc_hd__fill_1
XTAP_TAPCELL_ROW_35_392 VGND VPWR sky130_fd_sc_hd__tapvpwrvgnd_1
XFILLER_0_7_380 VGND VGND VPWR VPWR sky130_fd_sc_hd__decap_4
XFILLER_0_7_391 VGND VGND VPWR VPWR sky130_fd_sc_hd__fill_1
XTAP_TAPCELL_ROW_10_215 VGND VPWR sky130_fd_sc_hd__tapvpwrvgnd_1
XFILLER_0_45_209 VGND VGND VPWR VPWR sky130_fd_sc_hd__decap_3
XFILLER_0_38_261 VGND VGND VPWR VPWR sky130_fd_sc_hd__fill_1
Xaccumulator._1750_ accumulator._0773_ accumulator._0792_ accumulator._0752_ accumulator._0844_
+ VGND VGND VPWR VPWR accumulator._0845_ sky130_fd_sc_hd__or4_1
XANTENNA_2 net28 VGND VGND VPWR VPWR sky130_fd_sc_hd__diode_2
XscaleAdd._318_ scaleAdd._191_ scaleAdd._207_ VGND VGND VPWR VPWR scaleAdd._025_ sky130_fd_sc_hd__nand2_1
Xaccumulator._1681_ accumulator._0774_ accumulator._0775_ VGND VGND VPWR VPWR accumulator._0776_
+ sky130_fd_sc_hd__or2_1
Xaccumulator._2233_ accumulator._0107_ accumulator._0185_ accumulator._0186_ accumulator._0062_
+ VGND VGND VPWR VPWR accumulator._0187_ sky130_fd_sc_hd__a211o_1
Xaccumulator._2302_ accumulator._1127_ accumulator._0247_ VGND VGND VPWR VPWR accumulator._0253_
+ sky130_fd_sc_hd__nand2_1
Xaccumulator._2164_ accumulator._1111_ VGND VGND VPWR VPWR accumulator._0119_ sky130_fd_sc_hd__inv_2
Xrebuffer14 scaleAdd._134_ VGND VGND VPWR VPWR net72 sky130_fd_sc_hd__dlygate4sd1_1
Xrebuffer36 accumulator._0232_ VGND VGND VPWR VPWR net94 sky130_fd_sc_hd__dlygate4sd1_1
XscaleAdd._249_ scaleAdd._185_ scaleAdd._192_ net11 VGND VGND VPWR VPWR scaleAdd._194_
+ sky130_fd_sc_hd__a21oi_1
Xrebuffer25 accumulator._0315_ VGND VGND VPWR VPWR net83 sky130_fd_sc_hd__clkbuf_1
Xaccumulator._2095_ accumulator.io_accOut\[0\] accumulator._0392_ accumulator._1122_
+ accumulator._0050_ VGND VGND VPWR VPWR accumulator._0051_ sky130_fd_sc_hd__a22o_1
XTAP_TAPCELL_ROW_32_373 VGND VPWR sky130_fd_sc_hd__tapvpwrvgnd_1
XFILLER_0_32_91 VGND VGND VPWR VPWR sky130_fd_sc_hd__fill_1
XFILLER_0_8_100 VGND VGND VPWR VPWR sky130_fd_sc_hd__decap_8
Xaccumulator._1879_ accumulator._0809_ accumulator._0839_ accumulator._0842_ VGND
+ VGND VPWR VPWR accumulator._0974_ sky130_fd_sc_hd__a21oi_1
Xaccumulator._1948_ accumulator._0881_ accumulator._1042_ VGND VGND VPWR VPWR accumulator._1043_
+ sky130_fd_sc_hd__xor2_2
XFILLER_0_4_361 VGND VGND VPWR VPWR sky130_fd_sc_hd__decap_3
XFILLER_0_67_389 VGND VGND VPWR VPWR sky130_fd_sc_hd__decap_3
XFILLER_0_50_234 VGND VGND VPWR VPWR sky130_fd_sc_hd__decap_3
XFILLER_0_50_223 VGND VGND VPWR VPWR sky130_fd_sc_hd__decap_8
XFILLER_0_35_286 VGND VGND VPWR VPWR sky130_fd_sc_hd__decap_3
XFILLER_0_2_309 VGND VGND VPWR VPWR sky130_fd_sc_hd__decap_8
Xoutput50 net50 VGND VGND VPWR VPWR io_accOut[5] sky130_fd_sc_hd__clkbuf_4
XFILLER_0_10_109 VGND VGND VPWR VPWR sky130_fd_sc_hd__decap_8
XTAP_TAPCELL_ROW_46_465 VGND VPWR sky130_fd_sc_hd__tapvpwrvgnd_1
XFILLER_0_58_389 VPWR VGND VPWR VGND sky130_ef_sc_hd__decap_12
XFILLER_0_58_345 VPWR VGND VPWR VGND sky130_ef_sc_hd__decap_12
XFILLER_0_26_264 VPWR VGND VPWR VGND sky130_ef_sc_hd__decap_12
XFILLER_0_26_253 VGND VGND VPWR VPWR sky130_fd_sc_hd__decap_4
XFILLER_0_18_209 VGND VGND VPWR VPWR sky130_fd_sc_hd__decap_8
XFILLER_0_41_289 VPWR VGND VPWR VGND sky130_ef_sc_hd__decap_12
Xaccumulator._1802_ accumulator._0538_ accumulator._0577_ accumulator._0883_ VGND
+ VGND VPWR VPWR accumulator._0897_ sky130_fd_sc_hd__a21bo_1
XFILLER_0_5_169 VGND VGND VPWR VPWR sky130_fd_sc_hd__decap_4
XFILLER_0_1_386 VGND VGND VPWR VPWR sky130_fd_sc_hd__decap_6
Xaccumulator._1733_ accumulator._0579_ accumulator._0635_ VGND VGND VPWR VPWR accumulator._0828_
+ sky130_fd_sc_hd__nor2_1
Xclkbuf_2_3__f_clock clknet_0_clock VGND VGND VPWR VPWR clknet_2_3__leaf_clock sky130_fd_sc_hd__clkbuf_16
Xaccumulator._1664_ accumulator._0651_ accumulator._0751_ accumulator._0757_ accumulator._0758_
+ VGND VGND VPWR VPWR accumulator._0759_ sky130_fd_sc_hd__a211o_1
Xaccumulator._1595_ accumulator._0563_ accumulator._0655_ accumulator._0689_ VGND
+ VGND VPWR VPWR accumulator._0690_ sky130_fd_sc_hd__a21o_1
Xaccumulator._2216_ accumulator._0152_ accumulator._0169_ accumulator._0042_ VGND
+ VGND VPWR VPWR accumulator._0170_ sky130_fd_sc_hd__mux2_4
Xaccumulator._2147_ accumulator._0067_ accumulator._0101_ net104 VGND VGND VPWR VPWR
+ accumulator._0102_ sky130_fd_sc_hd__mux2_4
Xaccumulator._2078_ accumulator._1081_ accumulator._1084_ VGND VGND VPWR VPWR accumulator._1175_
+ sky130_fd_sc_hd__nor2_1
XFILLER_0_67_197 VPWR VGND VPWR VGND sky130_ef_sc_hd__decap_12
XFILLER_0_67_153 VPWR VGND VPWR VGND sky130_ef_sc_hd__decap_12
XTAP_TAPCELL_ROW_43_446 VGND VPWR sky130_fd_sc_hd__tapvpwrvgnd_1
XFILLER_0_2_139 VGND VGND VPWR VPWR sky130_fd_sc_hd__fill_1
Xrebuffer5 net70 VGND VGND VPWR VPWR net63 sky130_fd_sc_hd__dlygate4sd1_1
Xaccumulator._1380_ accumulator._0444_ accumulator._0448_ accumulator._0203_ VGND
+ VGND VPWR VPWR accumulator._0475_ sky130_fd_sc_hd__mux2_1
XFILLER_0_3_15 VPWR VGND VPWR VGND sky130_ef_sc_hd__decap_12
XFILLER_0_64_89 VGND VGND VPWR VPWR sky130_fd_sc_hd__decap_3
XFILLER_0_46_304 VGND VGND VPWR VPWR sky130_fd_sc_hd__decap_4
Xaccumulator._2001_ accumulator._1022_ accumulator._0951_ VGND VGND VPWR VPWR accumulator._1096_
+ sky130_fd_sc_hd__nand2_1
XFILLER_0_61_329 VGND VGND VPWR VPWR sky130_fd_sc_hd__decap_6
XFILLER_0_13_93 VPWR VGND VPWR VGND sky130_ef_sc_hd__decap_12
XFILLER_0_66_3 VPWR VGND VPWR VGND sky130_ef_sc_hd__decap_12
Xaccumulator._1716_ accumulator._0739_ accumulator._0732_ accumulator._0740_ VGND
+ VGND VPWR VPWR accumulator._0811_ sky130_fd_sc_hd__nand3_2
XFILLER_0_1_161 VGND VGND VPWR VPWR sky130_fd_sc_hd__decap_6
Xaccumulator._1647_ accumulator._0722_ accumulator._0729_ accumulator._0730_ VGND
+ VGND VPWR VPWR accumulator._0742_ sky130_fd_sc_hd__a21oi_1
Xaccumulator._1578_ accumulator._0416_ accumulator._0419_ accumulator._0671_ accumulator._0672_
+ VGND VGND VPWR VPWR accumulator._0673_ sky130_fd_sc_hd__a22o_1
XFILLER_0_49_186 VPWR VGND VPWR VGND sky130_ef_sc_hd__decap_12
XTAP_TAPCELL_ROW_40_427 VGND VPWR sky130_fd_sc_hd__tapvpwrvgnd_1
XFILLER_0_37_337 VGND VGND VPWR VPWR sky130_fd_sc_hd__decap_6
XTAP_TAPCELL_ROW_5_182 VGND VPWR sky130_fd_sc_hd__tapvpwrvgnd_1
XFILLER_0_18_27 VGND VGND VPWR VPWR sky130_fd_sc_hd__fill_1
XPHY_EDGE_ROW_16_Right_16 VGND VGND VPWR VPWR sky130_fd_sc_hd__decap_3
XFILLER_0_55_189 VGND VGND VPWR VPWR sky130_fd_sc_hd__fill_2
XFILLER_0_55_167 VGND VGND VPWR VPWR sky130_fd_sc_hd__fill_1
XFILLER_0_28_359 VGND VGND VPWR VPWR sky130_fd_sc_hd__decap_4
XPHY_EDGE_ROW_25_Right_25 VGND VGND VPWR VPWR sky130_fd_sc_hd__decap_3
XFILLER_0_11_215 VGND VGND VPWR VPWR sky130_fd_sc_hd__decap_4
XPHY_EDGE_ROW_34_Right_34 VGND VGND VPWR VPWR sky130_fd_sc_hd__decap_3
Xaccumulator._1501_ accumulator._0558_ accumulator._0559_ accumulator._0420_ VGND
+ VGND VPWR VPWR accumulator._0596_ sky130_fd_sc_hd__a21o_1
Xaccumulator._1432_ accumulator._0489_ accumulator._0412_ accumulator._0512_ accumulator._0526_
+ VGND VGND VPWR VPWR accumulator._0527_ sky130_fd_sc_hd__a31o_1
Xaccumulator._1363_ accumulator._0426_ accumulator._0456_ accumulator._0457_ VGND
+ VGND VPWR VPWR accumulator._0458_ sky130_fd_sc_hd__a21o_1
XPHY_EDGE_ROW_49_Left_117 VGND VGND VPWR VPWR sky130_fd_sc_hd__decap_3
XFILLER_0_46_167 VGND VGND VPWR VPWR sky130_fd_sc_hd__decap_8
Xaccumulator._1294_ accumulator.io_inSign accumulator._0034_ accumulator._0379_ accumulator._0381_
+ accumulator._0390_ VGND VGND VPWR VPWR accumulator._0000_ sky130_fd_sc_hd__o311a_1
XFILLER_0_34_307 VGND VGND VPWR VPWR sky130_fd_sc_hd__fill_1
XPHY_EDGE_ROW_43_Right_43 VGND VGND VPWR VPWR sky130_fd_sc_hd__decap_3
XFILLER_0_42_362 VGND VGND VPWR VPWR sky130_fd_sc_hd__fill_2
XFILLER_0_40_80 VGND VGND VPWR VPWR sky130_fd_sc_hd__decap_4
XFILLER_0_27_381 VGND VGND VPWR VPWR sky130_fd_sc_hd__fill_1
XFILLER_0_6_253 VPWR VGND VPWR VGND sky130_ef_sc_hd__decap_12
XPHY_EDGE_ROW_58_Left_126 VGND VGND VPWR VPWR sky130_fd_sc_hd__decap_3
XPHY_EDGE_ROW_52_Right_52 VGND VGND VPWR VPWR sky130_fd_sc_hd__decap_3
XFILLER_0_10_292 VPWR VGND VPWR VGND sky130_ef_sc_hd__decap_12
XTAP_TAPCELL_ROW_2_163 VGND VPWR sky130_fd_sc_hd__tapvpwrvgnd_1
Xoperator._19_ operator.io_outExp\[2\] operator._02_ operator._03_ operator._04_ VGND
+ VGND VPWR VPWR operator.io_outExp\[1\] sky130_fd_sc_hd__a2bb2o_1
XPHY_EDGE_ROW_67_Left_135 VGND VGND VPWR VPWR sky130_fd_sc_hd__decap_3
XPHY_EDGE_ROW_61_Right_61 VGND VGND VPWR VPWR sky130_fd_sc_hd__decap_3
XFILLER_0_52_137 VGND VGND VPWR VPWR sky130_fd_sc_hd__decap_3
XscaleAdd._420_ scaleAdd._095_ scaleAdd._108_ VGND VGND VPWR VPWR scaleAdd._122_ sky130_fd_sc_hd__nor2_1
XFILLER_0_29_37 VPWR VGND VPWR VGND sky130_ef_sc_hd__decap_12
XFILLER_0_29_15 VPWR VGND VPWR VGND sky130_ef_sc_hd__decap_12
XscaleAdd._351_ scaleAdd._055_ scaleAdd._029_ scaleAdd._043_ VGND VGND VPWR VPWR scaleAdd._057_
+ sky130_fd_sc_hd__a21o_1
XscaleAdd._282_ scaleAdd._221_ scaleAdd._222_ scaleAdd._223_ VGND VGND VPWR VPWR scaleAdd._224_
+ sky130_fd_sc_hd__a21o_1
XFILLER_0_61_57 VPWR VGND VPWR VGND sky130_ef_sc_hd__decap_12
XFILLER_0_28_145 VGND VGND VPWR VPWR sky130_fd_sc_hd__fill_1
XFILLER_0_0_27 VGND VGND VPWR VPWR sky130_fd_sc_hd__fill_1
Xaccumulator._1981_ accumulator._0768_ accumulator._0538_ accumulator._0888_ accumulator._1075_
+ VGND VGND VPWR VPWR accumulator._1076_ sky130_fd_sc_hd__a31o_1
XFILLER_0_24_395 VGND VGND VPWR VPWR sky130_fd_sc_hd__fill_2
XFILLER_0_9_69 VGND VGND VPWR VPWR sky130_fd_sc_hd__decap_6
XFILLER_0_10_83 VGND VGND VPWR VPWR sky130_fd_sc_hd__fill_1
XTAP_TAPCELL_ROW_67_622 VGND VPWR sky130_fd_sc_hd__tapvpwrvgnd_1
XFILLER_0_66_218 VGND VGND VPWR VPWR sky130_fd_sc_hd__fill_2
XFILLER_0_29_3 VPWR VGND VPWR VGND sky130_ef_sc_hd__decap_12
Xaccumulator._1346_ accumulator.io_accOut\[19\] accumulator._0440_ net59 VGND VGND
+ VPWR VPWR accumulator._0441_ sky130_fd_sc_hd__mux2_2
Xaccumulator._1415_ accumulator._0504_ accumulator._0509_ accumulator._0462_ VGND
+ VGND VPWR VPWR accumulator._0510_ sky130_fd_sc_hd__a21o_1
XFILLER_0_66_229 VPWR VGND VPWR VGND sky130_ef_sc_hd__decap_12
XFILLER_0_59_281 VGND VGND VPWR VPWR sky130_fd_sc_hd__decap_8
Xaccumulator._1277_ accumulator._0372_ accumulator._0373_ VGND VGND VPWR VPWR accumulator._0374_
+ sky130_fd_sc_hd__nor2_2
XFILLER_0_34_148 VGND VGND VPWR VPWR sky130_fd_sc_hd__fill_1
XFILLER_0_15_340 VGND VGND VPWR VPWR sky130_fd_sc_hd__decap_6
XFILLER_0_65_273 VGND VGND VPWR VPWR sky130_fd_sc_hd__decap_6
XFILLER_0_33_181 VPWR VGND VPWR VGND sky130_ef_sc_hd__decap_12
XFILLER_0_25_159 VGND VGND VPWR VPWR sky130_fd_sc_hd__decap_3
XFILLER_0_25_148 VGND VGND VPWR VPWR sky130_fd_sc_hd__decap_8
XTAP_TAPCELL_ROW_13_235 VGND VPWR sky130_fd_sc_hd__tapvpwrvgnd_1
XTAP_TAPCELL_ROW_21_290 VGND VPWR sky130_fd_sc_hd__tapvpwrvgnd_1
XscaleAdd._334_ scaleAdd._008_ scaleAdd._040_ VGND VGND VPWR VPWR accumulator.io_inMant\[7\]
+ sky130_fd_sc_hd__xnor2_2
XscaleAdd._403_ scaleAdd._105_ net80 scaleAdd._070_ VGND VGND VPWR VPWR scaleAdd._106_
+ sky130_fd_sc_hd__o21ai_4
XscaleAdd._265_ scaleAdd._185_ scaleAdd._191_ scaleAdd._184_ scaleAdd._189_ operator.io_outMant\[3\]
+ VGND VGND VPWR VPWR scaleAdd._208_ sky130_fd_sc_hd__a32o_1
Xaccumulator._2180_ accumulator._1030_ VGND VGND VPWR VPWR accumulator._0135_ sky130_fd_sc_hd__inv_2
Xaccumulator._1200_ accumulator._0055_ accumulator._0065_ VGND VGND VPWR VPWR accumulator._0232_
+ sky130_fd_sc_hd__and2b_1
XFILLER_0_8_359 VGND VGND VPWR VPWR sky130_fd_sc_hd__decap_4
Xaccumulator._1895_ accumulator._0752_ accumulator._0984_ accumulator._0534_ accumulator._0789_
+ VGND VGND VPWR VPWR accumulator._0990_ sky130_fd_sc_hd__o211a_1
Xaccumulator._1964_ accumulator._1039_ VGND VGND VPWR VPWR accumulator._1059_ sky130_fd_sc_hd__inv_2
XFILLER_0_12_321 VPWR VGND VPWR VGND sky130_ef_sc_hd__decap_12
XFILLER_0_12_365 VGND VGND VPWR VPWR sky130_fd_sc_hd__decap_3
XFILLER_0_21_60 VPWR VGND VPWR VGND sky130_ef_sc_hd__decap_12
XPHY_EDGE_ROW_2_Right_2 VGND VGND VPWR VPWR sky130_fd_sc_hd__decap_3
Xaccumulator._2378_ clknet_2_1__leaf_clock accumulator._0023_ VGND VGND VPWR VPWR
+ accumulator.io_accOut\[21\] sky130_fd_sc_hd__dfxtp_1
XFILLER_0_46_90 VPWR VGND VPWR VGND sky130_ef_sc_hd__decap_12
XTAP_TAPCELL_ROW_27_338 VGND VPWR sky130_fd_sc_hd__tapvpwrvgnd_1
Xaccumulator._1329_ accumulator._0394_ accumulator._0403_ accumulator._0422_ VGND
+ VGND VPWR VPWR accumulator._0424_ sky130_fd_sc_hd__a21boi_2
XFILLER_0_1_81 VPWR VGND VPWR VGND sky130_ef_sc_hd__decap_12
XFILLER_0_62_265 VPWR VGND VPWR VGND sky130_ef_sc_hd__decap_12
XFILLER_0_62_210 VGND VGND VPWR VPWR sky130_fd_sc_hd__decap_6
XTAP_TAPCELL_ROW_35_393 VGND VPWR sky130_fd_sc_hd__tapvpwrvgnd_1
XFILLER_0_22_118 VPWR VGND VPWR VGND sky130_ef_sc_hd__decap_12
XTAP_TAPCELL_ROW_10_216 VGND VPWR sky130_fd_sc_hd__tapvpwrvgnd_1
XFILLER_0_15_181 VGND VGND VPWR VPWR sky130_fd_sc_hd__decap_8
Xhold50 accumulator.io_accOut\[19\] VGND VGND VPWR VPWR net108 sky130_fd_sc_hd__dlygate4sd3_1
XFILLER_0_26_16 VPWR VGND VPWR VGND sky130_ef_sc_hd__decap_12
XFILLER_0_42_48 VPWR VGND VPWR VGND sky130_ef_sc_hd__decap_12
XFILLER_0_42_15 VGND VGND VPWR VPWR sky130_fd_sc_hd__fill_1
XFILLER_0_5_318 VGND VGND VPWR VPWR sky130_fd_sc_hd__fill_1
XFILLER_0_21_151 VGND VGND VPWR VPWR sky130_fd_sc_hd__fill_1
XFILLER_0_6_15 VPWR VGND VPWR VGND sky130_ef_sc_hd__decap_12
XFILLER_0_13_118 VPWR VGND VPWR VGND sky130_ef_sc_hd__decap_12
Xaccumulator._2301_ accumulator._0147_ accumulator._0250_ accumulator._0252_ VGND
+ VGND VPWR VPWR accumulator._0027_ sky130_fd_sc_hd__a21oi_1
XscaleAdd._248_ scaleAdd._185_ net11 scaleAdd._192_ VGND VGND VPWR VPWR scaleAdd._193_
+ sky130_fd_sc_hd__and3_1
XscaleAdd._317_ operator.io_outMant\[3\] scaleAdd._195_ VGND VGND VPWR VPWR scaleAdd._024_
+ sky130_fd_sc_hd__nand2_1
Xaccumulator._1680_ accumulator._0576_ accumulator._0668_ accumulator._0669_ accumulator._0536_
+ VGND VGND VPWR VPWR accumulator._0775_ sky130_fd_sc_hd__a211oi_2
Xaccumulator._2232_ accumulator._0107_ accumulator._0153_ VGND VGND VPWR VPWR accumulator._0186_
+ sky130_fd_sc_hd__nor2_1
Xaccumulator._2094_ accumulator._1128_ accumulator._0043_ accumulator._0049_ VGND
+ VGND VPWR VPWR accumulator._0050_ sky130_fd_sc_hd__a21oi_1
Xaccumulator._2163_ accumulator._0113_ accumulator._0117_ accumulator._0118_ VGND
+ VGND VPWR VPWR accumulator._0009_ sky130_fd_sc_hd__o21a_1
Xrebuffer15 scaleAdd._120_ VGND VGND VPWR VPWR net73 sky130_fd_sc_hd__dlygate4sd1_1
Xrebuffer37 accumulator._0232_ VGND VGND VPWR VPWR net95 sky130_fd_sc_hd__dlygate4sd1_1
Xrebuffer26 accumulator._0354_ VGND VGND VPWR VPWR net84 sky130_fd_sc_hd__dlygate4sd1_1
XFILLER_0_8_134 VGND VGND VPWR VPWR sky130_fd_sc_hd__decap_6
Xaccumulator._1878_ accumulator._0799_ VGND VGND VPWR VPWR accumulator._0973_ sky130_fd_sc_hd__inv_2
Xaccumulator._1947_ accumulator._0535_ accumulator._1039_ accumulator._1041_ accumulator._0894_
+ VGND VGND VPWR VPWR accumulator._1042_ sky130_fd_sc_hd__o22a_1
XFILLER_0_12_29 VPWR VGND VPWR VGND sky130_ef_sc_hd__decap_12
Xoutput40 net40 VGND VGND VPWR VPWR io_accOut[25] sky130_fd_sc_hd__buf_2
Xoutput51 net51 VGND VGND VPWR VPWR io_accOut[6] sky130_fd_sc_hd__buf_2
XFILLER_0_58_357 VGND VGND VPWR VPWR sky130_fd_sc_hd__decap_6
XFILLER_0_53_69 VGND VGND VPWR VPWR sky130_fd_sc_hd__decap_8
XTAP_TAPCELL_ROW_46_466 VGND VPWR sky130_fd_sc_hd__tapvpwrvgnd_1
XFILLER_0_26_298 VGND VGND VPWR VPWR sky130_fd_sc_hd__fill_1
XFILLER_0_26_232 VPWR VGND VPWR VGND sky130_ef_sc_hd__decap_12
Xaccumulator._1663_ accumulator._0649_ accumulator._0650_ VGND VGND VPWR VPWR accumulator._0758_
+ sky130_fd_sc_hd__and2_1
Xaccumulator._1801_ accumulator._0886_ accumulator._0895_ VGND VGND VPWR VPWR accumulator._0896_
+ sky130_fd_sc_hd__or2_1
Xaccumulator._1732_ accumulator._0824_ accumulator._0825_ accumulator._0826_ accumulator._0412_
+ VGND VGND VPWR VPWR accumulator._0827_ sky130_fd_sc_hd__and4bb_1
XFILLER_0_27_81 VGND VGND VPWR VPWR sky130_fd_sc_hd__fill_1
Xaccumulator._1594_ accumulator._0459_ accumulator._0460_ accumulator._0687_ accumulator._0688_
+ VGND VGND VPWR VPWR accumulator._0689_ sky130_fd_sc_hd__o22a_1
Xaccumulator._2215_ accumulator._1006_ accumulator._1017_ net101 VGND VGND VPWR VPWR
+ accumulator._0169_ sky130_fd_sc_hd__mux2_1
Xaccumulator._2146_ accumulator._0086_ accumulator._0100_ accumulator._0042_ VGND
+ VGND VPWR VPWR accumulator._0101_ sky130_fd_sc_hd__mux2_4
Xaccumulator._2077_ accumulator._1173_ accumulator._1100_ net100 VGND VGND VPWR VPWR
+ accumulator._1174_ sky130_fd_sc_hd__mux2_2
XFILLER_0_11_3 VPWR VGND VPWR VGND sky130_ef_sc_hd__decap_12
XFILLER_0_32_224 VGND VGND VPWR VPWR sky130_fd_sc_hd__decap_8
XFILLER_0_4_181 VGND VGND VPWR VPWR sky130_fd_sc_hd__fill_1
XFILLER_0_17_243 VPWR VGND VPWR VGND sky130_ef_sc_hd__decap_12
XFILLER_0_17_276 VGND VGND VPWR VPWR sky130_fd_sc_hd__decap_4
XFILLER_0_67_165 VGND VGND VPWR VPWR sky130_fd_sc_hd__decap_3
XTAP_TAPCELL_ROW_43_447 VGND VPWR sky130_fd_sc_hd__tapvpwrvgnd_1
XFILLER_0_63_393 VGND VGND VPWR VPWR sky130_fd_sc_hd__decap_8
XFILLER_0_23_279 VGND VGND VPWR VPWR sky130_fd_sc_hd__fill_1
Xrebuffer6 net63 VGND VGND VPWR VPWR net64 sky130_fd_sc_hd__dlymetal6s2s_1
XFILLER_0_3_27 VPWR VGND VPWR VGND sky130_ef_sc_hd__decap_12
Xaccumulator._2000_ accumulator._1038_ VGND VGND VPWR VPWR accumulator._1095_ sky130_fd_sc_hd__inv_2
XFILLER_0_58_154 VPWR VGND VPWR VGND sky130_ef_sc_hd__decap_12
XFILLER_0_58_110 VPWR VGND VPWR VGND sky130_ef_sc_hd__decap_12
XFILLER_0_14_235 VGND VGND VPWR VPWR sky130_fd_sc_hd__fill_2
XFILLER_0_14_246 VGND VGND VPWR VPWR sky130_fd_sc_hd__fill_2
XFILLER_0_59_3 VPWR VGND VPWR VGND sky130_ef_sc_hd__decap_12
Xaccumulator._1715_ accumulator._0740_ accumulator._0739_ accumulator._0732_ VGND
+ VGND VPWR VPWR accumulator._0810_ sky130_fd_sc_hd__nand3b_1
Xaccumulator._1646_ accumulator._0732_ accumulator._0739_ accumulator._0740_ VGND
+ VGND VPWR VPWR accumulator._0741_ sky130_fd_sc_hd__a21o_1
XFILLER_0_54_90 VPWR VGND VPWR VGND sky130_ef_sc_hd__decap_12
XFILLER_0_49_121 VGND VGND VPWR VPWR sky130_fd_sc_hd__fill_2
XscaleAdd._481__57 VGND VGND VPWR VPWR scaleAdd._481__57/HI net57 sky130_fd_sc_hd__conb_1
Xaccumulator._1577_ accumulator.io_accOut\[5\] accumulator._0387_ accumulator._0571_
+ accumulator._0418_ VGND VGND VPWR VPWR accumulator._0672_ sky130_fd_sc_hd__a31o_1
XFILLER_0_49_198 VGND VGND VPWR VPWR sky130_fd_sc_hd__fill_2
Xaccumulator._2129_ accumulator._0074_ accumulator._0084_ VGND VGND VPWR VPWR accumulator._0005_
+ sky130_fd_sc_hd__nor2_1
XTAP_TAPCELL_ROW_40_428 VGND VPWR sky130_fd_sc_hd__tapvpwrvgnd_1
XFILLER_0_37_349 VPWR VGND VPWR VGND sky130_ef_sc_hd__decap_12
XFILLER_0_37_327 VGND VGND VPWR VPWR sky130_fd_sc_hd__decap_8
XFILLER_0_60_363 VGND VGND VPWR VPWR sky130_fd_sc_hd__fill_1
XFILLER_0_45_393 VGND VGND VPWR VPWR sky130_fd_sc_hd__decap_4
XFILLER_0_20_227 VPWR VGND VPWR VGND sky130_ef_sc_hd__decap_12
XFILLER_0_20_249 VGND VGND VPWR VPWR sky130_fd_sc_hd__decap_3
XFILLER_0_0_3 VPWR VGND VPWR VGND sky130_ef_sc_hd__decap_12
XTAP_TAPCELL_ROW_5_183 VGND VPWR sky130_fd_sc_hd__tapvpwrvgnd_1
XFILLER_0_55_113 VGND VGND VPWR VPWR sky130_fd_sc_hd__fill_2
XFILLER_0_50_15 VPWR VGND VPWR VGND sky130_ef_sc_hd__decap_12
XFILLER_0_34_27 VGND VGND VPWR VPWR sky130_fd_sc_hd__fill_1
XFILLER_0_28_338 VPWR VGND VPWR VGND sky130_ef_sc_hd__decap_12
XFILLER_0_50_59 VGND VGND VPWR VPWR sky130_fd_sc_hd__decap_3
XFILLER_0_43_319 VGND VGND VPWR VPWR sky130_fd_sc_hd__decap_3
XFILLER_0_59_57 VGND VGND VPWR VPWR sky130_fd_sc_hd__decap_3
Xaccumulator._1500_ accumulator._0539_ accumulator._0587_ accumulator._0594_ VGND
+ VGND VPWR VPWR accumulator._0595_ sky130_fd_sc_hd__nand3_1
Xaccumulator._1293_ accumulator._0384_ accumulator._0389_ accumulator.io_accOut\[31\]
+ VGND VGND VPWR VPWR accumulator._0390_ sky130_fd_sc_hd__a21o_1
Xaccumulator._1431_ accumulator._0513_ accumulator._0514_ accumulator._0421_ accumulator._0525_
+ VGND VGND VPWR VPWR accumulator._0526_ sky130_fd_sc_hd__and4_1
Xaccumulator._1362_ accumulator._0418_ VGND VGND VPWR VPWR accumulator._0457_ sky130_fd_sc_hd__buf_2
XFILLER_0_46_102 VGND VGND VPWR VPWR sky130_fd_sc_hd__decap_8
XFILLER_0_6_221 VGND VGND VPWR VPWR sky130_fd_sc_hd__fill_1
XFILLER_0_27_393 VGND VGND VPWR VPWR sky130_fd_sc_hd__decap_4
XFILLER_0_6_265 VPWR VGND VPWR VGND sky130_ef_sc_hd__decap_12
Xaccumulator._1629_ accumulator.io_accOut\[1\] net107 accumulator._0414_ accumulator._0571_
+ VGND VGND VPWR VPWR accumulator._0724_ sky130_fd_sc_hd__and4_1
XTAP_TAPCELL_ROW_53_520 VGND VPWR sky130_fd_sc_hd__tapvpwrvgnd_1
Xoperator._18_ net2 net3 VGND VGND VPWR VPWR operator._04_ sky130_fd_sc_hd__and2b_1
XFILLER_0_37_157 VGND VGND VPWR VPWR sky130_fd_sc_hd__decap_8
XFILLER_0_20_29 VPWR VGND VPWR VGND sky130_ef_sc_hd__decap_12
XFILLER_0_29_49 VGND VGND VPWR VPWR sky130_fd_sc_hd__fill_1
XFILLER_0_29_27 VGND VGND VPWR VPWR sky130_fd_sc_hd__decap_4
XscaleAdd._281_ net13 net11 net12 net10 VGND VGND VPWR VPWR scaleAdd._223_ sky130_fd_sc_hd__and4_1
XscaleAdd._350_ scaleAdd._055_ scaleAdd._043_ scaleAdd._029_ VGND VGND VPWR VPWR scaleAdd._056_
+ sky130_fd_sc_hd__nand3_2
XFILLER_0_45_15 VPWR VGND VPWR VGND sky130_ef_sc_hd__decap_12
XFILLER_0_61_69 VGND VGND VPWR VPWR sky130_fd_sc_hd__decap_6
XFILLER_0_28_113 VGND VGND VPWR VPWR sky130_fd_sc_hd__fill_1
XFILLER_0_9_15 VPWR VGND VPWR VGND sky130_ef_sc_hd__decap_12
XTAP_TAPCELL_ROW_16_255 VGND VPWR sky130_fd_sc_hd__tapvpwrvgnd_1
Xaccumulator._1980_ accumulator._0891_ accumulator._1053_ VGND VGND VPWR VPWR accumulator._1075_
+ sky130_fd_sc_hd__and2_1
XFILLER_0_24_363 VGND VGND VPWR VPWR sky130_fd_sc_hd__fill_1
XTAP_TAPCELL_ROW_67_623 VGND VPWR sky130_fd_sc_hd__tapvpwrvgnd_1
XTAP_TAPCELL_ROW_67_612 VGND VPWR sky130_fd_sc_hd__tapvpwrvgnd_1
XscaleAdd._479_ scaleAdd._153_ scaleAdd._164_ scaleAdd._165_ scaleAdd._172_ scaleAdd._155_
+ VGND VGND VPWR VPWR scaleAdd._173_ sky130_fd_sc_hd__a32o_1
Xaccumulator._1276_ accumulator.io_accOut\[29\] accumulator._0371_ VGND VGND VPWR
+ VPWR accumulator._0373_ sky130_fd_sc_hd__and2b_1
Xaccumulator._1345_ accumulator._0427_ accumulator._0335_ accumulator._0432_ accumulator._0439_
+ VGND VGND VPWR VPWR accumulator._0440_ sky130_fd_sc_hd__a31o_1
Xaccumulator._1414_ net96 accumulator._0508_ accumulator._0498_ VGND VGND VPWR VPWR
+ accumulator._0509_ sky130_fd_sc_hd__a21o_1
XFILLER_0_19_113 VGND VGND VPWR VPWR sky130_fd_sc_hd__fill_1
XFILLER_0_15_330 VGND VGND VPWR VPWR sky130_fd_sc_hd__decap_6
XFILLER_0_42_193 VGND VGND VPWR VPWR sky130_fd_sc_hd__decap_3
XFILLER_0_38_400 VGND VGND VPWR VPWR sky130_fd_sc_hd__fill_1
XFILLER_0_31_28 VGND VGND VPWR VPWR sky130_fd_sc_hd__decap_8
XTAP_TAPCELL_ROW_13_236 VGND VPWR sky130_fd_sc_hd__tapvpwrvgnd_1
XFILLER_0_25_127 VGND VGND VPWR VPWR sky130_fd_sc_hd__fill_2
XscaleAdd._402_ scaleAdd._072_ VGND VGND VPWR VPWR scaleAdd._105_ sky130_fd_sc_hd__inv_2
XTAP_TAPCELL_ROW_21_291 VGND VPWR sky130_fd_sc_hd__tapvpwrvgnd_1
XFILLER_0_21_377 VGND VGND VPWR VPWR sky130_fd_sc_hd__decap_8
XscaleAdd._264_ scaleAdd._204_ scaleAdd._206_ VGND VGND VPWR VPWR scaleAdd._207_ sky130_fd_sc_hd__xnor2_2
XscaleAdd._333_ scaleAdd._038_ scaleAdd._039_ VGND VGND VPWR VPWR scaleAdd._040_ sky130_fd_sc_hd__or2b_1
XFILLER_0_8_305 VGND VGND VPWR VPWR sky130_fd_sc_hd__decap_3
XFILLER_0_21_72 VPWR VGND VPWR VGND sky130_ef_sc_hd__decap_12
Xaccumulator._1963_ accumulator._1048_ accumulator._1043_ VGND VGND VPWR VPWR accumulator._1058_
+ sky130_fd_sc_hd__nand2_2
Xaccumulator._1894_ accumulator._0634_ accumulator._0759_ VGND VGND VPWR VPWR accumulator._0989_
+ sky130_fd_sc_hd__nand2_1
XFILLER_0_31_119 VPWR VGND VPWR VGND sky130_ef_sc_hd__decap_12
XFILLER_0_12_333 VPWR VGND VPWR VGND sky130_ef_sc_hd__decap_12
XFILLER_0_12_377 VGND VGND VPWR VPWR sky130_fd_sc_hd__fill_1
XFILLER_0_21_94 VPWR VGND VPWR VGND sky130_ef_sc_hd__decap_12
XFILLER_0_41_3 VPWR VGND VPWR VGND sky130_ef_sc_hd__decap_12
Xaccumulator._2377_ clknet_2_0__leaf_clock accumulator._0022_ VGND VGND VPWR VPWR
+ accumulator.io_accOut\[20\] sky130_fd_sc_hd__dfxtp_1
XTAP_TAPCELL_ROW_35_394 VGND VPWR sky130_fd_sc_hd__tapvpwrvgnd_1
Xaccumulator._1259_ accumulator._0354_ accumulator._0347_ accumulator._0355_ VGND
+ VGND VPWR VPWR accumulator._0356_ sky130_fd_sc_hd__a21o_4
Xaccumulator._1328_ accumulator._0422_ VGND VGND VPWR VPWR accumulator._0423_ sky130_fd_sc_hd__inv_2
XFILLER_0_1_93 VPWR VGND VPWR VGND sky130_ef_sc_hd__decap_12
XFILLER_0_62_277 VPWR VGND VPWR VGND sky130_ef_sc_hd__decap_12
XFILLER_0_7_393 VGND VGND VPWR VPWR sky130_fd_sc_hd__decap_8
XTAP_TAPCELL_ROW_10_217 VGND VPWR sky130_fd_sc_hd__tapvpwrvgnd_1
Xhold51 accumulator.io_accOut\[20\] VGND VGND VPWR VPWR net109 sky130_fd_sc_hd__dlygate4sd3_1
XFILLER_0_53_255 VGND VGND VPWR VPWR sky130_fd_sc_hd__fill_2
XFILLER_0_53_244 VGND VGND VPWR VPWR sky130_fd_sc_hd__fill_2
XFILLER_0_53_222 VGND VGND VPWR VPWR sky130_fd_sc_hd__fill_2
XFILLER_0_38_274 VPWR VGND VPWR VGND sky130_ef_sc_hd__decap_12
XFILLER_0_67_57 VPWR VGND VPWR VGND sky130_ef_sc_hd__decap_12
XFILLER_0_21_163 VGND VGND VPWR VPWR sky130_fd_sc_hd__fill_1
XFILLER_0_6_27 VGND VGND VPWR VPWR sky130_fd_sc_hd__fill_1
Xaccumulator._2231_ accumulator._0182_ accumulator._0184_ accumulator._0044_ VGND
+ VGND VPWR VPWR accumulator._0185_ sky130_fd_sc_hd__mux2_1
Xaccumulator._2300_ accumulator.io_accOut\[25\] accumulator._0384_ accumulator._0381_
+ VGND VGND VPWR VPWR accumulator._0252_ sky130_fd_sc_hd__o21ai_1
Xrebuffer27 scaleAdd._067_ VGND VGND VPWR VPWR net85 sky130_fd_sc_hd__dlygate4sd1_1
XscaleAdd._247_ net12 VGND VGND VPWR VPWR scaleAdd._192_ sky130_fd_sc_hd__buf_2
XscaleAdd._316_ scaleAdd._181_ scaleAdd._207_ VGND VGND VPWR VPWR scaleAdd._023_ sky130_fd_sc_hd__nand2_1
Xrebuffer16 accumulator._0352_ VGND VGND VPWR VPWR net74 sky130_fd_sc_hd__dlygate4sd1_1
Xaccumulator._2093_ accumulator._1128_ accumulator._0048_ VGND VGND VPWR VPWR accumulator._0049_
+ sky130_fd_sc_hd__nor2_1
Xaccumulator._2162_ accumulator._0380_ VGND VGND VPWR VPWR accumulator._0118_ sky130_fd_sc_hd__buf_2
XTAP_TAPCELL_ROW_49_486 VGND VPWR sky130_fd_sc_hd__tapvpwrvgnd_1
Xaccumulator._1946_ accumulator._1040_ accumulator._0875_ accumulator._0535_ VGND
+ VGND VPWR VPWR accumulator._1041_ sky130_fd_sc_hd__o21ai_1
XFILLER_0_4_374 VGND VGND VPWR VPWR sky130_fd_sc_hd__decap_6
XFILLER_0_4_341 VPWR VGND VPWR VGND sky130_ef_sc_hd__decap_12
XFILLER_0_8_168 VGND VGND VPWR VPWR sky130_fd_sc_hd__decap_3
Xaccumulator._1877_ accumulator._0667_ accumulator._0971_ VGND VGND VPWR VPWR accumulator._0972_
+ sky130_fd_sc_hd__xor2_4
XFILLER_0_12_141 VGND VGND VPWR VPWR sky130_fd_sc_hd__fill_2
XFILLER_0_57_90 VGND VGND VPWR VPWR sky130_fd_sc_hd__decap_8
XFILLER_0_35_233 VGND VGND VPWR VPWR sky130_fd_sc_hd__fill_1
Xoutput41 net41 VGND VGND VPWR VPWR io_accOut[26] sky130_fd_sc_hd__buf_2
Xoutput30 net30 VGND VGND VPWR VPWR io_accOut[16] sky130_fd_sc_hd__buf_2
Xoutput52 net52 VGND VGND VPWR VPWR io_accOut[7] sky130_fd_sc_hd__buf_2
XFILLER_0_53_37 VPWR VGND VPWR VGND sky130_ef_sc_hd__decap_12
XFILLER_0_53_15 VPWR VGND VPWR VGND sky130_ef_sc_hd__decap_12
XTAP_TAPCELL_ROW_46_467 VGND VPWR sky130_fd_sc_hd__tapvpwrvgnd_1
XFILLER_0_41_225 VGND VGND VPWR VPWR sky130_fd_sc_hd__decap_3
Xaccumulator._1800_ accumulator._0879_ accumulator._0894_ accumulator._0878_ VGND
+ VGND VPWR VPWR accumulator._0895_ sky130_fd_sc_hd__o21ai_1
XFILLER_0_26_244 VGND VGND VPWR VPWR sky130_fd_sc_hd__decap_8
Xaccumulator._1662_ accumulator._0752_ accumulator._0756_ VGND VGND VPWR VPWR accumulator._0757_
+ sky130_fd_sc_hd__nand2_1
Xaccumulator._1731_ accumulator._0442_ accumulator._0511_ accumulator._0551_ accumulator._0818_
+ VGND VGND VPWR VPWR accumulator._0826_ sky130_fd_sc_hd__or4_1
.ends
