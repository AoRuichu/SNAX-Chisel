* NGSPICE file created from DotProductUnit_E2M1_x_E2M1_scale_UE2M6.ext - technology: sky130A

* Black-box entry subcircuit for sky130_fd_sc_hd__mux2_1 abstract view
.subckt sky130_fd_sc_hd__mux2_1 A0 A1 S VGND VNB VPB VPWR X
.ends

* Black-box entry subcircuit for sky130_fd_sc_hd__o21a_1 abstract view
.subckt sky130_fd_sc_hd__o21a_1 A1 A2 B1 VGND VNB VPB VPWR X
.ends

* Black-box entry subcircuit for sky130_fd_sc_hd__fill_2 abstract view
.subckt sky130_fd_sc_hd__fill_2 VGND VNB VPB VPWR
.ends

* Black-box entry subcircuit for sky130_fd_sc_hd__a21oi_1 abstract view
.subckt sky130_fd_sc_hd__a21oi_1 A1 A2 B1 VGND VNB VPB VPWR Y
.ends

* Black-box entry subcircuit for sky130_fd_sc_hd__nor2_8 abstract view
.subckt sky130_fd_sc_hd__nor2_8 A B VGND VNB VPB VPWR Y
.ends

* Black-box entry subcircuit for sky130_ef_sc_hd__decap_12 abstract view
.subckt sky130_ef_sc_hd__decap_12 VPWR VGND VPB VNB
.ends

* Black-box entry subcircuit for sky130_fd_sc_hd__fill_1 abstract view
.subckt sky130_fd_sc_hd__fill_1 VGND VNB VPB VPWR
.ends

* Black-box entry subcircuit for sky130_fd_sc_hd__tapvpwrvgnd_1 abstract view
.subckt sky130_fd_sc_hd__tapvpwrvgnd_1 VGND VPWR
.ends

* Black-box entry subcircuit for sky130_fd_sc_hd__nand2_1 abstract view
.subckt sky130_fd_sc_hd__nand2_1 A B VGND VNB VPB VPWR Y
.ends

* Black-box entry subcircuit for sky130_fd_sc_hd__decap_4 abstract view
.subckt sky130_fd_sc_hd__decap_4 VGND VNB VPB VPWR
.ends

* Black-box entry subcircuit for sky130_fd_sc_hd__decap_3 abstract view
.subckt sky130_fd_sc_hd__decap_3 VGND VNB VPB VPWR
.ends

* Black-box entry subcircuit for sky130_fd_sc_hd__decap_8 abstract view
.subckt sky130_fd_sc_hd__decap_8 VGND VNB VPB VPWR
.ends

* Black-box entry subcircuit for sky130_fd_sc_hd__dlygate4sd1_1 abstract view
.subckt sky130_fd_sc_hd__dlygate4sd1_1 A VGND VNB VPB VPWR X
.ends

* Black-box entry subcircuit for sky130_fd_sc_hd__and3_1 abstract view
.subckt sky130_fd_sc_hd__and3_1 A B C VGND VNB VPB VPWR X
.ends

* Black-box entry subcircuit for sky130_fd_sc_hd__decap_6 abstract view
.subckt sky130_fd_sc_hd__decap_6 VGND VNB VPB VPWR
.ends

* Black-box entry subcircuit for sky130_fd_sc_hd__a211oi_2 abstract view
.subckt sky130_fd_sc_hd__a211oi_2 A1 A2 B1 C1 VGND VNB VPB VPWR Y
.ends

* Black-box entry subcircuit for sky130_fd_sc_hd__a31o_1 abstract view
.subckt sky130_fd_sc_hd__a31o_1 A1 A2 A3 B1 VGND VNB VPB VPWR X
.ends

* Black-box entry subcircuit for sky130_fd_sc_hd__a31oi_1 abstract view
.subckt sky130_fd_sc_hd__a31oi_1 A1 A2 A3 B1 VGND VNB VPB VPWR Y
.ends

* Black-box entry subcircuit for sky130_fd_sc_hd__nor2_1 abstract view
.subckt sky130_fd_sc_hd__nor2_1 A B VGND VNB VPB VPWR Y
.ends

* Black-box entry subcircuit for sky130_fd_sc_hd__o21bai_1 abstract view
.subckt sky130_fd_sc_hd__o21bai_1 A1 A2 B1_N VGND VNB VPB VPWR Y
.ends

* Black-box entry subcircuit for sky130_fd_sc_hd__a21o_1 abstract view
.subckt sky130_fd_sc_hd__a21o_1 A1 A2 B1 VGND VNB VPB VPWR X
.ends

* Black-box entry subcircuit for sky130_fd_sc_hd__xnor2_2 abstract view
.subckt sky130_fd_sc_hd__xnor2_2 A B VGND VNB VPB VPWR Y
.ends

* Black-box entry subcircuit for sky130_fd_sc_hd__buf_1 abstract view
.subckt sky130_fd_sc_hd__buf_1 A VGND VNB VPB VPWR X
.ends

* Black-box entry subcircuit for sky130_fd_sc_hd__a31oi_2 abstract view
.subckt sky130_fd_sc_hd__a31oi_2 A1 A2 A3 B1 VGND VNB VPB VPWR Y
.ends

* Black-box entry subcircuit for sky130_fd_sc_hd__and4_1 abstract view
.subckt sky130_fd_sc_hd__and4_1 A B C D VGND VNB VPB VPWR X
.ends

* Black-box entry subcircuit for sky130_fd_sc_hd__and2_1 abstract view
.subckt sky130_fd_sc_hd__and2_1 A B VGND VNB VPB VPWR X
.ends

* Black-box entry subcircuit for sky130_fd_sc_hd__or2_1 abstract view
.subckt sky130_fd_sc_hd__or2_1 A B VGND VNB VPB VPWR X
.ends

* Black-box entry subcircuit for sky130_fd_sc_hd__and2b_1 abstract view
.subckt sky130_fd_sc_hd__and2b_1 A_N B VGND VNB VPB VPWR X
.ends

* Black-box entry subcircuit for sky130_fd_sc_hd__xor2_1 abstract view
.subckt sky130_fd_sc_hd__xor2_1 A B VGND VNB VPB VPWR X
.ends

* Black-box entry subcircuit for sky130_fd_sc_hd__or2b_1 abstract view
.subckt sky130_fd_sc_hd__or2b_1 A B_N VGND VNB VPB VPWR X
.ends

* Black-box entry subcircuit for sky130_fd_sc_hd__o21ai_1 abstract view
.subckt sky130_fd_sc_hd__o21ai_1 A1 A2 B1 VGND VNB VPB VPWR Y
.ends

* Black-box entry subcircuit for sky130_fd_sc_hd__o31a_1 abstract view
.subckt sky130_fd_sc_hd__o31a_1 A1 A2 A3 B1 VGND VNB VPB VPWR X
.ends

* Black-box entry subcircuit for sky130_fd_sc_hd__o211a_1 abstract view
.subckt sky130_fd_sc_hd__o211a_1 A1 A2 B1 C1 VGND VNB VPB VPWR X
.ends

* Black-box entry subcircuit for sky130_fd_sc_hd__buf_6 abstract view
.subckt sky130_fd_sc_hd__buf_6 A VGND VNB VPB VPWR X
.ends

* Black-box entry subcircuit for sky130_fd_sc_hd__mux2_2 abstract view
.subckt sky130_fd_sc_hd__mux2_2 A0 A1 S VGND VNB VPB VPWR X
.ends

* Black-box entry subcircuit for sky130_fd_sc_hd__inv_2 abstract view
.subckt sky130_fd_sc_hd__inv_2 A VGND VNB VPB VPWR Y
.ends

* Black-box entry subcircuit for sky130_fd_sc_hd__dfxtp_1 abstract view
.subckt sky130_fd_sc_hd__dfxtp_1 CLK D VGND VNB VPB VPWR Q
.ends

* Black-box entry subcircuit for sky130_fd_sc_hd__buf_2 abstract view
.subckt sky130_fd_sc_hd__buf_2 A VGND VNB VPB VPWR X
.ends

* Black-box entry subcircuit for sky130_fd_sc_hd__clkbuf_1 abstract view
.subckt sky130_fd_sc_hd__clkbuf_1 A VGND VNB VPB VPWR X
.ends

* Black-box entry subcircuit for sky130_fd_sc_hd__or3_1 abstract view
.subckt sky130_fd_sc_hd__or3_1 A B C VGND VNB VPB VPWR X
.ends

* Black-box entry subcircuit for sky130_fd_sc_hd__dlymetal6s2s_1 abstract view
.subckt sky130_fd_sc_hd__dlymetal6s2s_1 A VGND VNB VPB VPWR X
.ends

* Black-box entry subcircuit for sky130_fd_sc_hd__clkbuf_4 abstract view
.subckt sky130_fd_sc_hd__clkbuf_4 A VGND VNB VPB VPWR X
.ends

* Black-box entry subcircuit for sky130_fd_sc_hd__or4_4 abstract view
.subckt sky130_fd_sc_hd__or4_4 A B C D VGND VNB VPB VPWR X
.ends

* Black-box entry subcircuit for sky130_fd_sc_hd__a211o_1 abstract view
.subckt sky130_fd_sc_hd__a211o_1 A1 A2 B1 C1 VGND VNB VPB VPWR X
.ends

* Black-box entry subcircuit for sky130_fd_sc_hd__xnor2_1 abstract view
.subckt sky130_fd_sc_hd__xnor2_1 A B VGND VNB VPB VPWR Y
.ends

* Black-box entry subcircuit for sky130_fd_sc_hd__o311a_1 abstract view
.subckt sky130_fd_sc_hd__o311a_1 A1 A2 A3 B1 C1 VGND VNB VPB VPWR X
.ends

* Black-box entry subcircuit for sky130_fd_sc_hd__mux2_4 abstract view
.subckt sky130_fd_sc_hd__mux2_4 A0 A1 S VGND VNB VPB VPWR X
.ends

* Black-box entry subcircuit for sky130_fd_sc_hd__a311o_1 abstract view
.subckt sky130_fd_sc_hd__a311o_1 A1 A2 A3 B1 C1 VGND VNB VPB VPWR X
.ends

* Black-box entry subcircuit for sky130_fd_sc_hd__a2111o_1 abstract view
.subckt sky130_fd_sc_hd__a2111o_1 A1 A2 B1 C1 D1 VGND VNB VPB VPWR X
.ends

* Black-box entry subcircuit for sky130_fd_sc_hd__nand3_1 abstract view
.subckt sky130_fd_sc_hd__nand3_1 A B C VGND VNB VPB VPWR Y
.ends

* Black-box entry subcircuit for sky130_fd_sc_hd__a32o_1 abstract view
.subckt sky130_fd_sc_hd__a32o_1 A1 A2 A3 B1 B2 VGND VNB VPB VPWR X
.ends

* Black-box entry subcircuit for sky130_fd_sc_hd__xor2_2 abstract view
.subckt sky130_fd_sc_hd__xor2_2 A B VGND VNB VPB VPWR X
.ends

* Black-box entry subcircuit for sky130_fd_sc_hd__dfxtp_2 abstract view
.subckt sky130_fd_sc_hd__dfxtp_2 CLK D VGND VNB VPB VPWR Q
.ends

* Black-box entry subcircuit for sky130_fd_sc_hd__or2_2 abstract view
.subckt sky130_fd_sc_hd__or2_2 A B VGND VNB VPB VPWR X
.ends

* Black-box entry subcircuit for sky130_fd_sc_hd__a22o_1 abstract view
.subckt sky130_fd_sc_hd__a22o_1 A1 A2 B1 B2 VGND VNB VPB VPWR X
.ends

* Black-box entry subcircuit for sky130_fd_sc_hd__o32a_2 abstract view
.subckt sky130_fd_sc_hd__o32a_2 A1 A2 A3 B1 B2 VGND VNB VPB VPWR X
.ends

* Black-box entry subcircuit for sky130_fd_sc_hd__nor2_2 abstract view
.subckt sky130_fd_sc_hd__nor2_2 A B VGND VNB VPB VPWR Y
.ends

* Black-box entry subcircuit for sky130_fd_sc_hd__o32ai_4 abstract view
.subckt sky130_fd_sc_hd__o32ai_4 A1 A2 A3 B1 B2 VGND VNB VPB VPWR Y
.ends

* Black-box entry subcircuit for sky130_fd_sc_hd__o31ai_4 abstract view
.subckt sky130_fd_sc_hd__o31ai_4 A1 A2 A3 B1 VGND VNB VPB VPWR Y
.ends

* Black-box entry subcircuit for sky130_fd_sc_hd__or3_4 abstract view
.subckt sky130_fd_sc_hd__or3_4 A B C VGND VNB VPB VPWR X
.ends

* Black-box entry subcircuit for sky130_fd_sc_hd__xnor2_4 abstract view
.subckt sky130_fd_sc_hd__xnor2_4 A B VGND VNB VPB VPWR Y
.ends

* Black-box entry subcircuit for sky130_fd_sc_hd__nor2b_2 abstract view
.subckt sky130_fd_sc_hd__nor2b_2 A B_N VGND VNB VPB VPWR Y
.ends

* Black-box entry subcircuit for sky130_fd_sc_hd__clkbuf_16 abstract view
.subckt sky130_fd_sc_hd__clkbuf_16 A VGND VNB VPB VPWR X
.ends

* Black-box entry subcircuit for sky130_fd_sc_hd__a21boi_1 abstract view
.subckt sky130_fd_sc_hd__a21boi_1 A1 A2 B1_N VGND VNB VPB VPWR Y
.ends

* Black-box entry subcircuit for sky130_fd_sc_hd__a21oi_2 abstract view
.subckt sky130_fd_sc_hd__a21oi_2 A1 A2 B1 VGND VNB VPB VPWR Y
.ends

* Black-box entry subcircuit for sky130_fd_sc_hd__nor2_4 abstract view
.subckt sky130_fd_sc_hd__nor2_4 A B VGND VNB VPB VPWR Y
.ends

* Black-box entry subcircuit for sky130_fd_sc_hd__clkbuf_2 abstract view
.subckt sky130_fd_sc_hd__clkbuf_2 A VGND VNB VPB VPWR X
.ends

* Black-box entry subcircuit for sky130_fd_sc_hd__o31a_2 abstract view
.subckt sky130_fd_sc_hd__o31a_2 A1 A2 A3 B1 VGND VNB VPB VPWR X
.ends

* Black-box entry subcircuit for sky130_fd_sc_hd__clkinvlp_2 abstract view
.subckt sky130_fd_sc_hd__clkinvlp_2 A VGND VNB VPB VPWR Y
.ends

* Black-box entry subcircuit for sky130_fd_sc_hd__a2bb2o_1 abstract view
.subckt sky130_fd_sc_hd__a2bb2o_1 A1_N A2_N B1 B2 VGND VNB VPB VPWR X
.ends

* Black-box entry subcircuit for sky130_fd_sc_hd__and2_4 abstract view
.subckt sky130_fd_sc_hd__and2_4 A B VGND VNB VPB VPWR X
.ends

* Black-box entry subcircuit for sky130_fd_sc_hd__a21bo_1 abstract view
.subckt sky130_fd_sc_hd__a21bo_1 A1 A2 B1_N VGND VNB VPB VPWR X
.ends

* Black-box entry subcircuit for sky130_fd_sc_hd__o22a_1 abstract view
.subckt sky130_fd_sc_hd__o22a_1 A1 A2 B1 B2 VGND VNB VPB VPWR X
.ends

* Black-box entry subcircuit for sky130_fd_sc_hd__o21ba_1 abstract view
.subckt sky130_fd_sc_hd__o21ba_1 A1 A2 B1_N VGND VNB VPB VPWR X
.ends

* Black-box entry subcircuit for sky130_fd_sc_hd__o311a_4 abstract view
.subckt sky130_fd_sc_hd__o311a_4 A1 A2 A3 B1 C1 VGND VNB VPB VPWR X
.ends

* Black-box entry subcircuit for sky130_fd_sc_hd__buf_4 abstract view
.subckt sky130_fd_sc_hd__buf_4 A VGND VNB VPB VPWR X
.ends

* Black-box entry subcircuit for sky130_fd_sc_hd__o21ai_2 abstract view
.subckt sky130_fd_sc_hd__o21ai_2 A1 A2 B1 VGND VNB VPB VPWR Y
.ends

* Black-box entry subcircuit for sky130_fd_sc_hd__dlygate4sd3_1 abstract view
.subckt sky130_fd_sc_hd__dlygate4sd3_1 A VGND VNB VPB VPWR X
.ends

* Black-box entry subcircuit for sky130_fd_sc_hd__o41a_4 abstract view
.subckt sky130_fd_sc_hd__o41a_4 A1 A2 A3 A4 B1 VGND VNB VPB VPWR X
.ends

* Black-box entry subcircuit for sky130_fd_sc_hd__clkinv_1 abstract view
.subckt sky130_fd_sc_hd__clkinv_1 A VGND VNB VPB VPWR Y
.ends

* Black-box entry subcircuit for sky130_fd_sc_hd__a41o_1 abstract view
.subckt sky130_fd_sc_hd__a41o_1 A1 A2 A3 A4 B1 VGND VNB VPB VPWR X
.ends

* Black-box entry subcircuit for sky130_fd_sc_hd__nand2_2 abstract view
.subckt sky130_fd_sc_hd__nand2_2 A B VGND VNB VPB VPWR Y
.ends

* Black-box entry subcircuit for sky130_fd_sc_hd__a22oi_1 abstract view
.subckt sky130_fd_sc_hd__a22oi_1 A1 A2 B1 B2 VGND VNB VPB VPWR Y
.ends

* Black-box entry subcircuit for sky130_fd_sc_hd__or2b_2 abstract view
.subckt sky130_fd_sc_hd__or2b_2 A B_N VGND VNB VPB VPWR X
.ends

* Black-box entry subcircuit for sky130_fd_sc_hd__or4bb_1 abstract view
.subckt sky130_fd_sc_hd__or4bb_1 A B C_N D_N VGND VNB VPB VPWR X
.ends

* Black-box entry subcircuit for sky130_fd_sc_hd__and3b_2 abstract view
.subckt sky130_fd_sc_hd__and3b_2 A_N B C VGND VNB VPB VPWR X
.ends

* Black-box entry subcircuit for sky130_fd_sc_hd__o221a_1 abstract view
.subckt sky130_fd_sc_hd__o221a_1 A1 A2 B1 B2 C1 VGND VNB VPB VPWR X
.ends

* Black-box entry subcircuit for sky130_fd_sc_hd__or3b_1 abstract view
.subckt sky130_fd_sc_hd__or3b_1 A B C_N VGND VNB VPB VPWR X
.ends

* Black-box entry subcircuit for sky130_fd_sc_hd__nand4_1 abstract view
.subckt sky130_fd_sc_hd__nand4_1 A B C D VGND VNB VPB VPWR Y
.ends

* Black-box entry subcircuit for sky130_fd_sc_hd__or2_4 abstract view
.subckt sky130_fd_sc_hd__or2_4 A B VGND VNB VPB VPWR X
.ends

* Black-box entry subcircuit for sky130_fd_sc_hd__a2bb2o_2 abstract view
.subckt sky130_fd_sc_hd__a2bb2o_2 A1_N A2_N B1 B2 VGND VNB VPB VPWR X
.ends

* Black-box entry subcircuit for sky130_fd_sc_hd__o2111a_1 abstract view
.subckt sky130_fd_sc_hd__o2111a_1 A1 A2 B1 C1 D1 VGND VNB VPB VPWR X
.ends

* Black-box entry subcircuit for sky130_fd_sc_hd__o32a_1 abstract view
.subckt sky130_fd_sc_hd__o32a_1 A1 A2 A3 B1 B2 VGND VNB VPB VPWR X
.ends

* Black-box entry subcircuit for sky130_fd_sc_hd__a211oi_1 abstract view
.subckt sky130_fd_sc_hd__a211oi_1 A1 A2 B1 C1 VGND VNB VPB VPWR Y
.ends

* Black-box entry subcircuit for sky130_fd_sc_hd__o22ai_1 abstract view
.subckt sky130_fd_sc_hd__o22ai_1 A1 A2 B1 B2 VGND VNB VPB VPWR Y
.ends

* Black-box entry subcircuit for sky130_fd_sc_hd__a221o_1 abstract view
.subckt sky130_fd_sc_hd__a221o_1 A1 A2 B1 B2 C1 VGND VNB VPB VPWR X
.ends

* Black-box entry subcircuit for sky130_fd_sc_hd__or4b_2 abstract view
.subckt sky130_fd_sc_hd__or4b_2 A B C D_N VGND VNB VPB VPWR X
.ends

* Black-box entry subcircuit for sky130_fd_sc_hd__o31ai_1 abstract view
.subckt sky130_fd_sc_hd__o31ai_1 A1 A2 A3 B1 VGND VNB VPB VPWR Y
.ends

* Black-box entry subcircuit for sky130_fd_sc_hd__and2_2 abstract view
.subckt sky130_fd_sc_hd__and2_2 A B VGND VNB VPB VPWR X
.ends

* Black-box entry subcircuit for sky130_fd_sc_hd__nand2_4 abstract view
.subckt sky130_fd_sc_hd__nand2_4 A B VGND VNB VPB VPWR Y
.ends

* Black-box entry subcircuit for sky130_fd_sc_hd__o21a_2 abstract view
.subckt sky130_fd_sc_hd__o21a_2 A1 A2 B1 VGND VNB VPB VPWR X
.ends

* Black-box entry subcircuit for sky130_fd_sc_hd__o221ai_2 abstract view
.subckt sky130_fd_sc_hd__o221ai_2 A1 A2 B1 B2 C1 VGND VNB VPB VPWR Y
.ends

* Black-box entry subcircuit for sky130_fd_sc_hd__xor2_4 abstract view
.subckt sky130_fd_sc_hd__xor2_4 A B VGND VNB VPB VPWR X
.ends

* Black-box entry subcircuit for sky130_fd_sc_hd__or4b_1 abstract view
.subckt sky130_fd_sc_hd__or4b_1 A B C D_N VGND VNB VPB VPWR X
.ends

* Black-box entry subcircuit for sky130_fd_sc_hd__nor3_1 abstract view
.subckt sky130_fd_sc_hd__nor3_1 A B C VGND VNB VPB VPWR Y
.ends

* Black-box entry subcircuit for sky130_fd_sc_hd__buf_8 abstract view
.subckt sky130_fd_sc_hd__buf_8 A VGND VNB VPB VPWR X
.ends

* Black-box entry subcircuit for sky130_fd_sc_hd__or4_1 abstract view
.subckt sky130_fd_sc_hd__or4_1 A B C D VGND VNB VPB VPWR X
.ends

* Black-box entry subcircuit for sky130_fd_sc_hd__a21o_4 abstract view
.subckt sky130_fd_sc_hd__a21o_4 A1 A2 B1 VGND VNB VPB VPWR X
.ends

* Black-box entry subcircuit for sky130_fd_sc_hd__nand3b_1 abstract view
.subckt sky130_fd_sc_hd__nand3b_1 A_N B C VGND VNB VPB VPWR Y
.ends

* Black-box entry subcircuit for sky130_fd_sc_hd__and3b_1 abstract view
.subckt sky130_fd_sc_hd__and3b_1 A_N B C VGND VNB VPB VPWR X
.ends

* Black-box entry subcircuit for sky130_fd_sc_hd__a21oi_4 abstract view
.subckt sky130_fd_sc_hd__a21oi_4 A1 A2 B1 VGND VNB VPB VPWR Y
.ends

* Black-box entry subcircuit for sky130_fd_sc_hd__or4b_4 abstract view
.subckt sky130_fd_sc_hd__or4b_4 A B C D_N VGND VNB VPB VPWR X
.ends

* Black-box entry subcircuit for sky130_fd_sc_hd__o21ai_4 abstract view
.subckt sky130_fd_sc_hd__o21ai_4 A1 A2 B1 VGND VNB VPB VPWR Y
.ends

* Black-box entry subcircuit for sky130_fd_sc_hd__a21o_2 abstract view
.subckt sky130_fd_sc_hd__a21o_2 A1 A2 B1 VGND VNB VPB VPWR X
.ends

* Black-box entry subcircuit for sky130_fd_sc_hd__conb_1 abstract view
.subckt sky130_fd_sc_hd__conb_1 VGND VNB VPB VPWR HI LO
.ends

* Black-box entry subcircuit for sky130_fd_sc_hd__nor3b_2 abstract view
.subckt sky130_fd_sc_hd__nor3b_2 A B C_N VGND VNB VPB VPWR Y
.ends

* Black-box entry subcircuit for sky130_fd_sc_hd__o2111ai_4 abstract view
.subckt sky130_fd_sc_hd__o2111ai_4 A1 A2 B1 C1 D1 VGND VNB VPB VPWR Y
.ends

* Black-box entry subcircuit for sky130_fd_sc_hd__o2bb2a_1 abstract view
.subckt sky130_fd_sc_hd__o2bb2a_1 A1_N A2_N B1 B2 VGND VNB VPB VPWR X
.ends

* Black-box entry subcircuit for sky130_fd_sc_hd__o311ai_2 abstract view
.subckt sky130_fd_sc_hd__o311ai_2 A1 A2 A3 B1 C1 VGND VNB VPB VPWR Y
.ends

* Black-box entry subcircuit for sky130_fd_sc_hd__a311oi_2 abstract view
.subckt sky130_fd_sc_hd__a311oi_2 A1 A2 A3 B1 C1 VGND VNB VPB VPWR Y
.ends

* Black-box entry subcircuit for sky130_fd_sc_hd__or2b_4 abstract view
.subckt sky130_fd_sc_hd__or2b_4 A B_N VGND VNB VPB VPWR X
.ends

* Black-box entry subcircuit for sky130_fd_sc_hd__a32o_2 abstract view
.subckt sky130_fd_sc_hd__a32o_2 A1 A2 A3 B1 B2 VGND VNB VPB VPWR X
.ends

* Black-box entry subcircuit for sky130_fd_sc_hd__or3b_2 abstract view
.subckt sky130_fd_sc_hd__or3b_2 A B C_N VGND VNB VPB VPWR X
.ends

* Black-box entry subcircuit for sky130_fd_sc_hd__a211o_2 abstract view
.subckt sky130_fd_sc_hd__a211o_2 A1 A2 B1 C1 VGND VNB VPB VPWR X
.ends

* Black-box entry subcircuit for sky130_fd_sc_hd__o21bai_2 abstract view
.subckt sky130_fd_sc_hd__o21bai_2 A1 A2 B1_N VGND VNB VPB VPWR Y
.ends

* Black-box entry subcircuit for sky130_fd_sc_hd__a31oi_4 abstract view
.subckt sky130_fd_sc_hd__a31oi_4 A1 A2 A3 B1 VGND VNB VPB VPWR Y
.ends

* Black-box entry subcircuit for sky130_fd_sc_hd__nand2b_2 abstract view
.subckt sky130_fd_sc_hd__nand2b_2 A_N B VGND VNB VPB VPWR Y
.ends

* Black-box entry subcircuit for sky130_fd_sc_hd__a311oi_1 abstract view
.subckt sky130_fd_sc_hd__a311oi_1 A1 A2 A3 B1 C1 VGND VNB VPB VPWR Y
.ends

* Black-box entry subcircuit for sky130_fd_sc_hd__o211ai_1 abstract view
.subckt sky130_fd_sc_hd__o211ai_1 A1 A2 B1 C1 VGND VNB VPB VPWR Y
.ends

* Black-box entry subcircuit for sky130_fd_sc_hd__o21a_4 abstract view
.subckt sky130_fd_sc_hd__o21a_4 A1 A2 B1 VGND VNB VPB VPWR X
.ends

* Black-box entry subcircuit for sky130_fd_sc_hd__nor3b_1 abstract view
.subckt sky130_fd_sc_hd__nor3b_1 A B C_N VGND VNB VPB VPWR Y
.ends

* Black-box entry subcircuit for sky130_fd_sc_hd__nor4_1 abstract view
.subckt sky130_fd_sc_hd__nor4_1 A B C D VGND VNB VPB VPWR Y
.ends

* Black-box entry subcircuit for sky130_fd_sc_hd__a21boi_4 abstract view
.subckt sky130_fd_sc_hd__a21boi_4 A1 A2 B1_N VGND VNB VPB VPWR Y
.ends

* Black-box entry subcircuit for sky130_fd_sc_hd__dlymetal6s4s_1 abstract view
.subckt sky130_fd_sc_hd__dlymetal6s4s_1 A VGND VNB VPB VPWR X
.ends

* Black-box entry subcircuit for sky130_fd_sc_hd__and2b_2 abstract view
.subckt sky130_fd_sc_hd__and2b_2 A_N B VGND VNB VPB VPWR X
.ends

.subckt DotProductUnit_E2M1_x_E2M1_scale_UE2M6 VGND VPWR clock io_accOut[0] io_accOut[10]
+ io_accOut[11] io_accOut[12] io_accOut[13] io_accOut[14] io_accOut[15] io_accOut[16]
+ io_accOut[17] io_accOut[18] io_accOut[19] io_accOut[1] io_accOut[20] io_accOut[21]
+ io_accOut[22] io_accOut[23] io_accOut[24] io_accOut[25] io_accOut[26] io_accOut[27]
+ io_accOut[28] io_accOut[29] io_accOut[2] io_accOut[30] io_accOut[31] io_accOut[3]
+ io_accOut[4] io_accOut[5] io_accOut[6] io_accOut[7] io_accOut[8] io_accOut[9] io_done
+ io_inA[0] io_inA[1] io_inA[2] io_inA[3] io_inB[0] io_inB[1] io_inB[2] io_inB[3]
+ io_inScaleA[0] io_inScaleA[1] io_inScaleA[2] io_inScaleA[3] io_inScaleA[4] io_inScaleA[5]
+ io_inScaleA[6] io_inScaleA[7] io_inScaleB[0] io_inScaleB[1] io_inScaleB[2] io_inScaleB[3]
+ io_inScaleB[4] io_inScaleB[5] io_inScaleB[6] io_inScaleB[7] io_resetAcc io_start
+ reset
Xaccumulator._1593_ accumulator._0689_ accumulator._0644_ accumulator._0526_ VGND
+ VGND VPWR VPWR accumulator._0690_ sky130_fd_sc_hd__mux2_1
Xaccumulator._2214_ accumulator._0141_ accumulator._0149_ accumulator._0093_ VGND
+ VGND VPWR VPWR accumulator._0011_ sky130_fd_sc_hd__o21a_1
XFILLER_0_64_306 VGND VGND VPWR VPWR sky130_fd_sc_hd__fill_2
Xaccumulator._2076_ accumulator._1052_ accumulator._1172_ accumulator._1085_ VGND
+ VGND VPWR VPWR accumulator._1173_ sky130_fd_sc_hd__a21oi_1
Xaccumulator._2145_ accumulator._1088_ accumulator._1139_ VGND VGND VPWR VPWR accumulator._0079_
+ sky130_fd_sc_hd__nor2_8
XFILLER_0_43_81 VPWR VGND VPWR VGND sky130_ef_sc_hd__decap_12
XFILLER_0_17_211 VGND VGND VPWR VPWR sky130_fd_sc_hd__fill_1
XTAP_TAPCELL_ROW_20_301 VGND VPWR sky130_fd_sc_hd__tapvpwrvgnd_1
Xaccumulator._1929_ accumulator._0918_ accumulator._0941_ VGND VGND VPWR VPWR accumulator._1026_
+ sky130_fd_sc_hd__nand2_1
XFILLER_0_32_247 VGND VGND VPWR VPWR sky130_fd_sc_hd__decap_4
XFILLER_0_70_309 VPWR VGND VPWR VGND sky130_ef_sc_hd__decap_12
XFILLER_0_63_383 VGND VGND VPWR VPWR sky130_fd_sc_hd__decap_3
XFILLER_0_48_380 VPWR VGND VPWR VGND sky130_ef_sc_hd__decap_12
XPHY_EDGE_ROW_39_Left_110 VGND VGND VPWR VPWR sky130_fd_sc_hd__decap_3
XFILLER_0_23_203 VGND VGND VPWR VPWR sky130_fd_sc_hd__decap_8
XscaleAdd._650_ scaleAdd._186_ scaleAdd._202_ scaleAdd._224_ VGND VGND VPWR VPWR scaleAdd._225_
+ sky130_fd_sc_hd__o21a_1
Xrebuffer7 scaleAdd._107_ VGND VGND VPWR VPWR net64 sky130_fd_sc_hd__dlygate4sd1_1
XscaleAdd._581_ scaleAdd._319_ scaleAdd._085_ scaleAdd._156_ VGND VGND VPWR VPWR scaleAdd._158_
+ sky130_fd_sc_hd__and3_1
XFILLER_0_48_59 VGND VGND VPWR VPWR sky130_fd_sc_hd__fill_1
XFILLER_0_48_15 VPWR VGND VPWR VGND sky130_ef_sc_hd__decap_12
XTAP_TAPCELL_ROW_59_592 VGND VPWR sky130_fd_sc_hd__tapvpwrvgnd_1
XFILLER_0_61_309 VGND VGND VPWR VPWR sky130_fd_sc_hd__decap_6
XFILLER_0_58_155 VGND VGND VPWR VPWR sky130_fd_sc_hd__fill_1
XTAP_TAPCELL_ROW_42_470 VGND VPWR sky130_fd_sc_hd__tapvpwrvgnd_1
XTAP_TAPCELL_ROW_34_404 VGND VPWR sky130_fd_sc_hd__tapvpwrvgnd_1
XFILLER_0_54_383 VPWR VGND VPWR VGND sky130_ef_sc_hd__decap_12
XFILLER_0_54_361 VGND VGND VPWR VPWR sky130_fd_sc_hd__decap_3
XFILLER_0_22_280 VPWR VGND VPWR VGND sky130_ef_sc_hd__decap_12
XFILLER_0_13_95 VGND VGND VPWR VPWR sky130_fd_sc_hd__decap_3
XFILLER_0_14_236 VGND VGND VPWR VPWR sky130_fd_sc_hd__fill_1
Xaccumulator._1714_ accumulator._0740_ accumulator._0619_ accumulator._0651_ accumulator._0810_
+ VGND VGND VPWR VPWR accumulator._0811_ sky130_fd_sc_hd__a211oi_2
Xaccumulator._1645_ accumulator._0635_ accumulator._0664_ accumulator._0667_ accumulator._0651_
+ VGND VGND VPWR VPWR accumulator._0742_ sky130_fd_sc_hd__a31o_1
Xaccumulator._1576_ accumulator._0669_ accumulator._0671_ accumulator._0672_ accumulator._0553_
+ VGND VGND VPWR VPWR accumulator._0673_ sky130_fd_sc_hd__a31oi_1
XFILLER_0_49_144 VPWR VGND VPWR VGND sky130_ef_sc_hd__decap_12
XFILLER_0_49_111 VGND VGND VPWR VPWR sky130_fd_sc_hd__fill_1
Xaccumulator._2059_ accumulator._0919_ accumulator._1155_ VGND VGND VPWR VPWR accumulator._1156_
+ sky130_fd_sc_hd__nor2_1
Xaccumulator._2128_ accumulator._1183_ accumulator._0051_ accumulator._1186_ VGND
+ VGND VPWR VPWR accumulator._0062_ sky130_fd_sc_hd__o21bai_1
XFILLER_0_60_397 VGND VGND VPWR VPWR sky130_fd_sc_hd__fill_2
XFILLER_0_20_206 VGND VGND VPWR VPWR sky130_fd_sc_hd__fill_1
XFILLER_0_18_18 VGND VGND VPWR VPWR sky130_fd_sc_hd__decap_8
XFILLER_0_18_29 VGND VGND VPWR VPWR sky130_fd_sc_hd__decap_6
XTAP_TAPCELL_ROW_56_573 VGND VPWR sky130_fd_sc_hd__tapvpwrvgnd_1
XFILLER_0_50_27 VGND VGND VPWR VPWR sky130_fd_sc_hd__fill_1
XFILLER_0_28_317 VPWR VGND VPWR VGND sky130_ef_sc_hd__decap_12
XFILLER_0_55_169 VGND VGND VPWR VPWR sky130_fd_sc_hd__decap_6
XFILLER_0_51_364 VGND VGND VPWR VPWR sky130_fd_sc_hd__fill_1
XFILLER_0_36_372 VPWR VGND VPWR VGND sky130_ef_sc_hd__decap_12
XFILLER_0_3_417 VGND VGND VPWR VPWR sky130_fd_sc_hd__decap_4
XscaleAdd._564_ scaleAdd._313_ scaleAdd._140_ scaleAdd._125_ VGND VGND VPWR VPWR scaleAdd._142_
+ sky130_fd_sc_hd__a21o_1
XscaleAdd._633_ scaleAdd._206_ scaleAdd._208_ VGND VGND VPWR VPWR accumulator.io_inMant\[11\]
+ sky130_fd_sc_hd__xnor2_2
XFILLER_0_11_217 VGND VGND VPWR VPWR sky130_fd_sc_hd__fill_1
XscaleAdd._702_ scaleAdd._273_ scaleAdd._261_ VGND VGND VPWR VPWR scaleAdd._274_ sky130_fd_sc_hd__nand2_1
XFILLER_0_59_69 VGND VGND VPWR VPWR sky130_fd_sc_hd__decap_8
Xaccumulator._1430_ accumulator.io_accOut\[5\] net60 accumulator._0431_ accumulator._0414_
+ VGND VGND VPWR VPWR accumulator._0527_ sky130_fd_sc_hd__a31o_1
XscaleAdd._495_ scaleAdd._074_ VGND VGND VPWR VPWR accumulator.io_inMant\[7\] sky130_fd_sc_hd__buf_1
Xaccumulator._1361_ accumulator._0447_ accumulator._0457_ VGND VGND VPWR VPWR accumulator._0458_
+ sky130_fd_sc_hd__nor2_1
XFILLER_0_24_50 VPWR VGND VPWR VGND sky130_ef_sc_hd__decap_12
Xaccumulator._1292_ accumulator.io_accOut\[29\] net79 VGND VGND VPWR VPWR accumulator._0391_
+ sky130_fd_sc_hd__nand2_1
XTAP_TAPCELL_ROW_19_297 VGND VPWR sky130_fd_sc_hd__tapvpwrvgnd_1
XFILLER_0_61_139 VPWR VGND VPWR VGND sky130_ef_sc_hd__decap_12
XFILLER_0_46_114 VGND VGND VPWR VPWR sky130_fd_sc_hd__decap_3
XFILLER_0_42_353 VGND VGND VPWR VPWR sky130_fd_sc_hd__decap_4
Xaccumulator._1628_ accumulator._0635_ accumulator._0722_ accumulator._0723_ accumulator._0724_
+ VGND VGND VPWR VPWR accumulator._0725_ sky130_fd_sc_hd__a31oi_2
Xaccumulator._1559_ accumulator._0476_ accumulator._0578_ accumulator._0584_ VGND
+ VGND VPWR VPWR accumulator._0656_ sky130_fd_sc_hd__and3_1
XTAP_TAPCELL_ROW_2_165 VGND VPWR sky130_fd_sc_hd__tapvpwrvgnd_1
Xoperator._17_ net2 net3 net6 net7 VGND VGND VPWR VPWR operator._03_ sky130_fd_sc_hd__and4_1
XFILLER_0_60_161 VGND VGND VPWR VPWR sky130_fd_sc_hd__fill_2
XFILLER_0_52_139 VGND VGND VPWR VPWR sky130_fd_sc_hd__fill_1
XFILLER_0_52_106 VGND VGND VPWR VPWR sky130_fd_sc_hd__decap_4
XFILLER_0_37_169 VPWR VGND VPWR VGND sky130_ef_sc_hd__decap_12
XFILLER_0_18_383 VPWR VGND VPWR VGND sky130_ef_sc_hd__decap_12
XFILLER_0_60_194 VGND VGND VPWR VPWR sky130_fd_sc_hd__fill_2
XFILLER_0_61_15 VPWR VGND VPWR VGND sky130_ef_sc_hd__decap_12
XFILLER_0_45_27 VPWR VGND VPWR VGND sky130_ef_sc_hd__decap_12
XFILLER_0_0_29 VPWR VGND VPWR VGND sky130_ef_sc_hd__decap_12
XFILLER_0_16_309 VPWR VGND VPWR VGND sky130_ef_sc_hd__decap_12
XFILLER_0_24_397 VGND VGND VPWR VPWR sky130_fd_sc_hd__decap_4
XPHY_EDGE_ROW_24_Left_95 VGND VGND VPWR VPWR sky130_fd_sc_hd__decap_3
XFILLER_0_3_225 VGND VGND VPWR VPWR sky130_fd_sc_hd__fill_2
XFILLER_0_3_214 VGND VGND VPWR VPWR sky130_fd_sc_hd__decap_8
XscaleAdd._547_ operator.io_outMant\[3\] scaleAdd._025_ VGND VGND VPWR VPWR scaleAdd._125_
+ sky130_fd_sc_hd__and2_1
XscaleAdd._616_ scaleAdd._337_ scaleAdd._085_ VGND VGND VPWR VPWR scaleAdd._192_ sky130_fd_sc_hd__or2_1
XFILLER_0_10_41 VGND VGND VPWR VPWR sky130_fd_sc_hd__fill_2
XTAP_TAPCELL_ROW_67_657 VGND VPWR sky130_fd_sc_hd__tapvpwrvgnd_1
Xaccumulator._1413_ accumulator._0478_ accumulator._0509_ accumulator._0469_ VGND
+ VGND VPWR VPWR accumulator._0510_ sky130_fd_sc_hd__a21o_1
Xaccumulator._2393_ accumulator._0320_ accumulator._0322_ accumulator._0325_ VGND
+ VGND VPWR VPWR accumulator._0326_ sky130_fd_sc_hd__and3_1
XscaleAdd._478_ scaleAdd._002_ scaleAdd._019_ scaleAdd._057_ VGND VGND VPWR VPWR scaleAdd._058_
+ sky130_fd_sc_hd__a21o_1
XFILLER_0_19_83 VGND VGND VPWR VPWR sky130_fd_sc_hd__fill_1
XTAP_TAPCELL_ROW_50_524 VGND VPWR sky130_fd_sc_hd__tapvpwrvgnd_1
XFILLER_0_47_412 VGND VGND VPWR VPWR sky130_fd_sc_hd__decap_4
Xaccumulator._1275_ accumulator._0370_ accumulator.io_accOut\[24\] VGND VGND VPWR
+ VPWR accumulator._0374_ sky130_fd_sc_hd__and2b_1
Xaccumulator._1344_ accumulator.io_inMant\[8\] accumulator.io_inMant\[9\] accumulator._0345_
+ VGND VGND VPWR VPWR accumulator._0441_ sky130_fd_sc_hd__mux2_1
XFILLER_0_62_404 VPWR VGND VPWR VGND sky130_ef_sc_hd__decap_12
XFILLER_0_51_81 VGND VGND VPWR VPWR sky130_fd_sc_hd__decap_6
XFILLER_0_42_161 VGND VGND VPWR VPWR sky130_fd_sc_hd__fill_1
XFILLER_0_34_117 VGND VGND VPWR VPWR sky130_fd_sc_hd__decap_8
XFILLER_0_15_342 VPWR VGND VPWR VGND sky130_ef_sc_hd__decap_12
XFILLER_0_15_397 VPWR VGND VPWR VGND sky130_ef_sc_hd__decap_12
XFILLER_0_19_169 VGND VGND VPWR VPWR sky130_fd_sc_hd__decap_4
XTAP_TAPCELL_ROW_7_202 VGND VPWR sky130_fd_sc_hd__tapvpwrvgnd_1
XFILLER_0_15_19 VPWR VGND VPWR VGND sky130_ef_sc_hd__decap_12
XFILLER_0_65_297 VGND VGND VPWR VPWR sky130_fd_sc_hd__decap_8
XFILLER_0_65_275 VGND VGND VPWR VPWR sky130_fd_sc_hd__fill_1
XFILLER_0_25_128 VGND VGND VPWR VPWR sky130_fd_sc_hd__fill_1
XTAP_TAPCELL_ROW_13_248 VGND VPWR sky130_fd_sc_hd__tapvpwrvgnd_1
XscaleAdd._401_ scaleAdd._334_ scaleAdd._342_ VGND VGND VPWR VPWR scaleAdd._343_ sky130_fd_sc_hd__xor2_1
XFILLER_0_21_312 VGND VGND VPWR VPWR sky130_fd_sc_hd__fill_2
XFILLER_0_56_15 VPWR VGND VPWR VGND sky130_ef_sc_hd__decap_12
XFILLER_0_56_231 VGND VGND VPWR VPWR sky130_fd_sc_hd__fill_1
XFILLER_0_29_401 VPWR VGND VPWR VGND sky130_ef_sc_hd__decap_12
XTAP_TAPCELL_ROW_29_370 VGND VPWR sky130_fd_sc_hd__tapvpwrvgnd_1
XFILLER_0_8_306 VGND VGND VPWR VPWR sky130_fd_sc_hd__fill_2
Xaccumulator._1962_ accumulator._1058_ accumulator._0851_ VGND VGND VPWR VPWR accumulator._1059_
+ sky130_fd_sc_hd__or2b_1
XFILLER_0_21_51 VGND VGND VPWR VPWR sky130_fd_sc_hd__fill_1
Xaccumulator._1893_ accumulator._0918_ accumulator._0987_ accumulator._0989_ VGND
+ VGND VPWR VPWR accumulator._0990_ sky130_fd_sc_hd__o21ai_1
XFILLER_0_12_345 VPWR VGND VPWR VGND sky130_ef_sc_hd__decap_12
XFILLER_0_12_389 VPWR VGND VPWR VGND sky130_ef_sc_hd__decap_12
Xaccumulator._1327_ accumulator._0421_ accumulator._0423_ VGND VGND VPWR VPWR accumulator._0424_
+ sky130_fd_sc_hd__xnor2_2
XFILLER_0_34_3 VPWR VGND VPWR VGND sky130_ef_sc_hd__decap_12
Xaccumulator._2376_ accumulator._0297_ accumulator._0300_ accumulator._0307_ accumulator._0308_
+ VGND VGND VPWR VPWR accumulator._0309_ sky130_fd_sc_hd__o31a_1
XFILLER_0_62_212 VPWR VGND VPWR VGND sky130_ef_sc_hd__decap_12
Xaccumulator._1258_ accumulator._0343_ accumulator._0355_ net63 VGND VGND VPWR VPWR
+ accumulator._0357_ sky130_fd_sc_hd__o21a_1
XFILLER_0_7_361 VPWR VGND VPWR VGND sky130_ef_sc_hd__decap_12
XTAP_TAPCELL_ROW_10_229 VGND VPWR sky130_fd_sc_hd__tapvpwrvgnd_1
XFILLER_0_15_161 VGND VGND VPWR VPWR sky130_fd_sc_hd__decap_6
XTAP_TAPCELL_ROW_61_608 VGND VPWR sky130_fd_sc_hd__tapvpwrvgnd_1
XTAP_TAPCELL_ROW_26_351 VGND VPWR sky130_fd_sc_hd__tapvpwrvgnd_1
XFILLER_0_38_253 VPWR VGND VPWR VGND sky130_ef_sc_hd__decap_12
XFILLER_0_5_309 VPWR VGND VPWR VGND sky130_ef_sc_hd__decap_12
XFILLER_0_67_69 VPWR VGND VPWR VGND sky130_ef_sc_hd__decap_12
XFILLER_0_21_175 VGND VGND VPWR VPWR sky130_fd_sc_hd__fill_1
XFILLER_0_21_131 VGND VGND VPWR VPWR sky130_fd_sc_hd__fill_1
Xaccumulator._2230_ accumulator._0080_ accumulator._0163_ accumulator._0164_ accumulator._0089_
+ VGND VGND VPWR VPWR accumulator._0165_ sky130_fd_sc_hd__o211a_1
Xrebuffer28 net86 VGND VGND VPWR VPWR net85 sky130_fd_sc_hd__dlygate4sd1_1
Xrebuffer17 scaleAdd._279_ VGND VGND VPWR VPWR net74 sky130_fd_sc_hd__buf_6
Xaccumulator._2092_ accumulator._1153_ accumulator._1185_ accumulator._0981_ VGND
+ VGND VPWR VPWR accumulator._1190_ sky130_fd_sc_hd__o21ai_1
Xaccumulator._2161_ accumulator._0081_ accumulator._0094_ net69 VGND VGND VPWR VPWR
+ accumulator._0096_ sky130_fd_sc_hd__mux2_2
XFILLER_0_32_83 VGND VGND VPWR VPWR sky130_fd_sc_hd__fill_1
XFILLER_0_29_275 VGND VGND VPWR VPWR sky130_fd_sc_hd__decap_4
XFILLER_0_29_253 VGND VGND VPWR VPWR sky130_fd_sc_hd__decap_8
XFILLER_0_8_136 VGND VGND VPWR VPWR sky130_fd_sc_hd__decap_4
Xaccumulator._1945_ accumulator._0918_ accumulator._0822_ VGND VGND VPWR VPWR accumulator._1042_
+ sky130_fd_sc_hd__or2_1
XFILLER_0_44_256 VPWR VGND VPWR VGND sky130_ef_sc_hd__decap_12
XFILLER_0_32_407 VGND VGND VPWR VPWR sky130_fd_sc_hd__fill_1
XFILLER_0_12_120 VGND VGND VPWR VPWR sky130_fd_sc_hd__decap_8
Xaccumulator._1876_ accumulator._0921_ accumulator._0676_ VGND VGND VPWR VPWR accumulator._0973_
+ sky130_fd_sc_hd__nor2_1
XFILLER_0_67_337 VPWR VGND VPWR VGND sky130_ef_sc_hd__decap_12
XPHY_EDGE_ROW_11_Left_82 VGND VGND VPWR VPWR sky130_fd_sc_hd__decap_3
Xaccumulator._2359_ accumulator._0357_ VGND VGND VPWR VPWR accumulator._0291_ sky130_fd_sc_hd__inv_2
Xaccumulator._2428_ clknet_2_1__leaf_clock accumulator._0029_ VGND VGND VPWR VPWR
+ accumulator.io_accOut\[27\] sky130_fd_sc_hd__dfxtp_1
XFILLER_0_35_223 VGND VGND VPWR VPWR sky130_fd_sc_hd__fill_1
XFILLER_0_35_212 VGND VGND VPWR VPWR sky130_fd_sc_hd__decap_6
Xoutput31 net31 VGND VGND VPWR VPWR io_accOut[18] sky130_fd_sc_hd__buf_2
Xoutput53 net53 VGND VGND VPWR VPWR io_accOut[9] sky130_fd_sc_hd__buf_2
Xoutput42 net42 VGND VGND VPWR VPWR io_accOut[28] sky130_fd_sc_hd__buf_2
XFILLER_0_53_27 VPWR VGND VPWR VGND sky130_ef_sc_hd__decap_12
XFILLER_0_37_39 VPWR VGND VPWR VGND sky130_ef_sc_hd__decap_12
Xaccumulator._1730_ accumulator._0824_ accumulator._0825_ VGND VGND VPWR VPWR accumulator._0827_
+ sky130_fd_sc_hd__nand2_1
XFILLER_0_41_237 VPWR VGND VPWR VGND sky130_ef_sc_hd__decap_12
XFILLER_0_26_256 VPWR VGND VPWR VGND sky130_ef_sc_hd__decap_12
Xaccumulator._1661_ accumulator._0635_ accumulator._0757_ VGND VGND VPWR VPWR accumulator._0758_
+ sky130_fd_sc_hd__or2_1
Xaccumulator._1592_ accumulator.io_accOut\[5\] accumulator._0539_ accumulator._0531_
+ accumulator._0640_ VGND VGND VPWR VPWR accumulator._0689_ sky130_fd_sc_hd__a31oi_1
Xaccumulator._2213_ accumulator._0080_ accumulator._0147_ accumulator._0148_ accumulator._0089_
+ VGND VGND VPWR VPWR accumulator._0149_ sky130_fd_sc_hd__o211a_1
Xaccumulator._2144_ accumulator._0078_ VGND VGND VPWR VPWR accumulator._0005_ sky130_fd_sc_hd__clkbuf_1
Xaccumulator._2075_ accumulator._1038_ accumulator._1171_ accumulator._1056_ VGND
+ VGND VPWR VPWR accumulator._1172_ sky130_fd_sc_hd__a21o_1
XTAP_TAPCELL_ROW_45_490 VGND VPWR sky130_fd_sc_hd__tapvpwrvgnd_1
XFILLER_0_43_93 VGND VGND VPWR VPWR sky130_fd_sc_hd__fill_1
XTAP_TAPCELL_ROW_20_302 VGND VPWR sky130_fd_sc_hd__tapvpwrvgnd_1
Xaccumulator._1859_ accumulator._0880_ accumulator._0881_ VGND VGND VPWR VPWR accumulator._0956_
+ sky130_fd_sc_hd__or2_1
Xaccumulator._1928_ accumulator._1011_ accumulator._1018_ accumulator._1024_ VGND
+ VGND VPWR VPWR accumulator._1025_ sky130_fd_sc_hd__or3_1
XFILLER_0_67_167 VGND VGND VPWR VPWR sky130_fd_sc_hd__fill_1
XFILLER_0_67_156 VGND VGND VPWR VPWR sky130_fd_sc_hd__fill_1
XFILLER_0_48_392 VGND VGND VPWR VPWR sky130_fd_sc_hd__fill_1
Xrebuffer8 net73 VGND VGND VPWR VPWR net65 sky130_fd_sc_hd__dlymetal6s2s_1
XscaleAdd._580_ scaleAdd._319_ scaleAdd._085_ scaleAdd._156_ VGND VGND VPWR VPWR scaleAdd._157_
+ sky130_fd_sc_hd__a21oi_1
XFILLER_0_48_27 VGND VGND VPWR VPWR sky130_fd_sc_hd__fill_1
XFILLER_0_31_281 VPWR VGND VPWR VGND sky130_ef_sc_hd__decap_12
XFILLER_0_64_15 VPWR VGND VPWR VGND sky130_ef_sc_hd__decap_12
XTAP_TAPCELL_ROW_59_593 VGND VPWR sky130_fd_sc_hd__tapvpwrvgnd_1
XTAP_TAPCELL_ROW_34_405 VGND VPWR sky130_fd_sc_hd__tapvpwrvgnd_1
XTAP_TAPCELL_ROW_42_471 VGND VPWR sky130_fd_sc_hd__tapvpwrvgnd_1
XFILLER_0_39_370 VPWR VGND VPWR VGND sky130_ef_sc_hd__decap_12
XFILLER_0_13_74 VGND VGND VPWR VPWR sky130_fd_sc_hd__decap_8
XFILLER_0_54_395 VGND VGND VPWR VPWR sky130_fd_sc_hd__fill_1
Xaccumulator._1713_ accumulator._0627_ accumulator._0634_ accumulator._0740_ VGND
+ VGND VPWR VPWR accumulator._0810_ sky130_fd_sc_hd__a21oi_1
XFILLER_0_22_292 VGND VGND VPWR VPWR sky130_fd_sc_hd__fill_2
XFILLER_0_1_175 VGND VGND VPWR VPWR sky130_fd_sc_hd__decap_3
Xaccumulator._1644_ accumulator._0525_ accumulator._0657_ accumulator._0660_ VGND
+ VGND VPWR VPWR accumulator._0741_ sky130_fd_sc_hd__o21ai_1
Xaccumulator._1575_ accumulator._0427_ accumulator._0475_ accumulator._0533_ VGND
+ VGND VPWR VPWR accumulator._0672_ sky130_fd_sc_hd__or3_1
XFILLER_0_38_93 VGND VGND VPWR VPWR sky130_fd_sc_hd__decap_3
Xaccumulator._2127_ accumulator._1196_ VGND VGND VPWR VPWR accumulator._0061_ sky130_fd_sc_hd__clkbuf_4
XFILLER_0_49_156 VPWR VGND VPWR VGND sky130_ef_sc_hd__decap_12
XFILLER_0_64_159 VGND VGND VPWR VPWR sky130_fd_sc_hd__fill_1
XFILLER_0_60_365 VPWR VGND VPWR VGND sky130_ef_sc_hd__decap_12
Xaccumulator._2058_ accumulator._0726_ accumulator._0715_ VGND VGND VPWR VPWR accumulator._1155_
+ sky130_fd_sc_hd__nor2_1
XFILLER_0_13_281 VPWR VGND VPWR VGND sky130_ef_sc_hd__decap_12
XTAP_TAPCELL_ROW_56_574 VGND VPWR sky130_fd_sc_hd__tapvpwrvgnd_1
XFILLER_0_34_29 VPWR VGND VPWR VGND sky130_ef_sc_hd__decap_12
XFILLER_0_28_329 VGND VGND VPWR VPWR sky130_fd_sc_hd__decap_6
XscaleAdd._701_ scaleAdd._258_ scaleAdd._259_ VGND VGND VPWR VPWR scaleAdd._273_ sky130_fd_sc_hd__or2_1
XFILLER_0_59_15 VPWR VGND VPWR VGND sky130_ef_sc_hd__decap_12
XFILLER_0_36_384 VPWR VGND VPWR VGND sky130_ef_sc_hd__decap_12
XscaleAdd._563_ scaleAdd._313_ scaleAdd._125_ scaleAdd._140_ VGND VGND VPWR VPWR scaleAdd._141_
+ sky130_fd_sc_hd__and3_1
XscaleAdd._632_ scaleAdd._207_ scaleAdd._180_ VGND VGND VPWR VPWR scaleAdd._208_ sky130_fd_sc_hd__and2_1
XscaleAdd._494_ scaleAdd._072_ scaleAdd._073_ VGND VGND VPWR VPWR scaleAdd._074_ sky130_fd_sc_hd__and2_1
Xaccumulator._1360_ accumulator._0439_ accumulator._0454_ accumulator._0456_ VGND
+ VGND VPWR VPWR accumulator._0457_ sky130_fd_sc_hd__a21oi_1
XFILLER_0_24_62 VPWR VGND VPWR VGND sky130_ef_sc_hd__decap_12
Xaccumulator._1291_ accumulator.io_accOut\[29\] net79 VGND VGND VPWR VPWR accumulator._0390_
+ sky130_fd_sc_hd__or2_1
XTAP_TAPCELL_ROW_19_298 VGND VPWR sky130_fd_sc_hd__tapvpwrvgnd_1
XFILLER_0_54_192 VGND VGND VPWR VPWR sky130_fd_sc_hd__decap_4
XFILLER_0_40_83 VGND VGND VPWR VPWR sky130_fd_sc_hd__fill_1
XFILLER_0_27_362 VGND VGND VPWR VPWR sky130_fd_sc_hd__decap_6
XFILLER_0_6_234 VGND VGND VPWR VPWR sky130_fd_sc_hd__fill_1
XFILLER_0_6_245 VGND VGND VPWR VPWR sky130_fd_sc_hd__fill_1
XFILLER_0_64_3 VPWR VGND VPWR VGND sky130_ef_sc_hd__decap_12
XPHY_EDGE_ROW_58_Left_129 VGND VGND VPWR VPWR sky130_fd_sc_hd__decap_3
XFILLER_0_10_251 VGND VGND VPWR VPWR sky130_fd_sc_hd__fill_1
XPHY_EDGE_ROW_12_Right_12 VGND VGND VPWR VPWR sky130_fd_sc_hd__decap_3
Xaccumulator._1627_ accumulator._0553_ accumulator._0599_ accumulator._0526_ accumulator._0598_
+ VGND VGND VPWR VPWR accumulator._0724_ sky130_fd_sc_hd__and4_1
Xaccumulator._1489_ accumulator._0526_ accumulator._0572_ accumulator._0585_ VGND
+ VGND VPWR VPWR accumulator._0586_ sky130_fd_sc_hd__a21o_1
Xaccumulator._1558_ accumulator._0653_ accumulator._0654_ VGND VGND VPWR VPWR accumulator._0655_
+ sky130_fd_sc_hd__nand2_1
Xoperator._16_ operator._01_ operator._02_ VGND VGND VPWR VPWR operator.io_outExp\[0\]
+ sky130_fd_sc_hd__xor2_1
XPHY_EDGE_ROW_21_Right_21 VGND VGND VPWR VPWR sky130_fd_sc_hd__decap_3
XTAP_TAPCELL_ROW_2_166 VGND VPWR sky130_fd_sc_hd__tapvpwrvgnd_1
XPHY_EDGE_ROW_67_Left_138 VGND VGND VPWR VPWR sky130_fd_sc_hd__decap_3
XPHY_EDGE_ROW_30_Right_30 VGND VGND VPWR VPWR sky130_fd_sc_hd__decap_3
XFILLER_0_18_395 VPWR VGND VPWR VGND sky130_ef_sc_hd__decap_12
XFILLER_0_29_18 VPWR VGND VPWR VGND sky130_ef_sc_hd__decap_12
XFILLER_0_61_27 VPWR VGND VPWR VGND sky130_ef_sc_hd__decap_12
XFILLER_0_56_413 VGND VGND VPWR VPWR sky130_fd_sc_hd__decap_3
XFILLER_0_45_39 VPWR VGND VPWR VGND sky130_ef_sc_hd__decap_12
XFILLER_0_36_181 VGND VGND VPWR VPWR sky130_fd_sc_hd__fill_1
XFILLER_0_24_354 VGND VGND VPWR VPWR sky130_fd_sc_hd__decap_6
XFILLER_0_24_321 VPWR VGND VPWR VGND sky130_ef_sc_hd__decap_12
XFILLER_0_24_365 VPWR VGND VPWR VGND sky130_ef_sc_hd__decap_12
XFILLER_0_3_237 VPWR VGND VPWR VGND sky130_ef_sc_hd__decap_12
XscaleAdd._546_ operator.io_outMant\[1\] net64 VGND VGND VPWR VPWR scaleAdd._124_
+ sky130_fd_sc_hd__nand2_1
XscaleAdd._615_ scaleAdd._159_ scaleAdd._161_ VGND VGND VPWR VPWR scaleAdd._191_ sky130_fd_sc_hd__nand2_1
XFILLER_0_10_64 VGND VGND VPWR VPWR sky130_fd_sc_hd__fill_1
XscaleAdd._477_ scaleAdd._018_ scaleAdd._017_ VGND VGND VPWR VPWR scaleAdd._057_ sky130_fd_sc_hd__and2b_1
XTAP_TAPCELL_ROW_67_658 VGND VPWR sky130_fd_sc_hd__tapvpwrvgnd_1
Xaccumulator._1412_ accumulator.io_accOut\[12\] accumulator._0508_ accumulator._0485_
+ VGND VGND VPWR VPWR accumulator._0509_ sky130_fd_sc_hd__mux2_1
XFILLER_0_29_6 VPWR VGND VPWR VGND sky130_ef_sc_hd__decap_12
Xaccumulator._1343_ accumulator._0437_ accumulator._0438_ accumulator._0439_ VGND
+ VGND VPWR VPWR accumulator._0440_ sky130_fd_sc_hd__mux2_1
Xaccumulator._2392_ accumulator._0324_ accumulator._0321_ VGND VGND VPWR VPWR accumulator._0325_
+ sky130_fd_sc_hd__xor2_1
XFILLER_0_62_416 VGND VGND VPWR VPWR sky130_fd_sc_hd__decap_4
XFILLER_0_59_251 VGND VGND VPWR VPWR sky130_fd_sc_hd__decap_6
XTAP_TAPCELL_ROW_50_525 VGND VPWR sky130_fd_sc_hd__tapvpwrvgnd_1
Xaccumulator._1274_ accumulator.io_accOut\[23\] accumulator._0372_ accumulator._0362_
+ accumulator._0344_ VGND VGND VPWR VPWR accumulator._0373_ sky130_fd_sc_hd__or4_4
XFILLER_0_15_354 VGND VGND VPWR VPWR sky130_fd_sc_hd__decap_4
XTAP_TAPCELL_ROW_7_203 VGND VPWR sky130_fd_sc_hd__tapvpwrvgnd_1
XTAP_TAPCELL_ROW_13_249 VGND VPWR sky130_fd_sc_hd__tapvpwrvgnd_1
XscaleAdd._400_ scaleAdd._340_ scaleAdd._341_ VGND VGND VPWR VPWR scaleAdd._342_ sky130_fd_sc_hd__xor2_1
XFILLER_0_56_27 VGND VGND VPWR VPWR sky130_fd_sc_hd__fill_1
XFILLER_0_29_413 VGND VGND VPWR VPWR sky130_fd_sc_hd__decap_4
XTAP_TAPCELL_ROW_29_371 VGND VPWR sky130_fd_sc_hd__tapvpwrvgnd_1
Xaccumulator._1961_ accumulator._0857_ accumulator._0944_ accumulator._0950_ VGND
+ VGND VPWR VPWR accumulator._1058_ sky130_fd_sc_hd__o21a_1
Xaccumulator._1892_ accumulator._0605_ accumulator._0988_ VGND VGND VPWR VPWR accumulator._0989_
+ sky130_fd_sc_hd__nand2_1
XFILLER_0_24_195 VGND VGND VPWR VPWR sky130_fd_sc_hd__fill_1
XscaleAdd._529_ operator.io_outMant\[0\] scaleAdd._107_ VGND VGND VPWR VPWR scaleAdd._108_
+ sky130_fd_sc_hd__nand2_1
XFILLER_0_12_357 VGND VGND VPWR VPWR sky130_fd_sc_hd__decap_6
Xaccumulator._1326_ accumulator._0394_ accumulator._0422_ VGND VGND VPWR VPWR accumulator._0423_
+ sky130_fd_sc_hd__nor2_1
XFILLER_0_1_51 VGND VGND VPWR VPWR sky130_fd_sc_hd__decap_4
Xaccumulator._2375_ accumulator._0297_ accumulator._0300_ accumulator._0307_ VGND
+ VGND VPWR VPWR accumulator._0308_ sky130_fd_sc_hd__o21ai_1
XFILLER_0_62_224 VPWR VGND VPWR VGND sky130_ef_sc_hd__decap_12
Xaccumulator._1257_ accumulator._0353_ accumulator._0354_ accumulator._0351_ accumulator._0348_
+ VGND VGND VPWR VPWR accumulator._0356_ sky130_fd_sc_hd__a211o_1
XFILLER_0_7_373 VPWR VGND VPWR VGND sky130_ef_sc_hd__decap_12
XFILLER_0_15_184 VGND VGND VPWR VPWR sky130_fd_sc_hd__decap_6
XTAP_TAPCELL_ROW_61_609 VGND VPWR sky130_fd_sc_hd__tapvpwrvgnd_1
XFILLER_0_42_29 VPWR VGND VPWR VGND sky130_ef_sc_hd__decap_12
XFILLER_0_38_265 VGND VGND VPWR VPWR sky130_fd_sc_hd__decap_3
XFILLER_0_41_408 VGND VGND VPWR VPWR sky130_fd_sc_hd__decap_8
XFILLER_0_67_15 VPWR VGND VPWR VGND sky130_ef_sc_hd__decap_12
XFILLER_0_21_165 VGND VGND VPWR VPWR sky130_fd_sc_hd__decap_3
XFILLER_0_6_29 VPWR VGND VPWR VGND sky130_ef_sc_hd__decap_12
Xaccumulator._2160_ accumulator._1002_ accumulator._1007_ VGND VGND VPWR VPWR accumulator._0094_
+ sky130_fd_sc_hd__xnor2_1
Xrebuffer18 accumulator._0340_ VGND VGND VPWR VPWR net75 sky130_fd_sc_hd__clkbuf_1
Xrebuffer29 net87 VGND VGND VPWR VPWR net86 sky130_fd_sc_hd__dlygate4sd1_1
XFILLER_0_16_85 VGND VGND VPWR VPWR sky130_fd_sc_hd__decap_8
Xaccumulator._2091_ accumulator._1099_ accumulator._1101_ VGND VGND VPWR VPWR accumulator._1189_
+ sky130_fd_sc_hd__nor2_1
Xaccumulator._1944_ accumulator._1028_ accumulator._1029_ accumulator._1036_ VGND
+ VGND VPWR VPWR accumulator._1041_ sky130_fd_sc_hd__and3_1
Xaccumulator._1875_ accumulator._0970_ accumulator._0971_ VGND VGND VPWR VPWR accumulator._0972_
+ sky130_fd_sc_hd__nor2_1
XFILLER_0_44_268 VPWR VGND VPWR VGND sky130_ef_sc_hd__decap_12
XFILLER_0_4_365 VPWR VGND VPWR VGND sky130_ef_sc_hd__decap_12
XFILLER_0_4_321 VPWR VGND VPWR VGND sky130_ef_sc_hd__decap_12
XPHY_EDGE_ROW_6_Right_6 VGND VGND VPWR VPWR sky130_fd_sc_hd__decap_3
Xaccumulator._2427_ clknet_2_1__leaf_clock accumulator._0028_ VGND VGND VPWR VPWR
+ accumulator.io_accOut\[26\] sky130_fd_sc_hd__dfxtp_1
XFILLER_0_67_349 VPWR VGND VPWR VGND sky130_ef_sc_hd__decap_12
XFILLER_0_67_305 VPWR VGND VPWR VGND sky130_ef_sc_hd__decap_12
Xaccumulator._2289_ accumulator._0086_ accumulator._0219_ accumulator._0222_ VGND
+ VGND VPWR VPWR accumulator._0223_ sky130_fd_sc_hd__or3_1
Xaccumulator._1309_ accumulator.io_inSign accumulator._0395_ accumulator._0398_ accumulator._0400_
+ accumulator._0407_ VGND VGND VPWR VPWR accumulator._0000_ sky130_fd_sc_hd__o311a_1
Xaccumulator._2358_ accumulator._0167_ accumulator._0289_ accumulator._0290_ VGND
+ VGND VPWR VPWR accumulator._0028_ sky130_fd_sc_hd__a21oi_1
XTAP_TAPCELL_ROW_23_322 VGND VPWR sky130_fd_sc_hd__tapvpwrvgnd_1
XFILLER_0_23_419 VGND VGND VPWR VPWR sky130_fd_sc_hd__fill_2
Xoutput32 net32 VGND VGND VPWR VPWR io_accOut[19] sky130_fd_sc_hd__buf_2
Xoutput54 net54 VGND VGND VPWR VPWR io_done sky130_fd_sc_hd__buf_2
Xoutput43 net43 VGND VGND VPWR VPWR io_accOut[29] sky130_fd_sc_hd__buf_2
XFILLER_0_53_39 VPWR VGND VPWR VGND sky130_ef_sc_hd__decap_12
XPHY_EDGE_ROW_59_Right_59 VGND VGND VPWR VPWR sky130_fd_sc_hd__decap_3
XFILLER_0_41_249 VGND VGND VPWR VPWR sky130_fd_sc_hd__decap_4
XFILLER_0_41_205 VPWR VGND VPWR VGND sky130_ef_sc_hd__decap_12
XFILLER_0_26_268 VGND VGND VPWR VPWR sky130_fd_sc_hd__fill_2
XFILLER_0_1_335 VGND VGND VPWR VPWR sky130_fd_sc_hd__fill_1
XPHY_EDGE_ROW_68_Right_68 VGND VGND VPWR VPWR sky130_fd_sc_hd__decap_3
Xaccumulator._1591_ accumulator._0559_ accumulator._0684_ accumulator._0687_ accumulator._0635_
+ VGND VGND VPWR VPWR accumulator._0688_ sky130_fd_sc_hd__a211oi_2
Xaccumulator._1660_ accumulator._0755_ accumulator._0756_ accumulator._0525_ VGND
+ VGND VPWR VPWR accumulator._0757_ sky130_fd_sc_hd__mux2_2
Xaccumulator._2212_ accumulator._0128_ accumulator._0049_ accumulator._0054_ accumulator._1141_
+ VGND VGND VPWR VPWR accumulator._0148_ sky130_fd_sc_hd__a211o_1
Xaccumulator._2143_ accumulator._0399_ accumulator._0077_ VGND VGND VPWR VPWR accumulator._0078_
+ sky130_fd_sc_hd__and2_1
XFILLER_0_27_84 VPWR VGND VPWR VGND sky130_ef_sc_hd__decap_12
Xaccumulator._2074_ accumulator._1024_ accumulator._1170_ accumulator._1031_ VGND
+ VGND VPWR VPWR accumulator._1171_ sky130_fd_sc_hd__o21ai_1
XTAP_TAPCELL_ROW_45_491 VGND VPWR sky130_fd_sc_hd__tapvpwrvgnd_1
XFILLER_0_17_279 VGND VGND VPWR VPWR sky130_fd_sc_hd__fill_1
XTAP_TAPCELL_ROW_20_303 VGND VPWR sky130_fd_sc_hd__tapvpwrvgnd_1
Xaccumulator._1858_ accumulator._0886_ VGND VGND VPWR VPWR accumulator._0955_ sky130_fd_sc_hd__inv_2
Xaccumulator._1927_ accumulator._1022_ accumulator._1023_ VGND VGND VPWR VPWR accumulator._1024_
+ sky130_fd_sc_hd__xnor2_2
XFILLER_0_40_282 VGND VGND VPWR VPWR sky130_fd_sc_hd__fill_1
Xaccumulator._1789_ accumulator.io_accOut\[19\] accumulator._0563_ accumulator._0404_
+ VGND VGND VPWR VPWR accumulator._0886_ sky130_fd_sc_hd__mux2_4
XFILLER_0_63_352 VGND VGND VPWR VPWR sky130_fd_sc_hd__decap_8
Xrebuffer9 accumulator._0373_ VGND VGND VPWR VPWR net66 sky130_fd_sc_hd__clkbuf_1
XFILLER_0_64_27 VGND VGND VPWR VPWR sky130_fd_sc_hd__fill_1
XFILLER_0_31_293 VPWR VGND VPWR VGND sky130_ef_sc_hd__decap_12
XTAP_TAPCELL_ROW_59_594 VGND VPWR sky130_fd_sc_hd__tapvpwrvgnd_1
XFILLER_0_58_113 VPWR VGND VPWR VGND sky130_ef_sc_hd__decap_12
XTAP_TAPCELL_ROW_34_406 VGND VPWR sky130_fd_sc_hd__tapvpwrvgnd_1
XFILLER_0_54_330 VGND VGND VPWR VPWR sky130_fd_sc_hd__decap_8
XFILLER_0_39_382 VGND VGND VPWR VPWR sky130_fd_sc_hd__decap_6
Xaccumulator._1712_ accumulator._0798_ accumulator._0745_ accumulator._0805_ accumulator._0807_
+ accumulator._0808_ VGND VGND VPWR VPWR accumulator._0809_ sky130_fd_sc_hd__a311o_1
Xaccumulator._1643_ accumulator._0734_ VGND VGND VPWR VPWR accumulator._0740_ sky130_fd_sc_hd__buf_2
XFILLER_0_1_165 VGND VGND VPWR VPWR sky130_fd_sc_hd__decap_3
Xaccumulator._1574_ accumulator._0543_ accumulator._0645_ accumulator._0670_ accumulator._0427_
+ accumulator._0497_ VGND VGND VPWR VPWR accumulator._0671_ sky130_fd_sc_hd__a2111o_1
XFILLER_0_38_83 VGND VGND VPWR VPWR sky130_fd_sc_hd__fill_1
Xaccumulator._2057_ accumulator._1111_ accumulator._1135_ VGND VGND VPWR VPWR accumulator._1154_
+ sky130_fd_sc_hd__nor2_1
Xaccumulator._2126_ accumulator._1182_ accumulator._0059_ accumulator._1196_ VGND
+ VGND VPWR VPWR accumulator._0060_ sky130_fd_sc_hd__mux2_1
XFILLER_0_49_113 VPWR VGND VPWR VGND sky130_ef_sc_hd__decap_12
XFILLER_0_9_221 VGND VGND VPWR VPWR sky130_fd_sc_hd__decap_3
XFILLER_0_9_243 VPWR VGND VPWR VGND sky130_ef_sc_hd__decap_12
XFILLER_0_70_81 VGND VGND VPWR VPWR sky130_fd_sc_hd__decap_3
XFILLER_0_60_377 VPWR VGND VPWR VGND sky130_ef_sc_hd__decap_12
XFILLER_0_13_293 VPWR VGND VPWR VGND sky130_ef_sc_hd__decap_12
XTAP_TAPCELL_ROW_56_575 VGND VPWR sky130_fd_sc_hd__tapvpwrvgnd_1
XTAP_TAPCELL_ROW_48_509 VGND VPWR sky130_fd_sc_hd__tapvpwrvgnd_1
XFILLER_0_50_29 VPWR VGND VPWR VGND sky130_ef_sc_hd__decap_12
XFILLER_0_36_396 VGND VGND VPWR VPWR sky130_fd_sc_hd__fill_2
XscaleAdd._631_ scaleAdd._175_ scaleAdd._177_ VGND VGND VPWR VPWR scaleAdd._207_ sky130_fd_sc_hd__nand2_1
XscaleAdd._700_ scaleAdd._270_ scaleAdd._271_ VGND VGND VPWR VPWR scaleAdd._272_ sky130_fd_sc_hd__or2_1
XFILLER_0_59_27 VPWR VGND VPWR VGND sky130_ef_sc_hd__decap_12
XscaleAdd._562_ scaleAdd._137_ scaleAdd._139_ VGND VGND VPWR VPWR scaleAdd._140_ sky130_fd_sc_hd__xnor2_2
XscaleAdd._493_ scaleAdd._042_ scaleAdd._039_ scaleAdd._071_ VGND VGND VPWR VPWR scaleAdd._073_
+ sky130_fd_sc_hd__nand3_1
XFILLER_0_46_138 VGND VGND VPWR VPWR sky130_fd_sc_hd__fill_2
XFILLER_0_24_85 VPWR VGND VPWR VGND sky130_ef_sc_hd__decap_12
XFILLER_0_24_74 VGND VGND VPWR VPWR sky130_fd_sc_hd__decap_8
XFILLER_0_24_41 VGND VGND VPWR VPWR sky130_fd_sc_hd__decap_6
Xaccumulator._1290_ accumulator._0387_ accumulator._0384_ accumulator._0388_ VGND
+ VGND VPWR VPWR accumulator._0389_ sky130_fd_sc_hd__a21o_1
XFILLER_0_57_3 VPWR VGND VPWR VGND sky130_ef_sc_hd__decap_12
Xaccumulator._1626_ accumulator._0477_ accumulator._0499_ accumulator._0428_ VGND
+ VGND VPWR VPWR accumulator._0723_ sky130_fd_sc_hd__a21o_1
XFILLER_0_4_51 VGND VGND VPWR VPWR sky130_fd_sc_hd__fill_2
XFILLER_0_65_81 VGND VGND VPWR VPWR sky130_fd_sc_hd__decap_6
Xaccumulator._1557_ accumulator.io_accOut\[1\] accumulator._0394_ VGND VGND VPWR VPWR
+ accumulator._0654_ sky130_fd_sc_hd__nand2_1
Xaccumulator._1488_ accumulator._0497_ accumulator._0578_ accumulator._0584_ VGND
+ VGND VPWR VPWR accumulator._0585_ sky130_fd_sc_hd__and3_1
Xoperator._15_ net6 net7 VGND VGND VPWR VPWR operator._02_ sky130_fd_sc_hd__and2b_1
XTAP_TAPCELL_ROW_2_167 VGND VPWR sky130_fd_sc_hd__tapvpwrvgnd_1
Xaccumulator._2109_ accumulator._1142_ accumulator._0039_ accumulator._0042_ accumulator._0397_
+ accumulator.io_accOut\[0\] VGND VGND VPWR VPWR accumulator._0043_ sky130_fd_sc_hd__a32o_1
XFILLER_0_18_363 VGND VGND VPWR VPWR sky130_fd_sc_hd__fill_1
XFILLER_0_60_141 VPWR VGND VPWR VGND sky130_ef_sc_hd__decap_12
XFILLER_0_33_366 VPWR VGND VPWR VGND sky130_ef_sc_hd__decap_12
XFILLER_0_61_39 VPWR VGND VPWR VGND sky130_ef_sc_hd__decap_12
XFILLER_0_56_403 VGND VGND VPWR VPWR sky130_fd_sc_hd__fill_1
XTAP_TAPCELL_ROW_16_269 VGND VPWR sky130_fd_sc_hd__tapvpwrvgnd_1
XFILLER_0_51_141 VGND VGND VPWR VPWR sky130_fd_sc_hd__decap_3
XFILLER_0_24_377 VGND VGND VPWR VPWR sky130_fd_sc_hd__fill_2
XFILLER_0_24_333 VGND VGND VPWR VPWR sky130_fd_sc_hd__decap_3
XFILLER_0_24_300 VGND VGND VPWR VPWR sky130_fd_sc_hd__decap_8
XFILLER_0_3_249 VPWR VGND VPWR VGND sky130_ef_sc_hd__decap_12
XscaleAdd._614_ scaleAdd._136_ scaleAdd._166_ scaleAdd._167_ scaleAdd._163_ VGND VGND
+ VPWR VPWR scaleAdd._190_ sky130_fd_sc_hd__o31a_1
XscaleAdd._545_ operator.io_outMant\[2\] scaleAdd._077_ VGND VGND VPWR VPWR scaleAdd._123_
+ sky130_fd_sc_hd__and2_1
XscaleAdd._476_ scaleAdd._048_ scaleAdd._055_ VGND VGND VPWR VPWR scaleAdd._056_ sky130_fd_sc_hd__xnor2_2
XFILLER_0_35_51 VGND VGND VPWR VPWR sky130_fd_sc_hd__decap_4
Xaccumulator._1411_ accumulator._0116_ accumulator._0507_ VGND VGND VPWR VPWR accumulator._0508_
+ sky130_fd_sc_hd__nor2_1
Xaccumulator._2391_ accumulator.io_accOut\[30\] accumulator._0392_ VGND VGND VPWR
+ VPWR accumulator._0324_ sky130_fd_sc_hd__nand2_1
Xaccumulator._1342_ accumulator._0215_ VGND VGND VPWR VPWR accumulator._0439_ sky130_fd_sc_hd__clkbuf_4
Xaccumulator._1273_ accumulator.io_inExp\[0\] accumulator._0345_ VGND VGND VPWR VPWR
+ accumulator._0372_ sky130_fd_sc_hd__nor2_1
XTAP_TAPCELL_ROW_50_526 VGND VPWR sky130_fd_sc_hd__tapvpwrvgnd_1
XFILLER_0_35_95 VGND VGND VPWR VPWR sky130_fd_sc_hd__fill_2
XFILLER_0_30_325 VGND VGND VPWR VPWR sky130_fd_sc_hd__fill_1
XTAP_TAPCELL_ROW_7_204 VGND VPWR sky130_fd_sc_hd__tapvpwrvgnd_1
Xaccumulator._1609_ accumulator._0611_ accumulator._0614_ accumulator._0617_ accumulator._0558_
+ VGND VGND VPWR VPWR accumulator._0706_ sky130_fd_sc_hd__o211a_1
XFILLER_0_65_255 VPWR VGND VPWR VGND sky130_ef_sc_hd__decap_12
XFILLER_0_33_163 VGND VGND VPWR VPWR sky130_fd_sc_hd__decap_4
XFILLER_0_33_185 VPWR VGND VPWR VGND sky130_ef_sc_hd__decap_12
XTAP_TAPCELL_ROW_64_629 VGND VPWR sky130_fd_sc_hd__tapvpwrvgnd_1
XTAP_TAPCELL_ROW_29_372 VGND VPWR sky130_fd_sc_hd__tapvpwrvgnd_1
XFILLER_0_56_299 VGND VGND VPWR VPWR sky130_fd_sc_hd__fill_1
XFILLER_0_56_211 VGND VGND VPWR VPWR sky130_fd_sc_hd__fill_1
XFILLER_0_44_417 VGND VGND VPWR VPWR sky130_fd_sc_hd__decap_3
Xaccumulator._1960_ accumulator._1053_ accumulator._1056_ VGND VGND VPWR VPWR accumulator._1057_
+ sky130_fd_sc_hd__nor2_1
Xaccumulator._1891_ accumulator._0604_ accumulator._0655_ accumulator._0677_ accumulator._0933_
+ VGND VGND VPWR VPWR accumulator._0988_ sky130_fd_sc_hd__a31o_1
XFILLER_0_24_141 VPWR VGND VPWR VGND sky130_ef_sc_hd__decap_12
XFILLER_0_24_130 VGND VGND VPWR VPWR sky130_fd_sc_hd__decap_8
XscaleAdd._528_ net71 scaleAdd._099_ VGND VGND VPWR VPWR scaleAdd._107_ sky130_fd_sc_hd__xor2_2
XscaleAdd._459_ scaleAdd._037_ scaleAdd._038_ scaleAdd._000_ VGND VGND VPWR VPWR scaleAdd._040_
+ sky130_fd_sc_hd__o21ai_1
XFILLER_0_47_211 VGND VGND VPWR VPWR sky130_fd_sc_hd__decap_3
Xaccumulator._1325_ accumulator._0409_ accumulator._0417_ VGND VGND VPWR VPWR accumulator._0422_
+ sky130_fd_sc_hd__nor2_1
Xaccumulator._1256_ accumulator._0352_ accumulator._0353_ accumulator._0354_ VGND
+ VGND VPWR VPWR accumulator._0355_ sky130_fd_sc_hd__nand3_1
XFILLER_0_1_74 VPWR VGND VPWR VGND sky130_ef_sc_hd__decap_12
Xaccumulator._2374_ accumulator._0294_ accumulator._0306_ VGND VGND VPWR VPWR accumulator._0307_
+ sky130_fd_sc_hd__xnor2_2
XFILLER_0_62_236 VGND VGND VPWR VPWR sky130_fd_sc_hd__decap_8
XFILLER_0_7_385 VGND VGND VPWR VPWR sky130_fd_sc_hd__decap_6
XFILLER_0_11_391 VGND VGND VPWR VPWR sky130_fd_sc_hd__fill_1
XFILLER_0_53_269 VGND VGND VPWR VPWR sky130_fd_sc_hd__fill_1
XFILLER_0_53_225 VPWR VGND VPWR VGND sky130_ef_sc_hd__decap_12
XFILLER_0_67_27 VPWR VGND VPWR VGND sky130_ef_sc_hd__decap_12
Xaccumulator._2090_ accumulator._1135_ accumulator._1137_ VGND VGND VPWR VPWR accumulator._1188_
+ sky130_fd_sc_hd__nor2_1
Xrebuffer19 scaleAdd._227_ VGND VGND VPWR VPWR net76 sky130_fd_sc_hd__dlygate4sd1_1
XFILLER_0_16_64 VGND VGND VPWR VPWR sky130_fd_sc_hd__decap_4
XFILLER_0_69_391 VGND VGND VPWR VPWR sky130_fd_sc_hd__fill_1
XFILLER_0_32_85 VPWR VGND VPWR VGND sky130_ef_sc_hd__decap_12
XTAP_TAPCELL_ROW_32_389 VGND VPWR sky130_fd_sc_hd__tapvpwrvgnd_1
XFILLER_0_32_41 VPWR VGND VPWR VGND sky130_ef_sc_hd__decap_12
XFILLER_0_4_333 VPWR VGND VPWR VGND sky130_ef_sc_hd__decap_12
Xaccumulator._1943_ accumulator._1032_ accumulator._1039_ VGND VGND VPWR VPWR accumulator._1040_
+ sky130_fd_sc_hd__nor2_1
XFILLER_0_52_280 VGND VGND VPWR VPWR sky130_fd_sc_hd__fill_2
Xaccumulator._1874_ accumulator._0676_ accumulator._0681_ VGND VGND VPWR VPWR accumulator._0971_
+ sky130_fd_sc_hd__and2_1
XFILLER_0_4_377 VPWR VGND VPWR VGND sky130_ef_sc_hd__decap_12
XFILLER_0_12_166 VPWR VGND VPWR VGND sky130_ef_sc_hd__decap_12
Xaccumulator._2426_ clknet_2_0__leaf_clock accumulator._0027_ VGND VGND VPWR VPWR
+ accumulator.io_accOut\[25\] sky130_fd_sc_hd__dfxtp_2
XFILLER_0_67_317 VPWR VGND VPWR VGND sky130_ef_sc_hd__decap_12
Xaccumulator._2288_ accumulator._0220_ accumulator._0221_ accumulator._0072_ VGND
+ VGND VPWR VPWR accumulator._0222_ sky130_fd_sc_hd__a21oi_1
Xaccumulator._1308_ accumulator._0405_ accumulator._0406_ accumulator.io_accOut\[31\]
+ VGND VGND VPWR VPWR accumulator._0407_ sky130_fd_sc_hd__a21o_1
Xaccumulator._2357_ net105 accumulator._0167_ accumulator._0400_ VGND VGND VPWR VPWR
+ accumulator._0290_ sky130_fd_sc_hd__o21ai_1
XTAP_TAPCELL_ROW_23_323 VGND VPWR sky130_fd_sc_hd__tapvpwrvgnd_1
Xaccumulator._1239_ accumulator.io_inExp\[0\] accumulator._0336_ accumulator._0337_
+ VGND VGND VPWR VPWR accumulator._0338_ sky130_fd_sc_hd__or3_1
XFILLER_0_35_225 VGND VGND VPWR VPWR sky130_fd_sc_hd__decap_4
Xoutput22 net22 VGND VGND VPWR VPWR io_accOut[0] sky130_fd_sc_hd__buf_2
Xoutput33 net33 VGND VGND VPWR VPWR io_accOut[1] sky130_fd_sc_hd__buf_2
Xoutput44 net44 VGND VGND VPWR VPWR io_accOut[2] sky130_fd_sc_hd__buf_2
XFILLER_0_9_3 VGND VGND VPWR VPWR sky130_fd_sc_hd__decap_3
XFILLER_0_58_317 VGND VGND VPWR VPWR sky130_fd_sc_hd__decap_3
XFILLER_0_66_350 VPWR VGND VPWR VGND sky130_ef_sc_hd__decap_12
XFILLER_0_26_225 VPWR VGND VPWR VGND sky130_ef_sc_hd__decap_12
XFILLER_0_41_217 VGND VGND VPWR VPWR sky130_fd_sc_hd__decap_6
Xaccumulator._2211_ accumulator._0086_ accumulator._0142_ accumulator._0145_ VGND
+ VGND VPWR VPWR accumulator._0147_ sky130_fd_sc_hd__a21oi_1
Xaccumulator._1590_ accumulator._0599_ accumulator._0685_ accumulator._0686_ VGND
+ VGND VPWR VPWR accumulator._0687_ sky130_fd_sc_hd__and3_1
XFILLER_0_27_96 VPWR VGND VPWR VGND sky130_ef_sc_hd__decap_12
XFILLER_0_27_30 VPWR VGND VPWR VGND sky130_ef_sc_hd__decap_12
XFILLER_0_64_309 VGND VGND VPWR VPWR sky130_fd_sc_hd__fill_1
Xaccumulator._2073_ accumulator._1169_ accumulator._1008_ accumulator._1018_ VGND
+ VGND VPWR VPWR accumulator._1170_ sky130_fd_sc_hd__a21oi_1
XTAP_TAPCELL_ROW_45_492 VGND VPWR sky130_fd_sc_hd__tapvpwrvgnd_1
XFILLER_0_43_51 VGND VGND VPWR VPWR sky130_fd_sc_hd__decap_4
Xaccumulator._2142_ accumulator._1142_ accumulator._0042_ accumulator._0076_ accumulator._0396_
+ accumulator.io_accOut\[3\] VGND VGND VPWR VPWR accumulator._0077_ sky130_fd_sc_hd__a32o_1
XFILLER_0_32_206 VGND VGND VPWR VPWR sky130_fd_sc_hd__decap_3
XFILLER_0_17_247 VGND VGND VPWR VPWR sky130_fd_sc_hd__fill_1
XTAP_TAPCELL_ROW_20_304 VGND VPWR sky130_fd_sc_hd__tapvpwrvgnd_1
Xaccumulator._1857_ accumulator._0866_ accumulator._0953_ VGND VGND VPWR VPWR accumulator._0954_
+ sky130_fd_sc_hd__or2_1
Xaccumulator._1788_ accumulator._0852_ accumulator._0774_ VGND VGND VPWR VPWR accumulator._0885_
+ sky130_fd_sc_hd__or2_2
Xaccumulator._1926_ accumulator._1016_ accumulator._1015_ accumulator._0992_ VGND
+ VGND VPWR VPWR accumulator._1023_ sky130_fd_sc_hd__a21oi_1
XFILLER_0_67_103 VGND VGND VPWR VPWR sky130_fd_sc_hd__fill_1
Xaccumulator._2409_ clknet_2_2__leaf_clock accumulator._0010_ VGND VGND VPWR VPWR
+ accumulator.io_accOut\[8\] sky130_fd_sc_hd__dfxtp_1
XFILLER_0_67_169 VPWR VGND VPWR VGND sky130_ef_sc_hd__decap_12
XFILLER_0_67_147 VGND VGND VPWR VPWR sky130_fd_sc_hd__fill_1
XFILLER_0_48_29 VPWR VGND VPWR VGND sky130_ef_sc_hd__decap_12
XTAP_TAPCELL_ROW_59_595 VGND VPWR sky130_fd_sc_hd__tapvpwrvgnd_1
XFILLER_0_58_169 VGND VGND VPWR VPWR sky130_fd_sc_hd__decap_3
XFILLER_0_58_136 VGND VGND VPWR VPWR sky130_fd_sc_hd__decap_4
XFILLER_0_58_125 VGND VGND VPWR VPWR sky130_fd_sc_hd__fill_2
XFILLER_0_46_309 VPWR VGND VPWR VGND sky130_ef_sc_hd__decap_12
XTAP_TAPCELL_ROW_34_407 VGND VPWR sky130_fd_sc_hd__tapvpwrvgnd_1
XFILLER_0_54_342 VGND VGND VPWR VPWR sky130_fd_sc_hd__decap_4
XFILLER_0_14_206 VGND VGND VPWR VPWR sky130_fd_sc_hd__decap_8
Xaccumulator._1642_ accumulator._0738_ VGND VGND VPWR VPWR accumulator._0739_ sky130_fd_sc_hd__buf_1
Xaccumulator._1711_ accumulator._0743_ accumulator._0744_ VGND VGND VPWR VPWR accumulator._0808_
+ sky130_fd_sc_hd__nor2_1
XFILLER_0_22_250 VGND VGND VPWR VPWR sky130_fd_sc_hd__fill_2
XFILLER_0_1_111 VGND VGND VPWR VPWR sky130_fd_sc_hd__fill_1
XFILLER_0_1_199 VGND VGND VPWR VPWR sky130_fd_sc_hd__fill_1
XFILLER_0_10_401 VPWR VGND VPWR VGND sky130_ef_sc_hd__decap_12
Xaccumulator._1573_ accumulator.io_accOut\[0\] accumulator._0414_ accumulator._0531_
+ VGND VGND VPWR VPWR accumulator._0670_ sky130_fd_sc_hd__and3_1
Xaccumulator._2056_ accumulator._1151_ accumulator._0969_ accumulator._1152_ accumulator._0979_
+ VGND VGND VPWR VPWR accumulator._1153_ sky130_fd_sc_hd__a22o_1
Xaccumulator._2125_ accumulator._0978_ accumulator._0996_ net70 VGND VGND VPWR VPWR
+ accumulator._0059_ sky130_fd_sc_hd__mux2_1
XFILLER_0_49_125 VPWR VGND VPWR VGND sky130_ef_sc_hd__decap_12
XFILLER_0_9_255 VPWR VGND VPWR VGND sky130_ef_sc_hd__decap_12
XFILLER_0_60_389 VGND VGND VPWR VPWR sky130_fd_sc_hd__decap_8
Xaccumulator._1909_ accumulator._0795_ accumulator._1005_ VGND VGND VPWR VPWR accumulator._1006_
+ sky130_fd_sc_hd__xor2_2
XTAP_TAPCELL_ROW_5_187 VGND VPWR sky130_fd_sc_hd__tapvpwrvgnd_1
XFILLER_0_68_401 VPWR VGND VPWR VGND sky130_ef_sc_hd__decap_12
XTAP_TAPCELL_ROW_56_576 VGND VPWR sky130_fd_sc_hd__tapvpwrvgnd_1
XFILLER_0_70_109 VGND VGND VPWR VPWR sky130_fd_sc_hd__decap_3
XFILLER_0_36_331 VGND VGND VPWR VPWR sky130_fd_sc_hd__decap_4
XscaleAdd._561_ scaleAdd._099_ net71 scaleAdd._138_ VGND VGND VPWR VPWR scaleAdd._139_
+ sky130_fd_sc_hd__a21oi_1
XscaleAdd._630_ scaleAdd._204_ scaleAdd._205_ VGND VGND VPWR VPWR scaleAdd._206_ sky130_fd_sc_hd__and2b_1
XFILLER_0_59_39 VPWR VGND VPWR VGND sky130_ef_sc_hd__decap_12
XFILLER_0_11_209 VGND VGND VPWR VPWR sky130_fd_sc_hd__decap_8
XscaleAdd._492_ scaleAdd._039_ scaleAdd._042_ scaleAdd._071_ VGND VGND VPWR VPWR scaleAdd._072_
+ sky130_fd_sc_hd__a21o_1
XFILLER_0_61_109 VGND VGND VPWR VPWR sky130_fd_sc_hd__decap_3
XFILLER_0_27_353 VGND VGND VPWR VPWR sky130_fd_sc_hd__fill_2
XFILLER_0_24_97 VPWR VGND VPWR VGND sky130_ef_sc_hd__decap_12
XFILLER_0_40_41 VPWR VGND VPWR VGND sky130_ef_sc_hd__decap_12
XFILLER_0_27_375 VGND VGND VPWR VPWR sky130_fd_sc_hd__decap_3
Xaccumulator._1556_ accumulator._0606_ accumulator._0619_ accumulator._0620_ accumulator._0636_
+ accumulator._0652_ VGND VGND VPWR VPWR accumulator._0653_ sky130_fd_sc_hd__o32a_2
Xaccumulator._1625_ accumulator._0526_ accumulator._0572_ accumulator._0585_ accumulator._0599_
+ VGND VGND VPWR VPWR accumulator._0722_ sky130_fd_sc_hd__a211o_1
XFILLER_0_4_85 VPWR VGND VPWR VGND sky130_ef_sc_hd__decap_12
XFILLER_0_10_286 VGND VGND VPWR VPWR sky130_fd_sc_hd__fill_1
Xaccumulator._1487_ accumulator._0433_ accumulator._0583_ accumulator._0543_ VGND
+ VGND VPWR VPWR accumulator._0584_ sky130_fd_sc_hd__a21o_1
Xoperator._14_ net2 net3 VGND VGND VPWR VPWR operator._01_ sky130_fd_sc_hd__and2b_1
XTAP_TAPCELL_ROW_2_168 VGND VPWR sky130_fd_sc_hd__tapvpwrvgnd_1
Xaccumulator._2039_ accumulator._1105_ accumulator._1109_ accumulator._1054_ VGND
+ VGND VPWR VPWR accumulator._1136_ sky130_fd_sc_hd__a21o_1
XFILLER_0_37_117 VGND VGND VPWR VPWR sky130_fd_sc_hd__fill_1
Xaccumulator._2108_ accumulator._0396_ accumulator._0041_ VGND VGND VPWR VPWR accumulator._0042_
+ sky130_fd_sc_hd__nor2_2
XFILLER_0_33_334 VGND VGND VPWR VPWR sky130_fd_sc_hd__fill_2
XFILLER_0_60_175 VPWR VGND VPWR VGND sky130_ef_sc_hd__decap_12
XFILLER_0_60_153 VGND VGND VPWR VPWR sky130_fd_sc_hd__decap_8
XFILLER_0_33_378 VPWR VGND VPWR VGND sky130_ef_sc_hd__decap_12
XFILLER_0_28_139 VGND VGND VPWR VPWR sky130_fd_sc_hd__fill_1
XFILLER_0_51_120 VGND VGND VPWR VPWR sky130_fd_sc_hd__fill_2
XscaleAdd._613_ scaleAdd._318_ scaleAdd._188_ VGND VGND VPWR VPWR scaleAdd._189_ sky130_fd_sc_hd__nand2_1
XscaleAdd._544_ scaleAdd._076_ scaleAdd._113_ VGND VGND VPWR VPWR scaleAdd._122_ sky130_fd_sc_hd__or2_1
XFILLER_0_10_11 VGND VGND VPWR VPWR sky130_fd_sc_hd__fill_1
Xaccumulator._1410_ accumulator._0457_ accumulator._0506_ accumulator._0434_ VGND
+ VGND VPWR VPWR accumulator._0507_ sky130_fd_sc_hd__mux2_1
XscaleAdd._475_ scaleAdd._049_ scaleAdd._054_ VGND VGND VPWR VPWR scaleAdd._055_ sky130_fd_sc_hd__xor2_2
Xaccumulator._2390_ accumulator._0321_ accumulator._0306_ VGND VGND VPWR VPWR accumulator._0322_
+ sky130_fd_sc_hd__or2b_1
XFILLER_0_19_31 VPWR VGND VPWR VGND sky130_ef_sc_hd__decap_12
XFILLER_0_19_75 VGND VGND VPWR VPWR sky130_fd_sc_hd__decap_8
Xaccumulator._1272_ accumulator.io_accOut\[24\] accumulator._0370_ VGND VGND VPWR
+ VPWR accumulator._0371_ sky130_fd_sc_hd__xnor2_2
Xaccumulator._1341_ accumulator.io_inMant\[2\] accumulator.io_inMant\[3\] accumulator._0345_
+ VGND VGND VPWR VPWR accumulator._0438_ sky130_fd_sc_hd__mux2_1
XFILLER_0_59_286 VGND VGND VPWR VPWR sky130_fd_sc_hd__fill_1
XFILLER_0_51_51 VGND VGND VPWR VPWR sky130_fd_sc_hd__decap_4
XTAP_TAPCELL_ROW_50_527 VGND VPWR sky130_fd_sc_hd__tapvpwrvgnd_1
XFILLER_0_27_194 VGND VGND VPWR VPWR sky130_fd_sc_hd__decap_4
XFILLER_0_19_139 VPWR VGND VPWR VGND sky130_ef_sc_hd__decap_12
XFILLER_0_42_153 VGND VGND VPWR VPWR sky130_fd_sc_hd__decap_8
XFILLER_0_30_315 VGND VGND VPWR VPWR sky130_fd_sc_hd__fill_1
XFILLER_0_2_261 VGND VGND VPWR VPWR sky130_fd_sc_hd__fill_2
XFILLER_0_2_250 VGND VGND VPWR VPWR sky130_fd_sc_hd__fill_2
XTAP_TAPCELL_ROW_7_205 VGND VPWR sky130_fd_sc_hd__tapvpwrvgnd_1
Xaccumulator._1608_ accumulator._0651_ accumulator._0688_ accumulator._0694_ accumulator._0620_
+ accumulator._0704_ VGND VGND VPWR VPWR accumulator._0705_ sky130_fd_sc_hd__o32ai_4
Xaccumulator._1539_ accumulator._0627_ accumulator._0634_ accumulator._0635_ VGND
+ VGND VPWR VPWR accumulator._0636_ sky130_fd_sc_hd__a21oi_1
XFILLER_0_65_223 VGND VGND VPWR VPWR sky130_fd_sc_hd__fill_1
XFILLER_0_65_267 VGND VGND VPWR VPWR sky130_fd_sc_hd__decap_8
XFILLER_0_33_197 VPWR VGND VPWR VGND sky130_ef_sc_hd__decap_12
XFILLER_0_33_175 VGND VGND VPWR VPWR sky130_fd_sc_hd__fill_1
XFILLER_0_21_337 VPWR VGND VPWR VGND sky130_ef_sc_hd__decap_12
XFILLER_0_21_304 VGND VGND VPWR VPWR sky130_fd_sc_hd__decap_8
XFILLER_0_0_209 VPWR VGND VPWR VGND sky130_ef_sc_hd__decap_12
XFILLER_0_18_172 VGND VGND VPWR VPWR sky130_fd_sc_hd__fill_1
XFILLER_0_56_29 VPWR VGND VPWR VGND sky130_ef_sc_hd__decap_12
XTAP_TAPCELL_ROW_29_373 VGND VPWR sky130_fd_sc_hd__tapvpwrvgnd_1
XPHY_EDGE_ROW_28_Left_99 VGND VGND VPWR VPWR sky130_fd_sc_hd__decap_3
XFILLER_0_56_267 VGND VGND VPWR VPWR sky130_fd_sc_hd__decap_6
XFILLER_0_8_309 VPWR VGND VPWR VGND sky130_ef_sc_hd__decap_12
XTAP_TAPCELL_ROW_12_240 VGND VPWR sky130_fd_sc_hd__tapvpwrvgnd_1
Xaccumulator._1890_ accumulator._0777_ accumulator._0679_ accumulator._0729_ accumulator._0783_
+ VGND VGND VPWR VPWR accumulator._0987_ sky130_fd_sc_hd__o31a_1
XscaleAdd._527_ scaleAdd._103_ scaleAdd._101_ scaleAdd._100_ scaleAdd._105_ VGND VGND
+ VPWR VPWR scaleAdd._106_ sky130_fd_sc_hd__o31ai_4
XFILLER_0_46_73 VGND VGND VPWR VPWR sky130_fd_sc_hd__fill_1
XscaleAdd._458_ scaleAdd._000_ scaleAdd._037_ scaleAdd._038_ VGND VGND VPWR VPWR scaleAdd._039_
+ sky130_fd_sc_hd__or3_4
Xaccumulator._2373_ accumulator.io_accOut\[28\] accumulator._0305_ accumulator._0405_
+ VGND VGND VPWR VPWR accumulator._0306_ sky130_fd_sc_hd__mux2_2
XscaleAdd._389_ operator.io_outMant\[3\] scaleAdd._317_ VGND VGND VPWR VPWR scaleAdd._331_
+ sky130_fd_sc_hd__nand2_1
XFILLER_0_62_94 VPWR VGND VPWR VGND sky130_ef_sc_hd__decap_12
XFILLER_0_62_83 VGND VGND VPWR VPWR sky130_fd_sc_hd__fill_1
XFILLER_0_62_61 VGND VGND VPWR VPWR sky130_fd_sc_hd__fill_2
XFILLER_0_47_234 VPWR VGND VPWR VGND sky130_ef_sc_hd__decap_12
XFILLER_0_47_223 VGND VGND VPWR VPWR sky130_fd_sc_hd__fill_1
Xaccumulator._1255_ accumulator._0340_ accumulator._0105_ accumulator._0136_ VGND
+ VGND VPWR VPWR accumulator._0354_ sky130_fd_sc_hd__a21o_1
XFILLER_0_1_86 VPWR VGND VPWR VGND sky130_ef_sc_hd__decap_12
Xaccumulator._1324_ accumulator._0384_ accumulator._0420_ VGND VGND VPWR VPWR accumulator._0421_
+ sky130_fd_sc_hd__xnor2_4
X_29_ accumulator.io_accOut\[29\] VGND VGND VPWR VPWR net43 sky130_fd_sc_hd__clkbuf_1
XFILLER_0_70_281 VPWR VGND VPWR VGND sky130_ef_sc_hd__decap_12
XFILLER_0_47_278 VGND VGND VPWR VPWR sky130_fd_sc_hd__fill_2
XFILLER_0_35_407 VGND VGND VPWR VPWR sky130_fd_sc_hd__decap_3
XFILLER_0_15_175 VGND VGND VPWR VPWR sky130_fd_sc_hd__fill_1
XFILLER_0_53_248 VGND VGND VPWR VPWR sky130_fd_sc_hd__fill_1
XFILLER_0_53_237 VGND VGND VPWR VPWR sky130_fd_sc_hd__fill_2
XFILLER_0_53_204 VPWR VGND VPWR VGND sky130_ef_sc_hd__decap_12
XFILLER_0_26_418 VGND VGND VPWR VPWR sky130_fd_sc_hd__fill_2
XFILLER_0_67_39 VPWR VGND VPWR VGND sky130_ef_sc_hd__decap_12
XFILLER_0_61_281 VGND VGND VPWR VPWR sky130_fd_sc_hd__decap_4
XFILLER_0_21_101 VGND VGND VPWR VPWR sky130_fd_sc_hd__decap_8
XTAP_TAPCELL_ROW_60_600 VGND VPWR sky130_fd_sc_hd__tapvpwrvgnd_1
XFILLER_0_16_54 VGND VGND VPWR VPWR sky130_fd_sc_hd__decap_6
Xaccumulator._1942_ accumulator._1038_ VGND VGND VPWR VPWR accumulator._1039_ sky130_fd_sc_hd__inv_2
XFILLER_0_32_97 VGND VGND VPWR VPWR sky130_fd_sc_hd__fill_2
XFILLER_0_32_53 VPWR VGND VPWR VGND sky130_ef_sc_hd__decap_12
XFILLER_0_4_345 VPWR VGND VPWR VGND sky130_ef_sc_hd__decap_12
Xaccumulator._1873_ accumulator._0726_ accumulator._0715_ accumulator._0705_ VGND
+ VGND VPWR VPWR accumulator._0970_ sky130_fd_sc_hd__or3_1
XFILLER_0_4_389 VPWR VGND VPWR VGND sky130_ef_sc_hd__decap_12
XFILLER_0_12_178 VPWR VGND VPWR VGND sky130_ef_sc_hd__decap_12
XFILLER_0_57_72 VGND VGND VPWR VPWR sky130_fd_sc_hd__fill_2
Xaccumulator._2425_ clknet_2_0__leaf_clock accumulator._0026_ VGND VGND VPWR VPWR
+ accumulator.io_accOut\[24\] sky130_fd_sc_hd__dfxtp_1
Xaccumulator._2356_ accumulator._0287_ accumulator._0288_ VGND VGND VPWR VPWR accumulator._0289_
+ sky130_fd_sc_hd__or2_1
XFILLER_0_67_329 VGND VGND VPWR VPWR sky130_fd_sc_hd__decap_6
Xaccumulator._2287_ accumulator._1099_ accumulator._0103_ accumulator._0104_ VGND
+ VGND VPWR VPWR accumulator._0221_ sky130_fd_sc_hd__nand3_1
Xaccumulator._1307_ accumulator.state\[1\] accumulator.state\[0\] VGND VGND VPWR VPWR
+ accumulator._0406_ sky130_fd_sc_hd__nor2b_2
XTAP_TAPCELL_ROW_23_324 VGND VPWR sky130_fd_sc_hd__tapvpwrvgnd_1
Xaccumulator._1238_ accumulator.io_inExp\[1\] accumulator._0215_ VGND VGND VPWR VPWR
+ accumulator._0337_ sky130_fd_sc_hd__and2_1
Xoutput23 net23 VGND VGND VPWR VPWR io_accOut[10] sky130_fd_sc_hd__buf_2
XFILLER_0_50_229 VPWR VGND VPWR VGND sky130_ef_sc_hd__decap_12
Xoutput34 net34 VGND VGND VPWR VPWR io_accOut[20] sky130_fd_sc_hd__buf_2
XFILLER_0_43_281 VPWR VGND VPWR VGND sky130_ef_sc_hd__decap_12
XFILLER_0_43_270 VGND VGND VPWR VPWR sky130_fd_sc_hd__fill_2
XFILLER_0_7_161 VGND VGND VPWR VPWR sky130_fd_sc_hd__decap_3
Xoutput45 net45 VGND VGND VPWR VPWR io_accOut[30] sky130_fd_sc_hd__buf_2
XFILLER_0_58_307 VGND VGND VPWR VPWR sky130_fd_sc_hd__fill_1
XFILLER_0_66_362 VGND VGND VPWR VPWR sky130_fd_sc_hd__fill_2
XFILLER_0_26_237 VGND VGND VPWR VPWR sky130_fd_sc_hd__decap_6
XFILLER_0_34_292 VPWR VGND VPWR VGND sky130_ef_sc_hd__decap_12
XFILLER_0_1_337 VPWR VGND VPWR VGND sky130_ef_sc_hd__decap_12
Xaccumulator._2210_ accumulator._0111_ accumulator._0124_ accumulator._0144_ accumulator._0110_
+ VGND VGND VPWR VPWR accumulator._0145_ sky130_fd_sc_hd__o211a_1
XTAP_TAPCELL_ROW_37_427 VGND VPWR sky130_fd_sc_hd__tapvpwrvgnd_1
XFILLER_0_27_42 VPWR VGND VPWR VGND sky130_ef_sc_hd__decap_12
XFILLER_0_57_384 VGND VGND VPWR VPWR sky130_fd_sc_hd__decap_8
Xaccumulator._2072_ accumulator._0994_ accumulator._1168_ accumulator._1010_ VGND
+ VGND VPWR VPWR accumulator._1169_ sky130_fd_sc_hd__o21ai_1
XTAP_TAPCELL_ROW_45_493 VGND VPWR sky130_fd_sc_hd__tapvpwrvgnd_1
Xaccumulator._2141_ accumulator._1149_ accumulator._0071_ accumulator._0074_ VGND
+ VGND VPWR VPWR accumulator._0076_ sky130_fd_sc_hd__a21o_1
XTAP_TAPCELL_ROW_20_305 VGND VPWR sky130_fd_sc_hd__tapvpwrvgnd_1
Xaccumulator._1925_ accumulator._0928_ accumulator._1021_ VGND VGND VPWR VPWR accumulator._1022_
+ sky130_fd_sc_hd__xnor2_2
XFILLER_0_40_262 VPWR VGND VPWR VGND sky130_ef_sc_hd__decap_12
XFILLER_0_25_281 VGND VGND VPWR VPWR sky130_fd_sc_hd__decap_8
XFILLER_0_4_197 VPWR VGND VPWR VGND sky130_ef_sc_hd__decap_12
XFILLER_0_4_120 VGND VGND VPWR VPWR sky130_fd_sc_hd__fill_2
XFILLER_0_7_41 VPWR VGND VPWR VGND sky130_ef_sc_hd__decap_12
XPHY_EDGE_ROW_15_Left_86 VGND VGND VPWR VPWR sky130_fd_sc_hd__decap_3
Xaccumulator._1856_ accumulator._0879_ accumulator._0887_ VGND VGND VPWR VPWR accumulator._0953_
+ sky130_fd_sc_hd__nand2_1
XFILLER_0_68_93 VGND VGND VPWR VPWR sky130_fd_sc_hd__fill_2
Xaccumulator._1787_ accumulator._0883_ VGND VGND VPWR VPWR accumulator._0884_ sky130_fd_sc_hd__inv_2
Xaccumulator._2408_ clknet_2_1__leaf_clock accumulator._0009_ VGND VGND VPWR VPWR
+ accumulator.io_accOut\[7\] sky130_fd_sc_hd__dfxtp_1
Xaccumulator._2339_ accumulator._0367_ VGND VGND VPWR VPWR accumulator._0271_ sky130_fd_sc_hd__inv_2
XFILLER_0_31_251 VGND VGND VPWR VPWR sky130_fd_sc_hd__decap_4
XFILLER_0_16_281 VGND VGND VPWR VPWR sky130_fd_sc_hd__decap_8
XFILLER_0_16_292 VGND VGND VPWR VPWR sky130_fd_sc_hd__decap_4
XFILLER_0_64_29 VPWR VGND VPWR VGND sky130_ef_sc_hd__decap_12
XTAP_TAPCELL_ROW_59_596 VGND VPWR sky130_fd_sc_hd__tapvpwrvgnd_1
XFILLER_0_39_351 VPWR VGND VPWR VGND sky130_ef_sc_hd__decap_12
XTAP_TAPCELL_ROW_34_408 VGND VPWR sky130_fd_sc_hd__tapvpwrvgnd_1
XFILLER_0_13_55 VGND VGND VPWR VPWR sky130_fd_sc_hd__fill_1
Xaccumulator._1641_ accumulator._0736_ accumulator._0737_ VGND VGND VPWR VPWR accumulator._0738_
+ sky130_fd_sc_hd__or2_1
Xaccumulator._1710_ accumulator._0745_ accumulator._0806_ VGND VGND VPWR VPWR accumulator._0807_
+ sky130_fd_sc_hd__and2_1
Xaccumulator._1572_ accumulator._0497_ accumulator._0548_ accumulator._0551_ accumulator._0668_
+ accumulator._0501_ VGND VGND VPWR VPWR accumulator._0669_ sky130_fd_sc_hd__a311o_1
XFILLER_0_38_85 VGND VGND VPWR VPWR sky130_fd_sc_hd__decap_8
XFILLER_0_38_41 VPWR VGND VPWR VGND sky130_ef_sc_hd__decap_12
XFILLER_0_22_273 VGND VGND VPWR VPWR sky130_fd_sc_hd__fill_1
XFILLER_0_10_413 VGND VGND VPWR VPWR sky130_fd_sc_hd__decap_3
XFILLER_0_49_137 VGND VGND VPWR VPWR sky130_fd_sc_hd__fill_2
Xaccumulator._2124_ accumulator._0058_ VGND VGND VPWR VPWR accumulator._0003_ sky130_fd_sc_hd__clkbuf_1
Xclkbuf_0_clock clock VGND VGND VPWR VPWR clknet_0_clock sky130_fd_sc_hd__clkbuf_16
XFILLER_0_64_129 VGND VGND VPWR VPWR sky130_fd_sc_hd__fill_1
XFILLER_0_60_313 VPWR VGND VPWR VGND sky130_ef_sc_hd__decap_12
Xaccumulator._2055_ accumulator._0970_ accumulator._1151_ VGND VGND VPWR VPWR accumulator._1152_
+ sky130_fd_sc_hd__nand2_1
XFILLER_0_9_267 VPWR VGND VPWR VGND sky130_ef_sc_hd__decap_12
Xaccumulator._1908_ accumulator._0922_ accumulator._0786_ accumulator._1004_ VGND
+ VGND VPWR VPWR accumulator._1005_ sky130_fd_sc_hd__a21boi_1
Xaccumulator._1839_ accumulator._0932_ accumulator._0931_ accumulator._0934_ accumulator._0935_
+ accumulator._0793_ VGND VGND VPWR VPWR accumulator._0936_ sky130_fd_sc_hd__a311o_1
XFILLER_0_13_251 VGND VGND VPWR VPWR sky130_fd_sc_hd__decap_8
XTAP_TAPCELL_ROW_5_188 VGND VPWR sky130_fd_sc_hd__tapvpwrvgnd_1
XFILLER_0_68_413 VGND VGND VPWR VPWR sky130_fd_sc_hd__decap_6
XFILLER_0_55_118 VPWR VGND VPWR VGND sky130_ef_sc_hd__decap_12
XFILLER_0_51_346 VPWR VGND VPWR VGND sky130_ef_sc_hd__decap_12
XFILLER_0_51_302 VGND VGND VPWR VPWR sky130_fd_sc_hd__decap_6
XscaleAdd._560_ scaleAdd._080_ scaleAdd._098_ VGND VGND VPWR VPWR scaleAdd._138_ sky130_fd_sc_hd__and2b_1
XscaleAdd._491_ scaleAdd._069_ scaleAdd._070_ VGND VGND VPWR VPWR scaleAdd._071_ sky130_fd_sc_hd__xnor2_1
XFILLER_0_39_192 VGND VGND VPWR VPWR sky130_fd_sc_hd__fill_1
XFILLER_0_39_181 VGND VGND VPWR VPWR sky130_fd_sc_hd__decap_6
XFILLER_0_40_53 VGND VGND VPWR VPWR sky130_fd_sc_hd__decap_6
XFILLER_0_49_51 VGND VGND VPWR VPWR sky130_fd_sc_hd__decap_4
XscaleAdd._689_ scaleAdd._248_ net76 scaleAdd._246_ scaleAdd._245_ VGND VGND VPWR
+ VPWR scaleAdd._262_ sky130_fd_sc_hd__a31o_1
XFILLER_0_10_243 VGND VGND VPWR VPWR sky130_fd_sc_hd__fill_1
Xaccumulator._1624_ accumulator._0559_ accumulator._0535_ accumulator._0720_ VGND
+ VGND VPWR VPWR accumulator._0721_ sky130_fd_sc_hd__a21oi_2
Xaccumulator._1555_ accumulator._0642_ accumulator._0649_ accumulator._0651_ VGND
+ VGND VPWR VPWR accumulator._0652_ sky130_fd_sc_hd__a21o_1
XFILLER_0_4_97 VGND VGND VPWR VPWR sky130_fd_sc_hd__decap_8
XFILLER_0_4_75 VGND VGND VPWR VPWR sky130_fd_sc_hd__fill_2
XFILLER_0_65_405 VPWR VGND VPWR VGND sky130_ef_sc_hd__decap_12
Xaccumulator._2107_ accumulator._0040_ accumulator._1139_ VGND VGND VPWR VPWR accumulator._0041_
+ sky130_fd_sc_hd__nor2_4
XTAP_TAPCELL_ROW_53_547 VGND VPWR sky130_fd_sc_hd__tapvpwrvgnd_1
Xaccumulator._1486_ accumulator.io_accOut\[20\] accumulator._0582_ accumulator._0394_
+ VGND VGND VPWR VPWR accumulator._0583_ sky130_fd_sc_hd__mux2_1
Xoperator._13_ operator._00_ VGND VGND VPWR VPWR operator.io_outMant\[0\] sky130_fd_sc_hd__buf_2
XTAP_TAPCELL_ROW_2_169 VGND VPWR sky130_fd_sc_hd__tapvpwrvgnd_1
XTAP_TAPCELL_ROW_18_290 VGND VPWR sky130_fd_sc_hd__tapvpwrvgnd_1
Xaccumulator._2038_ accumulator._1127_ accumulator._1134_ VGND VGND VPWR VPWR accumulator._1135_
+ sky130_fd_sc_hd__xnor2_2
XPHY_EDGE_ROW_36_Left_107 VGND VGND VPWR VPWR sky130_fd_sc_hd__decap_3
XFILLER_0_5_281 VGND VGND VPWR VPWR sky130_fd_sc_hd__decap_8
XFILLER_0_18_321 VGND VGND VPWR VPWR sky130_fd_sc_hd__decap_3
XFILLER_0_60_187 VGND VGND VPWR VPWR sky130_fd_sc_hd__fill_2
XPHY_EDGE_ROW_45_Left_116 VGND VGND VPWR VPWR sky130_fd_sc_hd__decap_3
XPHY_EDGE_ROW_54_Left_125 VGND VGND VPWR VPWR sky130_fd_sc_hd__decap_3
XFILLER_0_51_132 VGND VGND VPWR VPWR sky130_fd_sc_hd__fill_1
XscaleAdd._474_ scaleAdd._051_ scaleAdd._053_ VGND VGND VPWR VPWR scaleAdd._054_ sky130_fd_sc_hd__xor2_2
XFILLER_0_3_207 VGND VGND VPWR VPWR sky130_fd_sc_hd__fill_1
XscaleAdd._612_ scaleAdd._187_ VGND VGND VPWR VPWR scaleAdd._188_ sky130_fd_sc_hd__clkbuf_2
XscaleAdd._543_ scaleAdd._110_ scaleAdd._112_ VGND VGND VPWR VPWR scaleAdd._121_ sky130_fd_sc_hd__or2b_1
XPHY_EDGE_ROW_63_Left_134 VGND VGND VPWR VPWR sky130_fd_sc_hd__decap_3
Xaccumulator._1340_ accumulator.io_inMant\[0\] accumulator.io_inMant\[1\] accumulator._0436_
+ VGND VGND VPWR VPWR accumulator._0437_ sky130_fd_sc_hd__mux2_1
XFILLER_0_19_43 VPWR VGND VPWR VGND sky130_ef_sc_hd__decap_12
XFILLER_0_19_65 VGND VGND VPWR VPWR sky130_fd_sc_hd__decap_3
XFILLER_0_47_416 VGND VGND VPWR VPWR sky130_fd_sc_hd__fill_1
Xaccumulator._1271_ net61 accumulator._0343_ accumulator._0369_ VGND VGND VPWR VPWR
+ accumulator._0370_ sky130_fd_sc_hd__a21oi_2
XTAP_TAPCELL_ROW_50_528 VGND VPWR sky130_fd_sc_hd__tapvpwrvgnd_1
XFILLER_0_62_3 VPWR VGND VPWR VGND sky130_ef_sc_hd__decap_12
XFILLER_0_30_305 VGND VGND VPWR VPWR sky130_fd_sc_hd__decap_3
XTAP_TAPCELL_ROW_7_206 VGND VPWR sky130_fd_sc_hd__tapvpwrvgnd_1
XTAP_TAPCELL_ROW_66_650 VGND VPWR sky130_fd_sc_hd__tapvpwrvgnd_1
Xaccumulator._1607_ accumulator._0606_ accumulator._0697_ accumulator._0700_ accumulator._0703_
+ VGND VGND VPWR VPWR accumulator._0704_ sky130_fd_sc_hd__o31a_2
Xaccumulator._1538_ accumulator._0523_ VGND VGND VPWR VPWR accumulator._0635_ sky130_fd_sc_hd__clkbuf_4
Xaccumulator._1469_ accumulator.io_inMant\[11\] accumulator.io_inMant\[12\] accumulator._0436_
+ VGND VGND VPWR VPWR accumulator._0566_ sky130_fd_sc_hd__mux2_1
XFILLER_0_33_143 VGND VGND VPWR VPWR sky130_fd_sc_hd__fill_1
Xclkload0 clknet_2_0__leaf_clock VGND VGND VPWR VPWR clkload0/Y sky130_fd_sc_hd__clkinvlp_2
XFILLER_0_21_349 VPWR VGND VPWR VGND sky130_ef_sc_hd__decap_12
XPHY_EDGE_ROW_3_Left_74 VGND VGND VPWR VPWR sky130_fd_sc_hd__decap_3
XFILLER_0_21_88 VGND VGND VPWR VPWR sky130_fd_sc_hd__fill_1
XFILLER_0_21_55 VGND VGND VPWR VPWR sky130_fd_sc_hd__fill_1
XTAP_TAPCELL_ROW_12_241 VGND VPWR sky130_fd_sc_hd__tapvpwrvgnd_1
XFILLER_0_21_33 VGND VGND VPWR VPWR sky130_fd_sc_hd__fill_1
XFILLER_0_24_187 VGND VGND VPWR VPWR sky130_fd_sc_hd__decap_8
XscaleAdd._526_ scaleAdd._056_ scaleAdd._058_ scaleAdd._104_ VGND VGND VPWR VPWR scaleAdd._105_
+ sky130_fd_sc_hd__a21oi_1
XscaleAdd._457_ scaleAdd._034_ scaleAdd._035_ scaleAdd._036_ VGND VGND VPWR VPWR scaleAdd._038_
+ sky130_fd_sc_hd__a21oi_1
XFILLER_0_46_41 VPWR VGND VPWR VGND sky130_ef_sc_hd__decap_12
XFILLER_0_27_6 VPWR VGND VPWR VGND sky130_ef_sc_hd__decap_12
Xaccumulator._1323_ accumulator._0388_ accumulator._0387_ VGND VGND VPWR VPWR accumulator._0420_
+ sky130_fd_sc_hd__and2b_1
Xaccumulator._2372_ accumulator._0386_ VGND VGND VPWR VPWR accumulator._0305_ sky130_fd_sc_hd__inv_2
XscaleAdd._388_ scaleAdd._328_ scaleAdd._329_ scaleAdd._330_ scaleAdd._317_ VGND VGND
+ VPWR VPWR accumulator.io_inMant\[4\] sky130_fd_sc_hd__a2bb2o_1
X_28_ accumulator.io_accOut\[28\] VGND VGND VPWR VPWR net42 sky130_fd_sc_hd__clkbuf_1
XFILLER_0_47_246 VGND VGND VPWR VPWR sky130_fd_sc_hd__decap_8
Xaccumulator._1254_ accumulator._0105_ accumulator._0136_ net75 VGND VGND VPWR VPWR
+ accumulator._0353_ sky130_fd_sc_hd__nand3_1
XFILLER_0_1_98 VGND VGND VPWR VPWR sky130_fd_sc_hd__decap_8
XFILLER_0_70_293 VPWR VGND VPWR VGND sky130_ef_sc_hd__decap_12
XFILLER_0_30_113 VGND VGND VPWR VPWR sky130_fd_sc_hd__decap_8
XFILLER_0_11_393 VPWR VGND VPWR VGND sky130_ef_sc_hd__decap_12
XTAP_TAPCELL_ROW_26_344 VGND VPWR sky130_fd_sc_hd__tapvpwrvgnd_1
XFILLER_0_53_216 VGND VGND VPWR VPWR sky130_fd_sc_hd__decap_8
XFILLER_0_38_246 VGND VGND VPWR VPWR sky130_fd_sc_hd__decap_6
XFILLER_0_21_146 VGND VGND VPWR VPWR sky130_fd_sc_hd__fill_1
XFILLER_0_21_113 VPWR VGND VPWR VGND sky130_ef_sc_hd__decap_12
XFILLER_0_69_393 VPWR VGND VPWR VGND sky130_ef_sc_hd__decap_12
XTAP_TAPCELL_ROW_60_601 VGND VPWR sky130_fd_sc_hd__tapvpwrvgnd_1
XFILLER_0_32_65 VPWR VGND VPWR VGND sky130_ef_sc_hd__decap_12
XFILLER_0_29_279 VGND VGND VPWR VPWR sky130_fd_sc_hd__fill_1
Xaccumulator._1941_ accumulator._1036_ accumulator._1037_ VGND VGND VPWR VPWR accumulator._1038_
+ sky130_fd_sc_hd__xnor2_2
Xaccumulator._1872_ accumulator._0968_ accumulator._0920_ VGND VGND VPWR VPWR accumulator._0969_
+ sky130_fd_sc_hd__and2_4
XFILLER_0_4_357 VGND VGND VPWR VPWR sky130_fd_sc_hd__decap_6
XFILLER_0_12_102 VGND VGND VPWR VPWR sky130_fd_sc_hd__fill_2
XFILLER_0_12_113 VGND VGND VPWR VPWR sky130_fd_sc_hd__fill_2
XFILLER_0_57_51 VGND VGND VPWR VPWR sky130_fd_sc_hd__decap_4
XscaleAdd._509_ scaleAdd._307_ scaleAdd._085_ scaleAdd._087_ VGND VGND VPWR VPWR scaleAdd._088_
+ sky130_fd_sc_hd__and3_1
Xaccumulator._2286_ accumulator._0103_ accumulator._0104_ accumulator._1113_ VGND
+ VGND VPWR VPWR accumulator._0220_ sky130_fd_sc_hd__a21bo_1
Xaccumulator._1306_ accumulator._0404_ VGND VGND VPWR VPWR accumulator._0405_ sky130_fd_sc_hd__clkbuf_4
Xaccumulator._2424_ clknet_2_0__leaf_clock accumulator._0025_ VGND VGND VPWR VPWR
+ accumulator.io_accOut\[23\] sky130_fd_sc_hd__dfxtp_1
Xaccumulator._2355_ accumulator._0279_ accumulator._0276_ accumulator._0286_ VGND
+ VGND VPWR VPWR accumulator._0288_ sky130_fd_sc_hd__a21oi_2
XTAP_TAPCELL_ROW_23_325 VGND VPWR sky130_fd_sc_hd__tapvpwrvgnd_1
Xaccumulator._1237_ accumulator.io_inMant\[17\] accumulator._0304_ accumulator._0334_
+ accumulator._0335_ VGND VGND VPWR VPWR accumulator._0336_ sky130_fd_sc_hd__o22a_1
XFILLER_0_43_293 VGND VGND VPWR VPWR sky130_fd_sc_hd__decap_4
Xoutput24 net24 VGND VGND VPWR VPWR io_accOut[11] sky130_fd_sc_hd__buf_2
Xoutput35 net35 VGND VGND VPWR VPWR io_accOut[21] sky130_fd_sc_hd__buf_2
Xoutput46 net46 VGND VGND VPWR VPWR io_accOut[31] sky130_fd_sc_hd__buf_2
XFILLER_0_11_190 VGND VGND VPWR VPWR sky130_fd_sc_hd__decap_8
XPHY_EDGE_ROW_19_Right_19 VGND VGND VPWR VPWR sky130_fd_sc_hd__decap_3
XFILLER_0_26_205 VGND VGND VPWR VPWR sky130_fd_sc_hd__fill_2
XFILLER_0_22_411 VGND VGND VPWR VPWR sky130_fd_sc_hd__fill_1
XFILLER_0_1_305 VPWR VGND VPWR VGND sky130_ef_sc_hd__decap_12
XPHY_EDGE_ROW_28_Right_28 VGND VGND VPWR VPWR sky130_fd_sc_hd__decap_3
XFILLER_0_1_349 VPWR VGND VPWR VGND sky130_ef_sc_hd__decap_12
Xaccumulator._2140_ accumulator._0072_ accumulator._0048_ accumulator._0073_ accumulator._0050_
+ VGND VGND VPWR VPWR accumulator._0074_ sky130_fd_sc_hd__o211a_1
XPHY_EDGE_ROW_37_Right_37 VGND VGND VPWR VPWR sky130_fd_sc_hd__decap_3
XTAP_TAPCELL_ROW_37_428 VGND VPWR sky130_fd_sc_hd__tapvpwrvgnd_1
XFILLER_0_27_65 VGND VGND VPWR VPWR sky130_fd_sc_hd__fill_1
XFILLER_0_27_54 VGND VGND VPWR VPWR sky130_fd_sc_hd__fill_2
Xaccumulator._2071_ accumulator._0978_ accumulator._1167_ accumulator._0996_ VGND
+ VGND VPWR VPWR accumulator._1168_ sky130_fd_sc_hd__o21ba_1
XFILLER_0_9_405 VPWR VGND VPWR VGND sky130_ef_sc_hd__decap_12
XFILLER_0_17_205 VGND VGND VPWR VPWR sky130_fd_sc_hd__decap_6
XTAP_TAPCELL_ROW_20_306 VGND VPWR sky130_fd_sc_hd__tapvpwrvgnd_1
Xaccumulator._1855_ accumulator._0857_ accumulator._0945_ accumulator._0944_ accumulator._0947_
+ accumulator._0951_ VGND VGND VPWR VPWR accumulator._0952_ sky130_fd_sc_hd__o311a_4
Xaccumulator._1924_ accumulator._0918_ accumulator._0806_ accumulator._1019_ accumulator._1020_
+ VGND VGND VPWR VPWR accumulator._1021_ sky130_fd_sc_hd__o31a_1
XPHY_EDGE_ROW_46_Right_46 VGND VGND VPWR VPWR sky130_fd_sc_hd__decap_3
XFILLER_0_40_274 VGND VGND VPWR VPWR sky130_fd_sc_hd__decap_8
XFILLER_0_4_132 VGND VGND VPWR VPWR sky130_fd_sc_hd__decap_8
XFILLER_0_7_20 VGND VGND VPWR VPWR sky130_fd_sc_hd__fill_2
XFILLER_0_68_83 VGND VGND VPWR VPWR sky130_fd_sc_hd__fill_1
Xaccumulator._1786_ accumulator._0879_ accumulator._0882_ VGND VGND VPWR VPWR accumulator._0883_
+ sky130_fd_sc_hd__or2b_1
XPHY_EDGE_ROW_55_Right_55 VGND VGND VPWR VPWR sky130_fd_sc_hd__decap_3
Xaccumulator._2407_ clknet_2_2__leaf_clock accumulator._0008_ VGND VGND VPWR VPWR
+ accumulator.io_accOut\[6\] sky130_fd_sc_hd__dfxtp_1
XFILLER_0_0_393 VPWR VGND VPWR VGND sky130_ef_sc_hd__decap_12
Xaccumulator._2269_ accumulator._1080_ accumulator._0036_ accumulator._0202_ VGND
+ VGND VPWR VPWR accumulator._0203_ sky130_fd_sc_hd__o21a_1
Xaccumulator._2338_ accumulator._1196_ accumulator._0264_ VGND VGND VPWR VPWR accumulator._0270_
+ sky130_fd_sc_hd__or2_1
XPHY_EDGE_ROW_64_Right_64 VGND VGND VPWR VPWR sky130_fd_sc_hd__decap_3
XFILLER_0_63_366 VGND VGND VPWR VPWR sky130_fd_sc_hd__decap_8
XFILLER_0_63_344 VGND VGND VPWR VPWR sky130_fd_sc_hd__fill_1
XFILLER_0_31_230 VGND VGND VPWR VPWR sky130_fd_sc_hd__fill_2
XTAP_TAPCELL_ROW_59_597 VGND VPWR sky130_fd_sc_hd__tapvpwrvgnd_1
XFILLER_0_58_149 VGND VGND VPWR VPWR sky130_fd_sc_hd__decap_6
XFILLER_0_54_355 VGND VGND VPWR VPWR sky130_fd_sc_hd__fill_1
XTAP_TAPCELL_ROW_42_464 VGND VPWR sky130_fd_sc_hd__tapvpwrvgnd_1
XFILLER_0_39_363 VGND VGND VPWR VPWR sky130_fd_sc_hd__fill_2
XTAP_TAPCELL_ROW_34_409 VGND VPWR sky130_fd_sc_hd__tapvpwrvgnd_1
XFILLER_0_6_419 VGND VGND VPWR VPWR sky130_fd_sc_hd__fill_1
XFILLER_0_13_34 VGND VGND VPWR VPWR sky130_fd_sc_hd__fill_2
XFILLER_0_1_157 VGND VGND VPWR VPWR sky130_fd_sc_hd__fill_1
XFILLER_0_38_53 VGND VGND VPWR VPWR sky130_fd_sc_hd__decap_6
Xaccumulator._1571_ accumulator._0472_ accumulator._0473_ accumulator._0527_ accumulator._0528_
+ VGND VGND VPWR VPWR accumulator._0668_ sky130_fd_sc_hd__o211a_1
Xaccumulator._1640_ net79 accumulator._0590_ accumulator._0395_ VGND VGND VPWR VPWR
+ accumulator._0737_ sky130_fd_sc_hd__mux2_1
XFILLER_0_54_85 VPWR VGND VPWR VGND sky130_ef_sc_hd__decap_12
XFILLER_0_54_41 VGND VGND VPWR VPWR sky130_fd_sc_hd__decap_8
XFILLER_0_49_105 VGND VGND VPWR VPWR sky130_fd_sc_hd__decap_6
Xaccumulator._2123_ accumulator._0400_ accumulator._0057_ VGND VGND VPWR VPWR accumulator._0058_
+ sky130_fd_sc_hd__and2_1
XFILLER_0_9_213 VGND VGND VPWR VPWR sky130_fd_sc_hd__decap_3
XFILLER_0_60_325 VGND VGND VPWR VPWR sky130_fd_sc_hd__decap_6
Xaccumulator._2054_ accumulator._0971_ accumulator._1150_ VGND VGND VPWR VPWR accumulator._1151_
+ sky130_fd_sc_hd__xnor2_1
XFILLER_0_45_388 VGND VGND VPWR VPWR sky130_fd_sc_hd__decap_4
XFILLER_0_45_377 VGND VGND VPWR VPWR sky130_fd_sc_hd__fill_2
XFILLER_0_9_279 VGND VGND VPWR VPWR sky130_fd_sc_hd__fill_1
Xaccumulator._1907_ accumulator._0931_ accumulator._0982_ accumulator._0921_ accumulator._0935_
+ VGND VGND VPWR VPWR accumulator._1004_ sky130_fd_sc_hd__a211o_1
Xaccumulator._1838_ accumulator.io_accOut\[4\] accumulator._0395_ accumulator._0764_
+ VGND VGND VPWR VPWR accumulator._0935_ sky130_fd_sc_hd__and3_1
XFILLER_0_13_241 VGND VGND VPWR VPWR sky130_fd_sc_hd__fill_2
Xaccumulator._1769_ accumulator._0864_ accumulator._0865_ VGND VGND VPWR VPWR accumulator._0866_
+ sky130_fd_sc_hd__or2_2
XTAP_TAPCELL_ROW_5_189 VGND VPWR sky130_fd_sc_hd__tapvpwrvgnd_1
XFILLER_0_51_358 VGND VGND VPWR VPWR sky130_fd_sc_hd__decap_6
XscaleAdd._490_ scaleAdd._032_ scaleAdd._034_ VGND VGND VPWR VPWR scaleAdd._070_ sky130_fd_sc_hd__and2_1
XFILLER_0_54_174 VGND VGND VPWR VPWR sky130_fd_sc_hd__fill_1
XFILLER_0_54_141 VPWR VGND VPWR VGND sky130_ef_sc_hd__decap_12
XFILLER_0_27_311 VGND VGND VPWR VPWR sky130_fd_sc_hd__decap_3
XFILLER_0_6_249 VGND VGND VPWR VPWR sky130_fd_sc_hd__decap_3
Xaccumulator._1623_ accumulator._0599_ accumulator._0611_ accumulator._0719_ accumulator._0553_
+ VGND VGND VPWR VPWR accumulator._0720_ sky130_fd_sc_hd__a31o_1
XscaleAdd._688_ scaleAdd._227_ scaleAdd._248_ scaleAdd._246_ scaleAdd._260_ scaleAdd._245_
+ VGND VGND VPWR VPWR scaleAdd._261_ sky130_fd_sc_hd__a311o_1
XFILLER_0_65_95 VGND VGND VPWR VPWR sky130_fd_sc_hd__decap_8
XFILLER_0_65_51 VGND VGND VPWR VPWR sky130_fd_sc_hd__decap_4
Xaccumulator._1554_ accumulator._0650_ VGND VGND VPWR VPWR accumulator._0651_ sky130_fd_sc_hd__buf_4
Xaccumulator._1485_ accumulator._0095_ accumulator._0507_ accumulator._0581_ VGND
+ VGND VPWR VPWR accumulator._0582_ sky130_fd_sc_hd__o21bai_1
Xoperator._12_ net5 net1 VGND VGND VPWR VPWR operator._00_ sky130_fd_sc_hd__and2_1
XFILLER_0_65_417 VGND VGND VPWR VPWR sky130_fd_sc_hd__decap_4
Xaccumulator._2037_ accumulator._1054_ accumulator._1124_ VGND VGND VPWR VPWR accumulator._1134_
+ sky130_fd_sc_hd__nor2_1
Xaccumulator._2106_ accumulator._1087_ VGND VGND VPWR VPWR accumulator._0040_ sky130_fd_sc_hd__inv_2
XTAP_TAPCELL_ROW_53_548 VGND VPWR sky130_fd_sc_hd__tapvpwrvgnd_1
XTAP_TAPCELL_ROW_18_291 VGND VPWR sky130_fd_sc_hd__tapvpwrvgnd_1
XFILLER_0_45_152 VGND VGND VPWR VPWR sky130_fd_sc_hd__fill_2
XFILLER_0_33_314 VPWR VGND VPWR VGND sky130_ef_sc_hd__decap_12
XFILLER_0_33_303 VGND VGND VPWR VPWR sky130_fd_sc_hd__decap_4
XFILLER_0_41_391 VGND VGND VPWR VPWR sky130_fd_sc_hd__fill_1
XTAP_TAPCELL_ROW_69_670 VGND VPWR sky130_fd_sc_hd__tapvpwrvgnd_1
XFILLER_0_51_111 VGND VGND VPWR VPWR sky130_fd_sc_hd__fill_1
XFILLER_0_36_141 VPWR VGND VPWR VGND sky130_ef_sc_hd__decap_12
XscaleAdd._611_ scaleAdd._168_ scaleAdd._169_ VGND VGND VPWR VPWR scaleAdd._187_ sky130_fd_sc_hd__and2_1
XscaleAdd._473_ scaleAdd._008_ scaleAdd._012_ scaleAdd._052_ VGND VGND VPWR VPWR scaleAdd._053_
+ sky130_fd_sc_hd__o21ai_2
XscaleAdd._542_ scaleAdd._114_ scaleAdd._116_ VGND VGND VPWR VPWR scaleAdd._120_ sky130_fd_sc_hd__and2_1
XFILLER_0_19_55 VGND VGND VPWR VPWR sky130_fd_sc_hd__fill_1
XFILLER_0_19_88 VPWR VGND VPWR VGND sky130_ef_sc_hd__decap_12
XTAP_TAPCELL_ROW_50_529 VGND VPWR sky130_fd_sc_hd__tapvpwrvgnd_1
Xaccumulator._1270_ accumulator._0344_ accumulator._0346_ VGND VGND VPWR VPWR accumulator._0369_
+ sky130_fd_sc_hd__xnor2_1
XFILLER_0_42_166 VGND VGND VPWR VPWR sky130_fd_sc_hd__decap_8
XFILLER_0_27_163 VGND VGND VPWR VPWR sky130_fd_sc_hd__decap_4
XFILLER_0_55_3 VPWR VGND VPWR VGND sky130_ef_sc_hd__decap_12
Xaccumulator._1606_ accumulator._0523_ accumulator._0702_ VGND VGND VPWR VPWR accumulator._0703_
+ sky130_fd_sc_hd__or2_1
XFILLER_0_2_274 VGND VGND VPWR VPWR sky130_fd_sc_hd__decap_3
XTAP_TAPCELL_ROW_7_207 VGND VPWR sky130_fd_sc_hd__tapvpwrvgnd_1
XTAP_TAPCELL_ROW_66_651 VGND VPWR sky130_fd_sc_hd__tapvpwrvgnd_1
Xaccumulator._1537_ accumulator._0630_ accumulator._0633_ accumulator._0428_ VGND
+ VGND VPWR VPWR accumulator._0634_ sky130_fd_sc_hd__a21o_1
Xaccumulator._1468_ accumulator._0433_ accumulator._0564_ accumulator._0451_ VGND
+ VGND VPWR VPWR accumulator._0565_ sky130_fd_sc_hd__a21o_1
Xaccumulator._1399_ accumulator._0478_ accumulator._0495_ accumulator._0469_ VGND
+ VGND VPWR VPWR accumulator._0496_ sky130_fd_sc_hd__a21o_1
XFILLER_0_65_225 VPWR VGND VPWR VGND sky130_ef_sc_hd__decap_12
XFILLER_0_33_111 VGND VGND VPWR VPWR sky130_fd_sc_hd__fill_1
Xclkload1 clknet_2_1__leaf_clock VGND VGND VPWR VPWR clkload1/X sky130_fd_sc_hd__clkbuf_4
XFILLER_0_56_225 VGND VGND VPWR VPWR sky130_fd_sc_hd__decap_6
XFILLER_0_29_417 VGND VGND VPWR VPWR sky130_fd_sc_hd__fill_1
XFILLER_0_56_258 VGND VGND VPWR VPWR sky130_fd_sc_hd__decap_6
XFILLER_0_24_177 VGND VGND VPWR VPWR sky130_fd_sc_hd__fill_1
XFILLER_0_24_166 VGND VGND VPWR VPWR sky130_fd_sc_hd__fill_1
XTAP_TAPCELL_ROW_12_242 VGND VPWR sky130_fd_sc_hd__tapvpwrvgnd_1
XscaleAdd._387_ operator.io_outMant\[2\] VGND VGND VPWR VPWR scaleAdd._330_ sky130_fd_sc_hd__buf_2
XscaleAdd._525_ scaleAdd._307_ scaleAdd._320_ scaleAdd._085_ VGND VGND VPWR VPWR scaleAdd._104_
+ sky130_fd_sc_hd__and3_1
XscaleAdd._456_ scaleAdd._034_ scaleAdd._035_ scaleAdd._036_ VGND VGND VPWR VPWR scaleAdd._037_
+ sky130_fd_sc_hd__and3_1
XFILLER_0_20_350 VGND VGND VPWR VPWR sky130_fd_sc_hd__decap_8
XFILLER_0_46_53 VPWR VGND VPWR VGND sky130_ef_sc_hd__decap_12
Xaccumulator._1322_ accumulator._0409_ accumulator._0418_ VGND VGND VPWR VPWR accumulator._0419_
+ sky130_fd_sc_hd__xnor2_4
Xaccumulator._1253_ accumulator._0348_ accumulator._0351_ VGND VGND VPWR VPWR accumulator._0352_
+ sky130_fd_sc_hd__or2_1
XFILLER_0_1_55 VGND VGND VPWR VPWR sky130_fd_sc_hd__fill_1
Xaccumulator._2371_ accumulator._0398_ accumulator._0302_ accumulator._0303_ accumulator._0177_
+ VGND VGND VPWR VPWR accumulator._0029_ sky130_fd_sc_hd__o211a_1
X_27_ accumulator.io_accOut\[27\] VGND VGND VPWR VPWR net41 sky130_fd_sc_hd__clkbuf_1
XFILLER_0_62_41 VPWR VGND VPWR VGND sky130_ef_sc_hd__decap_12
XFILLER_0_47_258 VPWR VGND VPWR VGND sky130_ef_sc_hd__decap_12
XFILLER_0_47_203 VGND VGND VPWR VPWR sky130_fd_sc_hd__decap_8
XFILLER_0_30_103 VGND VGND VPWR VPWR sky130_fd_sc_hd__fill_1
XFILLER_0_15_133 VGND VGND VPWR VPWR sky130_fd_sc_hd__decap_3
Xhold46 accumulator.io_accOut\[7\] VGND VGND VPWR VPWR net103 sky130_fd_sc_hd__dlygate4sd3_1
XFILLER_0_11_361 VPWR VGND VPWR VGND sky130_ef_sc_hd__decap_12
XFILLER_0_38_203 VPWR VGND VPWR VGND sky130_ef_sc_hd__decap_12
XTAP_TAPCELL_ROW_26_345 VGND VPWR sky130_fd_sc_hd__tapvpwrvgnd_1
XFILLER_0_21_169 VGND VGND VPWR VPWR sky130_fd_sc_hd__decap_6
XFILLER_0_21_125 VGND VGND VPWR VPWR sky130_fd_sc_hd__decap_6
XFILLER_0_69_361 VPWR VGND VPWR VGND sky130_ef_sc_hd__decap_12
XTAP_TAPCELL_ROW_60_602 VGND VPWR sky130_fd_sc_hd__tapvpwrvgnd_1
XFILLER_0_32_77 VGND VGND VPWR VPWR sky130_fd_sc_hd__decap_6
XFILLER_0_29_225 VGND VGND VPWR VPWR sky130_fd_sc_hd__decap_3
XFILLER_0_17_409 VGND VGND VPWR VPWR sky130_fd_sc_hd__decap_8
Xaccumulator._1940_ accumulator._1028_ accumulator._1029_ accumulator._0992_ VGND
+ VGND VPWR VPWR accumulator._1037_ sky130_fd_sc_hd__a21o_1
Xaccumulator._1871_ accumulator._0923_ accumulator._0739_ accumulator._0965_ accumulator._0909_
+ accumulator._0967_ VGND VGND VPWR VPWR accumulator._0968_ sky130_fd_sc_hd__o41a_4
XFILLER_0_52_272 VGND VGND VPWR VPWR sky130_fd_sc_hd__fill_1
XFILLER_0_4_303 VGND VGND VPWR VPWR sky130_fd_sc_hd__decap_4
XFILLER_0_12_158 VGND VGND VPWR VPWR sky130_fd_sc_hd__decap_3
Xaccumulator._2423_ clknet_2_0__leaf_clock accumulator._0024_ VGND VGND VPWR VPWR
+ accumulator.io_accOut\[22\] sky130_fd_sc_hd__dfxtp_1
XscaleAdd._508_ scaleAdd._083_ scaleAdd._086_ VGND VGND VPWR VPWR scaleAdd._087_ sky130_fd_sc_hd__nor2_1
XscaleAdd._439_ scaleAdd._019_ scaleAdd._002_ VGND VGND VPWR VPWR scaleAdd._020_ sky130_fd_sc_hd__xor2_2
Xaccumulator._2285_ accumulator._1080_ accumulator._0051_ accumulator._0202_ accumulator._1197_
+ VGND VGND VPWR VPWR accumulator._0219_ sky130_fd_sc_hd__o211a_1
Xaccumulator._1305_ accumulator._0403_ VGND VGND VPWR VPWR accumulator._0404_ sky130_fd_sc_hd__clkbuf_4
Xaccumulator._2354_ accumulator._0279_ accumulator._0276_ accumulator._0286_ VGND
+ VGND VPWR VPWR accumulator._0287_ sky130_fd_sc_hd__and3_1
Xaccumulator._1236_ accumulator.io_inMant\[17\] accumulator.io_inMant\[15\] VGND VGND
+ VPWR VPWR accumulator._0335_ sky130_fd_sc_hd__or2_1
XFILLER_0_43_250 VPWR VGND VPWR VGND sky130_ef_sc_hd__decap_12
XFILLER_0_28_280 VPWR VGND VPWR VGND sky130_ef_sc_hd__decap_12
XTAP_TAPCELL_ROW_23_326 VGND VPWR sky130_fd_sc_hd__tapvpwrvgnd_1
XFILLER_0_7_130 VGND VGND VPWR VPWR sky130_fd_sc_hd__decap_8
Xoutput47 net47 VGND VGND VPWR VPWR io_accOut[3] sky130_fd_sc_hd__buf_2
Xoutput36 net36 VGND VGND VPWR VPWR io_accOut[22] sky130_fd_sc_hd__buf_2
Xoutput25 net25 VGND VGND VPWR VPWR io_accOut[12] sky130_fd_sc_hd__buf_2
XFILLER_0_3_391 VGND VGND VPWR VPWR sky130_fd_sc_hd__fill_1
XFILLER_0_66_320 VPWR VGND VPWR VGND sky130_ef_sc_hd__decap_12
XFILLER_0_58_309 VGND VGND VPWR VPWR sky130_fd_sc_hd__decap_8
XFILLER_0_22_401 VGND VGND VPWR VPWR sky130_fd_sc_hd__fill_2
XFILLER_0_1_317 VPWR VGND VPWR VGND sky130_ef_sc_hd__decap_12
Xaccumulator._2070_ accumulator._1153_ accumulator._1166_ accumulator._0980_ VGND
+ VGND VPWR VPWR accumulator._1167_ sky130_fd_sc_hd__o21ba_1
XTAP_TAPCELL_ROW_37_429 VGND VPWR sky130_fd_sc_hd__tapvpwrvgnd_1
XFILLER_0_9_417 VGND VGND VPWR VPWR sky130_fd_sc_hd__decap_4
XFILLER_0_57_397 VGND VGND VPWR VPWR sky130_fd_sc_hd__decap_3
XFILLER_0_17_239 VGND VGND VPWR VPWR sky130_fd_sc_hd__decap_8
Xaccumulator._1785_ accumulator._0880_ accumulator._0881_ VGND VGND VPWR VPWR accumulator._0882_
+ sky130_fd_sc_hd__xnor2_4
Xaccumulator._1854_ accumulator._0945_ accumulator._0950_ VGND VGND VPWR VPWR accumulator._0951_
+ sky130_fd_sc_hd__or2_1
Xaccumulator._1923_ accumulator._0929_ accumulator._0939_ accumulator._0922_ VGND
+ VGND VPWR VPWR accumulator._1020_ sky130_fd_sc_hd__a21o_1
XFILLER_0_40_242 VGND VGND VPWR VPWR sky130_fd_sc_hd__decap_6
XFILLER_0_4_166 VPWR VGND VPWR VGND sky130_ef_sc_hd__decap_12
XFILLER_0_0_361 VGND VGND VPWR VPWR sky130_fd_sc_hd__decap_3
XFILLER_0_7_65 VGND VGND VPWR VPWR sky130_fd_sc_hd__decap_3
Xaccumulator._2406_ clknet_2_2__leaf_clock accumulator._0007_ VGND VGND VPWR VPWR
+ accumulator.io_accOut\[5\] sky130_fd_sc_hd__dfxtp_2
XFILLER_0_63_312 VGND VGND VPWR VPWR sky130_fd_sc_hd__fill_2
Xaccumulator._2268_ accumulator._0103_ accumulator._0104_ accumulator._1101_ VGND
+ VGND VPWR VPWR accumulator._0202_ sky130_fd_sc_hd__a21o_1
Xaccumulator._2199_ accumulator._1024_ accumulator._1032_ net69 VGND VGND VPWR VPWR
+ accumulator._0134_ sky130_fd_sc_hd__mux2_2
Xaccumulator._2337_ accumulator._0265_ VGND VGND VPWR VPWR accumulator._0269_ sky130_fd_sc_hd__inv_2
Xaccumulator._1219_ accumulator.io_inMant\[17\] accumulator.io_inMant\[16\] accumulator._0205_
+ VGND VGND VPWR VPWR accumulator._0215_ sky130_fd_sc_hd__or3_4
XFILLER_0_16_272 VGND VGND VPWR VPWR sky130_fd_sc_hd__decap_6
XFILLER_0_7_3 VGND VGND VPWR VPWR sky130_fd_sc_hd__decap_8
XTAP_TAPCELL_ROW_59_598 VGND VPWR sky130_fd_sc_hd__tapvpwrvgnd_1
XTAP_TAPCELL_ROW_42_465 VGND VPWR sky130_fd_sc_hd__tapvpwrvgnd_1
XFILLER_0_13_13 VGND VGND VPWR VPWR sky130_fd_sc_hd__fill_1
XFILLER_0_22_253 VPWR VGND VPWR VGND sky130_ef_sc_hd__decap_12
Xaccumulator._1570_ accumulator._0665_ accumulator._0666_ accumulator._0558_ VGND
+ VGND VPWR VPWR accumulator._0667_ sky130_fd_sc_hd__o21ai_1
XFILLER_0_38_65 VPWR VGND VPWR VGND sky130_ef_sc_hd__decap_12
XFILLER_0_70_41 VPWR VGND VPWR VGND sky130_ef_sc_hd__decap_12
XFILLER_0_57_161 VGND VGND VPWR VPWR sky130_fd_sc_hd__decap_6
XFILLER_0_54_97 VGND VGND VPWR VPWR sky130_fd_sc_hd__fill_1
XFILLER_0_54_75 VGND VGND VPWR VPWR sky130_fd_sc_hd__fill_1
Xaccumulator._2053_ accumulator._0923_ accumulator._0970_ VGND VGND VPWR VPWR accumulator._1150_
+ sky130_fd_sc_hd__nand2_1
Xaccumulator._2122_ accumulator._1142_ accumulator._0042_ accumulator._0056_ accumulator._0397_
+ accumulator.io_accOut\[1\] VGND VGND VPWR VPWR accumulator._0057_ sky130_fd_sc_hd__a32o_1
XFILLER_0_9_225 VPWR VGND VPWR VGND sky130_ef_sc_hd__decap_12
XFILLER_0_70_85 VPWR VGND VPWR VGND sky130_ef_sc_hd__decap_12
XFILLER_0_60_359 VGND VGND VPWR VPWR sky130_fd_sc_hd__fill_1
XFILLER_0_57_183 VPWR VGND VPWR VGND sky130_ef_sc_hd__decap_12
XFILLER_0_13_231 VGND VGND VPWR VPWR sky130_fd_sc_hd__fill_1
Xaccumulator._1768_ accumulator._0863_ accumulator._0862_ VGND VGND VPWR VPWR accumulator._0865_
+ sky130_fd_sc_hd__and2b_1
Xaccumulator._1906_ accumulator._0986_ accumulator._0991_ accumulator._0985_ VGND
+ VGND VPWR VPWR accumulator._1003_ sky130_fd_sc_hd__and3_1
Xaccumulator._1837_ accumulator._0604_ accumulator._0655_ accumulator._0677_ accumulator._0933_
+ accumulator._0780_ VGND VGND VPWR VPWR accumulator._0934_ sky130_fd_sc_hd__a311o_1
Xaccumulator._1699_ accumulator.io_accOut\[5\] accumulator._0395_ accumulator._0791_
+ VGND VGND VPWR VPWR accumulator._0796_ sky130_fd_sc_hd__and3_1
XFILLER_0_63_131 VGND VGND VPWR VPWR sky130_fd_sc_hd__decap_8
XFILLER_0_55_109 VGND VGND VPWR VPWR sky130_fd_sc_hd__decap_3
XFILLER_0_36_356 VGND VGND VPWR VPWR sky130_fd_sc_hd__decap_8
XTAP_TAPCELL_ROW_47_502 VGND VPWR sky130_fd_sc_hd__tapvpwrvgnd_1
XFILLER_0_24_23 VGND VGND VPWR VPWR sky130_fd_sc_hd__decap_4
XFILLER_0_54_197 VGND VGND VPWR VPWR sky130_fd_sc_hd__fill_2
XFILLER_0_54_153 VGND VGND VPWR VPWR sky130_fd_sc_hd__decap_8
XFILLER_0_40_77 VGND VGND VPWR VPWR sky130_fd_sc_hd__decap_6
XFILLER_0_27_334 VGND VGND VPWR VPWR sky130_fd_sc_hd__fill_2
XFILLER_0_2_401 VPWR VGND VPWR VGND sky130_ef_sc_hd__decap_12
Xaccumulator._1622_ accumulator._0543_ accumulator._0645_ accumulator._0670_ VGND
+ VGND VPWR VPWR accumulator._0719_ sky130_fd_sc_hd__a21o_1
XFILLER_0_4_33 VGND VGND VPWR VPWR sky130_fd_sc_hd__fill_1
XscaleAdd._687_ scaleAdd._258_ scaleAdd._259_ VGND VGND VPWR VPWR scaleAdd._260_ sky130_fd_sc_hd__xnor2_1
XFILLER_0_10_223 VPWR VGND VPWR VGND sky130_ef_sc_hd__decap_12
XFILLER_0_10_256 VGND VGND VPWR VPWR sky130_fd_sc_hd__decap_4
XFILLER_0_10_278 VGND VGND VPWR VPWR sky130_fd_sc_hd__decap_8
Xaccumulator._1553_ accumulator._0419_ accumulator._0424_ VGND VGND VPWR VPWR accumulator._0650_
+ sky130_fd_sc_hd__or2_1
Xoperator._11_ net8 net4 VGND VGND VPWR VPWR operator.io_outSign sky130_fd_sc_hd__xor2_1
Xaccumulator._1484_ accumulator._0464_ accumulator._0580_ accumulator._0434_ VGND
+ VGND VPWR VPWR accumulator._0581_ sky130_fd_sc_hd__mux2_1
Xaccumulator._2036_ accumulator._1130_ accumulator._1132_ VGND VGND VPWR VPWR accumulator._1133_
+ sky130_fd_sc_hd__nand2_1
XTAP_TAPCELL_ROW_53_549 VGND VPWR sky130_fd_sc_hd__tapvpwrvgnd_1
Xaccumulator._2105_ accumulator._1149_ accumulator._1198_ accumulator._0038_ VGND
+ VGND VPWR VPWR accumulator._0039_ sky130_fd_sc_hd__a21o_1
XFILLER_0_41_381 VGND VGND VPWR VPWR sky130_fd_sc_hd__fill_2
XFILLER_0_33_359 VGND VGND VPWR VPWR sky130_fd_sc_hd__fill_2
XFILLER_0_33_337 VGND VGND VPWR VPWR sky130_fd_sc_hd__decap_4
XFILLER_0_33_326 VGND VGND VPWR VPWR sky130_fd_sc_hd__decap_8
XTAP_TAPCELL_ROW_69_671 VGND VPWR sky130_fd_sc_hd__tapvpwrvgnd_1
XFILLER_0_28_109 VPWR VGND VPWR VGND sky130_ef_sc_hd__decap_12
XTAP_TAPCELL_ROW_1_160 VGND VPWR sky130_fd_sc_hd__tapvpwrvgnd_1
XFILLER_0_36_153 VPWR VGND VPWR VGND sky130_ef_sc_hd__decap_12
XFILLER_0_36_120 VGND VGND VPWR VPWR sky130_fd_sc_hd__fill_2
XscaleAdd._610_ scaleAdd._330_ scaleAdd._140_ VGND VGND VPWR VPWR scaleAdd._186_ sky130_fd_sc_hd__nand2_1
XFILLER_0_10_25 VGND VGND VPWR VPWR sky130_fd_sc_hd__decap_3
XscaleAdd._541_ scaleAdd._118_ scaleAdd._119_ VGND VGND VPWR VPWR accumulator.io_inMant\[8\]
+ sky130_fd_sc_hd__nor2_1
XFILLER_0_32_392 VPWR VGND VPWR VGND sky130_ef_sc_hd__decap_12
XscaleAdd._472_ scaleAdd._010_ scaleAdd._011_ VGND VGND VPWR VPWR scaleAdd._052_ sky130_fd_sc_hd__nand2_1
XFILLER_0_35_55 VGND VGND VPWR VPWR sky130_fd_sc_hd__fill_1
XFILLER_0_51_87 VGND VGND VPWR VPWR sky130_fd_sc_hd__fill_1
XTAP_TAPCELL_ROW_15_262 VGND VPWR sky130_fd_sc_hd__tapvpwrvgnd_1
XscaleAdd._739_ operator.io_outExp\[2\] VGND VGND VPWR VPWR scaleAdd._305_ sky130_fd_sc_hd__inv_2
XFILLER_0_2_253 VGND VGND VPWR VPWR sky130_fd_sc_hd__decap_8
XFILLER_0_48_3 VPWR VGND VPWR VGND sky130_ef_sc_hd__decap_12
Xaccumulator._1605_ accumulator._0427_ accumulator._0701_ VGND VGND VPWR VPWR accumulator._0702_
+ sky130_fd_sc_hd__or2_1
Xaccumulator._1536_ accumulator._0631_ accumulator._0632_ accumulator._0611_ VGND
+ VGND VPWR VPWR accumulator._0633_ sky130_fd_sc_hd__a21o_1
XTAP_TAPCELL_ROW_7_208 VGND VPWR sky130_fd_sc_hd__tapvpwrvgnd_1
XFILLER_0_38_407 VPWR VGND VPWR VGND sky130_ef_sc_hd__decap_12
Xaccumulator._1398_ accumulator.io_accOut\[14\] accumulator._0494_ accumulator._0485_
+ VGND VGND VPWR VPWR accumulator._0495_ sky130_fd_sc_hd__mux2_1
Xaccumulator._1467_ accumulator.io_accOut\[19\] accumulator._0563_ accumulator._0394_
+ VGND VGND VPWR VPWR accumulator._0564_ sky130_fd_sc_hd__mux2_1
XFILLER_0_65_237 VGND VGND VPWR VPWR sky130_fd_sc_hd__fill_2
Xaccumulator._2019_ accumulator._0907_ accumulator._0965_ accumulator._0906_ VGND
+ VGND VPWR VPWR accumulator._1116_ sky130_fd_sc_hd__o21ba_1
Xclkload2 clknet_2_3__leaf_clock VGND VGND VPWR VPWR clkload2/Y sky130_fd_sc_hd__clkinv_1
XFILLER_0_33_167 VGND VGND VPWR VPWR sky130_fd_sc_hd__fill_1
XscaleAdd._524_ scaleAdd._020_ scaleAdd._044_ scaleAdd._102_ VGND VGND VPWR VPWR scaleAdd._103_
+ sky130_fd_sc_hd__a21oi_2
XTAP_TAPCELL_ROW_12_243 VGND VPWR sky130_fd_sc_hd__tapvpwrvgnd_1
XscaleAdd._386_ scaleAdd._311_ scaleAdd._327_ VGND VGND VPWR VPWR scaleAdd._329_ sky130_fd_sc_hd__and2_1
XscaleAdd._455_ scaleAdd._313_ net55 scaleAdd._324_ scaleAdd._354_ scaleAdd._357_
+ VGND VGND VPWR VPWR scaleAdd._036_ sky130_fd_sc_hd__a41o_1
XTAP_TAPCELL_ROW_63_622 VGND VPWR sky130_fd_sc_hd__tapvpwrvgnd_1
XFILLER_0_62_53 VGND VGND VPWR VPWR sky130_fd_sc_hd__decap_8
XFILLER_0_46_65 VGND VGND VPWR VPWR sky130_fd_sc_hd__decap_8
Xaccumulator._1321_ accumulator._0403_ accumulator._0417_ VGND VGND VPWR VPWR accumulator._0418_
+ sky130_fd_sc_hd__nand2_2
X_26_ accumulator.io_accOut\[26\] VGND VGND VPWR VPWR net40 sky130_fd_sc_hd__clkbuf_1
Xaccumulator._1252_ accumulator._0349_ accumulator._0350_ VGND VGND VPWR VPWR accumulator._0351_
+ sky130_fd_sc_hd__xnor2_1
Xaccumulator._2370_ accumulator.io_accOut\[27\] accumulator._0406_ VGND VGND VPWR
+ VPWR accumulator._0303_ sky130_fd_sc_hd__or2_1
XFILLER_0_55_281 VPWR VGND VPWR VGND sky130_ef_sc_hd__decap_12
XFILLER_0_11_373 VPWR VGND VPWR VGND sky130_ef_sc_hd__decap_12
XFILLER_0_15_167 VGND VGND VPWR VPWR sky130_fd_sc_hd__fill_1
Xaccumulator._1519_ accumulator._0536_ accumulator._0564_ accumulator._0543_ VGND
+ VGND VPWR VPWR accumulator._0616_ sky130_fd_sc_hd__a21o_1
Xhold47 accumulator.state\[0\] VGND VGND VPWR VPWR net104 sky130_fd_sc_hd__dlygate4sd3_1
XFILLER_0_38_215 VPWR VGND VPWR VGND sky130_ef_sc_hd__decap_12
XTAP_TAPCELL_ROW_26_346 VGND VPWR sky130_fd_sc_hd__tapvpwrvgnd_1
XFILLER_0_46_270 VGND VGND VPWR VPWR sky130_fd_sc_hd__fill_2
XFILLER_0_69_373 VPWR VGND VPWR VGND sky130_ef_sc_hd__decap_12
XTAP_TAPCELL_ROW_60_603 VGND VPWR sky130_fd_sc_hd__tapvpwrvgnd_1
XFILLER_0_44_229 VGND VGND VPWR VPWR sky130_fd_sc_hd__fill_2
XFILLER_0_37_292 VPWR VGND VPWR VGND sky130_ef_sc_hd__decap_12
XFILLER_0_37_281 VGND VGND VPWR VPWR sky130_fd_sc_hd__decap_8
Xaccumulator._1870_ accumulator._0923_ accumulator._0737_ accumulator._0966_ VGND
+ VGND VPWR VPWR accumulator._0967_ sky130_fd_sc_hd__or3_1
XscaleAdd._507_ scaleAdd._319_ net13 scaleAdd._337_ scaleAdd._308_ VGND VGND VPWR
+ VPWR scaleAdd._086_ sky130_fd_sc_hd__a22oi_1
XPHY_EDGE_ROW_69_Left_140 VGND VGND VPWR VPWR sky130_fd_sc_hd__decap_3
XFILLER_0_57_86 VGND VGND VPWR VPWR sky130_fd_sc_hd__fill_1
XFILLER_0_32_6 VPWR VGND VPWR VGND sky130_ef_sc_hd__decap_12
Xaccumulator._2422_ clknet_2_1__leaf_clock accumulator._0023_ VGND VGND VPWR VPWR
+ accumulator.io_accOut\[21\] sky130_fd_sc_hd__dfxtp_1
Xaccumulator._2353_ accumulator._0284_ accumulator._0285_ VGND VGND VPWR VPWR accumulator._0286_
+ sky130_fd_sc_hd__or2_1
XscaleAdd._438_ scaleAdd._018_ scaleAdd._017_ VGND VGND VPWR VPWR scaleAdd._019_ sky130_fd_sc_hd__xnor2_2
XscaleAdd._369_ scaleAdd._314_ VGND VGND VPWR VPWR accumulator.io_inMant\[0\] sky130_fd_sc_hd__buf_1
XFILLER_0_20_181 VGND VGND VPWR VPWR sky130_fd_sc_hd__decap_4
Xaccumulator._2284_ accumulator._0072_ accumulator._0172_ accumulator._0188_ accumulator._1149_
+ VGND VGND VPWR VPWR accumulator._0218_ sky130_fd_sc_hd__a211o_1
Xaccumulator._1304_ accumulator._0402_ VGND VGND VPWR VPWR accumulator._0403_ sky130_fd_sc_hd__clkbuf_4
X_09_ accumulator.io_accOut\[9\] VGND VGND VPWR VPWR net53 sky130_fd_sc_hd__buf_1
XTAP_TAPCELL_ROW_23_327 VGND VPWR sky130_fd_sc_hd__tapvpwrvgnd_1
Xaccumulator._1235_ accumulator.io_inMant\[13\] accumulator._0333_ accumulator.io_inMant\[14\]
+ VGND VGND VPWR VPWR accumulator._0334_ sky130_fd_sc_hd__o21ba_1
XFILLER_0_43_262 VGND VGND VPWR VPWR sky130_fd_sc_hd__decap_8
XFILLER_0_35_229 VGND VGND VPWR VPWR sky130_fd_sc_hd__fill_1
XFILLER_0_35_218 VGND VGND VPWR VPWR sky130_fd_sc_hd__fill_1
XFILLER_0_31_402 VGND VGND VPWR VPWR sky130_fd_sc_hd__fill_1
XTAP_TAPCELL_ROW_31_382 VGND VPWR sky130_fd_sc_hd__tapvpwrvgnd_1
XFILLER_0_28_292 VGND VGND VPWR VPWR sky130_fd_sc_hd__decap_6
XFILLER_0_7_153 VGND VGND VPWR VPWR sky130_fd_sc_hd__decap_8
Xaccumulator._1999_ accumulator._0882_ accumulator._1095_ VGND VGND VPWR VPWR accumulator._1096_
+ sky130_fd_sc_hd__xor2_2
Xoutput48 net48 VGND VGND VPWR VPWR io_accOut[4] sky130_fd_sc_hd__buf_2
Xoutput26 net26 VGND VGND VPWR VPWR io_accOut[13] sky130_fd_sc_hd__buf_2
XPHY_EDGE_ROW_1_Right_1 VGND VGND VPWR VPWR sky130_fd_sc_hd__decap_3
Xoutput37 net37 VGND VGND VPWR VPWR io_accOut[23] sky130_fd_sc_hd__buf_2
XFILLER_0_66_365 VPWR VGND VPWR VGND sky130_ef_sc_hd__decap_12
XFILLER_0_66_332 VGND VGND VPWR VPWR sky130_fd_sc_hd__fill_2
XFILLER_0_19_281 VGND VGND VPWR VPWR sky130_fd_sc_hd__fill_1
XFILLER_0_19_292 VGND VGND VPWR VPWR sky130_fd_sc_hd__fill_1
XFILLER_0_34_251 VGND VGND VPWR VPWR sky130_fd_sc_hd__fill_1
XFILLER_0_1_329 VGND VGND VPWR VPWR sky130_fd_sc_hd__decap_6
XFILLER_0_43_55 VGND VGND VPWR VPWR sky130_fd_sc_hd__fill_1
Xaccumulator._1922_ accumulator._0804_ accumulator._0798_ VGND VGND VPWR VPWR accumulator._1019_
+ sky130_fd_sc_hd__and2b_1
XFILLER_0_4_156 VGND VGND VPWR VPWR sky130_fd_sc_hd__fill_2
XFILLER_0_4_112 VGND VGND VPWR VPWR sky130_fd_sc_hd__decap_8
XFILLER_0_17_218 VGND VGND VPWR VPWR sky130_fd_sc_hd__decap_6
XFILLER_0_68_85 VGND VGND VPWR VPWR sky130_fd_sc_hd__decap_8
XFILLER_0_68_41 VPWR VGND VPWR VGND sky130_ef_sc_hd__decap_12
Xaccumulator._1853_ accumulator._0854_ accumulator._0948_ accumulator._0949_ VGND
+ VGND VPWR VPWR accumulator._0950_ sky130_fd_sc_hd__a21o_1
XFILLER_0_40_232 VGND VGND VPWR VPWR sky130_fd_sc_hd__fill_1
Xaccumulator._1784_ accumulator.io_accOut\[17\] accumulator._0449_ accumulator._0404_
+ VGND VGND VPWR VPWR accumulator._0881_ sky130_fd_sc_hd__mux2_2
XFILLER_0_4_178 VPWR VGND VPWR VGND sky130_ef_sc_hd__decap_12
Xaccumulator._2405_ clknet_2_2__leaf_clock accumulator._0006_ VGND VGND VPWR VPWR
+ accumulator.io_accOut\[4\] sky130_fd_sc_hd__dfxtp_1
Xaccumulator._2336_ accumulator._0259_ VGND VGND VPWR VPWR accumulator._0268_ sky130_fd_sc_hd__inv_2
XFILLER_0_48_321 VGND VGND VPWR VPWR sky130_fd_sc_hd__decap_4
Xaccumulator._2267_ accumulator._0086_ accumulator._0173_ VGND VGND VPWR VPWR accumulator._0201_
+ sky130_fd_sc_hd__and2_1
Xaccumulator._2198_ accumulator.io_accOut\[8\] accumulator._0091_ VGND VGND VPWR VPWR
+ accumulator._0133_ sky130_fd_sc_hd__and2_1
Xaccumulator._1218_ accumulator.io_inMant\[12\] accumulator.io_inMant\[13\] accumulator._0185_
+ accumulator._0195_ VGND VGND VPWR VPWR accumulator._0205_ sky130_fd_sc_hd__o31a_1
XFILLER_0_16_251 VGND VGND VPWR VPWR sky130_fd_sc_hd__fill_1
XFILLER_0_54_313 VGND VGND VPWR VPWR sky130_fd_sc_hd__fill_2
XTAP_TAPCELL_ROW_42_466 VGND VPWR sky130_fd_sc_hd__tapvpwrvgnd_1
XFILLER_0_22_265 VGND VGND VPWR VPWR sky130_fd_sc_hd__decap_8
XFILLER_0_1_126 VGND VGND VPWR VPWR sky130_fd_sc_hd__decap_3
XFILLER_0_38_77 VGND VGND VPWR VPWR sky130_fd_sc_hd__decap_6
XFILLER_0_70_53 VGND VGND VPWR VPWR sky130_fd_sc_hd__decap_3
XFILLER_0_57_195 VGND VGND VPWR VPWR sky130_fd_sc_hd__decap_4
XFILLER_0_57_173 VGND VGND VPWR VPWR sky130_fd_sc_hd__fill_1
XFILLER_0_45_335 VGND VGND VPWR VPWR sky130_fd_sc_hd__fill_1
XFILLER_0_45_313 VGND VGND VPWR VPWR sky130_fd_sc_hd__decap_8
Xaccumulator._2121_ accumulator._1149_ accumulator._0049_ accumulator._0054_ VGND
+ VGND VPWR VPWR accumulator._0056_ sky130_fd_sc_hd__a21o_1
Xaccumulator._2052_ accumulator._1148_ VGND VGND VPWR VPWR accumulator._1149_ sky130_fd_sc_hd__clkbuf_4
XTAP_TAPCELL_ROW_33_400 VGND VPWR sky130_fd_sc_hd__tapvpwrvgnd_1
XFILLER_0_9_237 VGND VGND VPWR VPWR sky130_fd_sc_hd__decap_3
XFILLER_0_70_97 VPWR VGND VPWR VGND sky130_ef_sc_hd__decap_12
XFILLER_0_60_305 VGND VGND VPWR VPWR sky130_fd_sc_hd__decap_3
Xaccumulator._1905_ accumulator._0754_ accumulator._1001_ VGND VGND VPWR VPWR accumulator._1002_
+ sky130_fd_sc_hd__xnor2_2
XFILLER_0_45_357 VPWR VGND VPWR VGND sky130_ef_sc_hd__decap_12
XFILLER_0_13_221 VGND VGND VPWR VPWR sky130_fd_sc_hd__decap_3
Xaccumulator._1767_ accumulator._0862_ accumulator._0863_ VGND VGND VPWR VPWR accumulator._0864_
+ sky130_fd_sc_hd__and2b_1
Xaccumulator._1698_ accumulator._0793_ accumulator._0794_ VGND VGND VPWR VPWR accumulator._0795_
+ sky130_fd_sc_hd__or2b_2
Xaccumulator._1836_ accumulator.io_accOut\[2\] accumulator._0395_ accumulator._0602_
+ VGND VGND VPWR VPWR accumulator._0933_ sky130_fd_sc_hd__and3_1
XFILLER_0_0_181 VPWR VGND VPWR VGND sky130_ef_sc_hd__decap_12
Xaccumulator._2319_ accumulator._1148_ accumulator._0219_ accumulator._0222_ VGND
+ VGND VPWR VPWR accumulator._0252_ sky130_fd_sc_hd__or3_1
XTAP_TAPCELL_ROW_56_569 VGND VPWR sky130_fd_sc_hd__tapvpwrvgnd_1
XFILLER_0_63_198 VGND VGND VPWR VPWR sky130_fd_sc_hd__fill_2
XFILLER_0_48_195 VGND VGND VPWR VPWR sky130_fd_sc_hd__fill_1
XFILLER_0_8_270 VGND VGND VPWR VPWR sky130_fd_sc_hd__decap_8
XFILLER_0_59_405 VPWR VGND VPWR VGND sky130_ef_sc_hd__decap_12
XTAP_TAPCELL_ROW_47_503 VGND VPWR sky130_fd_sc_hd__tapvpwrvgnd_1
XTAP_TAPCELL_ROW_4_180 VGND VPWR sky130_fd_sc_hd__tapvpwrvgnd_1
XscaleAdd._686_ scaleAdd._230_ scaleAdd._241_ scaleAdd._239_ VGND VGND VPWR VPWR scaleAdd._259_
+ sky130_fd_sc_hd__o21a_1
XFILLER_0_2_413 VGND VGND VPWR VPWR sky130_fd_sc_hd__decap_6
XFILLER_0_6_218 VPWR VGND VPWR VGND sky130_ef_sc_hd__decap_12
Xaccumulator._1621_ accumulator._0559_ accumulator._0716_ accumulator._0717_ accumulator._0635_
+ VGND VGND VPWR VPWR accumulator._0718_ sky130_fd_sc_hd__a211oi_2
XFILLER_0_50_371 VGND VGND VPWR VPWR sky130_fd_sc_hd__decap_6
Xaccumulator._1552_ accumulator._0428_ accumulator._0648_ accumulator._0523_ VGND
+ VGND VPWR VPWR accumulator._0649_ sky130_fd_sc_hd__o21a_1
XFILLER_0_10_235 VGND VGND VPWR VPWR sky130_fd_sc_hd__decap_8
Xaccumulator._2104_ accumulator._1148_ accumulator._0037_ VGND VGND VPWR VPWR accumulator._0038_
+ sky130_fd_sc_hd__nor2_1
Xaccumulator._1483_ accumulator._0566_ accumulator._0579_ accumulator._0439_ VGND
+ VGND VPWR VPWR accumulator._0580_ sky130_fd_sc_hd__mux2_1
Xaccumulator._2035_ accumulator._1131_ VGND VGND VPWR VPWR accumulator._1132_ sky130_fd_sc_hd__clkbuf_4
XFILLER_0_45_176 VPWR VGND VPWR VGND sky130_ef_sc_hd__decap_12
XFILLER_0_18_357 VGND VGND VPWR VPWR sky130_fd_sc_hd__decap_6
Xaccumulator._1819_ accumulator._0903_ accumulator._0909_ accumulator._0913_ accumulator._0915_
+ VGND VGND VPWR VPWR accumulator._0916_ sky130_fd_sc_hd__a31o_1
XTAP_TAPCELL_ROW_69_672 VGND VPWR sky130_fd_sc_hd__tapvpwrvgnd_1
XTAP_TAPCELL_ROW_1_161 VGND VPWR sky130_fd_sc_hd__tapvpwrvgnd_1
XFILLER_0_51_157 VGND VGND VPWR VPWR sky130_fd_sc_hd__decap_3
XFILLER_0_51_113 VGND VGND VPWR VPWR sky130_fd_sc_hd__decap_3
XFILLER_0_36_165 VGND VGND VPWR VPWR sky130_fd_sc_hd__decap_8
XFILLER_0_10_48 VPWR VGND VPWR VGND sky130_ef_sc_hd__decap_12
XscaleAdd._540_ scaleAdd._075_ scaleAdd._072_ scaleAdd._117_ VGND VGND VPWR VPWR scaleAdd._119_
+ sky130_fd_sc_hd__and3_1
XFILLER_0_17_390 VGND VGND VPWR VPWR sky130_fd_sc_hd__fill_2
XscaleAdd._471_ scaleAdd._307_ scaleAdd._337_ scaleAdd._002_ scaleAdd._050_ VGND VGND
+ VPWR VPWR scaleAdd._051_ sky130_fd_sc_hd__a31o_1
XFILLER_0_19_57 VGND VGND VPWR VPWR sky130_fd_sc_hd__decap_8
XPHY_EDGE_ROW_32_Left_103 VGND VGND VPWR VPWR sky130_fd_sc_hd__decap_3
XFILLER_0_51_55 VGND VGND VPWR VPWR sky130_fd_sc_hd__fill_1
XPHY_EDGE_ROW_41_Left_112 VGND VGND VPWR VPWR sky130_fd_sc_hd__decap_3
XFILLER_0_27_176 VPWR VGND VPWR VGND sky130_ef_sc_hd__decap_12
XTAP_TAPCELL_ROW_15_263 VGND VPWR sky130_fd_sc_hd__tapvpwrvgnd_1
XFILLER_0_30_319 VGND VGND VPWR VPWR sky130_fd_sc_hd__decap_6
XFILLER_0_27_198 VGND VGND VPWR VPWR sky130_fd_sc_hd__fill_1
XscaleAdd._738_ scaleAdd._301_ scaleAdd._302_ VGND VGND VPWR VPWR scaleAdd._304_ sky130_fd_sc_hd__and2_1
XscaleAdd._669_ scaleAdd._330_ scaleAdd._188_ scaleAdd._222_ VGND VGND VPWR VPWR scaleAdd._243_
+ sky130_fd_sc_hd__and3_1
XPHY_EDGE_ROW_50_Left_121 VGND VGND VPWR VPWR sky130_fd_sc_hd__decap_3
Xaccumulator._1535_ accumulator._0478_ accumulator._0538_ accumulator._0469_ VGND
+ VGND VPWR VPWR accumulator._0632_ sky130_fd_sc_hd__a21o_1
Xaccumulator._1604_ accumulator._0468_ accumulator._0471_ net72 accumulator._0592_
+ VGND VGND VPWR VPWR accumulator._0701_ sky130_fd_sc_hd__or4bb_1
XFILLER_0_65_205 VGND VGND VPWR VPWR sky130_fd_sc_hd__fill_1
XFILLER_0_38_419 VGND VGND VPWR VPWR sky130_fd_sc_hd__fill_1
Xaccumulator._1397_ accumulator._0435_ accumulator._0490_ accumulator._0493_ accumulator._0453_
+ VGND VGND VPWR VPWR accumulator._0494_ sky130_fd_sc_hd__a22o_1
Xaccumulator._1466_ accumulator._0435_ accumulator._0512_ accumulator._0560_ accumulator._0562_
+ VGND VGND VPWR VPWR accumulator._0563_ sky130_fd_sc_hd__a22o_1
Xaccumulator._2018_ accumulator._1099_ accumulator._1101_ accumulator._1114_ VGND
+ VGND VPWR VPWR accumulator._1115_ sky130_fd_sc_hd__or3_1
XFILLER_0_33_113 VPWR VGND VPWR VGND sky130_ef_sc_hd__decap_12
XFILLER_0_18_187 VGND VGND VPWR VPWR sky130_fd_sc_hd__decap_3
XTAP_TAPCELL_ROW_12_244 VGND VPWR sky130_fd_sc_hd__tapvpwrvgnd_1
XscaleAdd._523_ scaleAdd._307_ scaleAdd._349_ scaleAdd._346_ VGND VGND VPWR VPWR scaleAdd._102_
+ sky130_fd_sc_hd__o21ai_1
XscaleAdd._454_ operator.io_outMant\[2\] net55 scaleAdd._032_ scaleAdd._033_ VGND
+ VGND VPWR VPWR scaleAdd._035_ sky130_fd_sc_hd__a22o_1
Xaccumulator._1320_ accumulator._0410_ accumulator._0415_ accumulator._0416_ VGND
+ VGND VPWR VPWR accumulator._0417_ sky130_fd_sc_hd__or3_1
XscaleAdd._385_ scaleAdd._311_ scaleAdd._327_ VGND VGND VPWR VPWR scaleAdd._328_ sky130_fd_sc_hd__nor2_1
XTAP_TAPCELL_ROW_63_623 VGND VPWR sky130_fd_sc_hd__tapvpwrvgnd_1
X_25_ accumulator.io_accOut\[25\] VGND VGND VPWR VPWR net39 sky130_fd_sc_hd__clkbuf_1
XFILLER_0_1_57 VGND VGND VPWR VPWR sky130_fd_sc_hd__decap_4
Xaccumulator._1251_ accumulator._0225_ accumulator._0293_ accumulator._0338_ accumulator._0273_
+ VGND VGND VPWR VPWR accumulator._0350_ sky130_fd_sc_hd__a31o_1
XFILLER_0_55_293 VPWR VGND VPWR VGND sky130_ef_sc_hd__decap_12
XFILLER_0_15_113 VPWR VGND VPWR VGND sky130_ef_sc_hd__decap_12
XFILLER_0_60_3 VPWR VGND VPWR VGND sky130_ef_sc_hd__decap_12
XFILLER_0_30_149 VGND VGND VPWR VPWR sky130_fd_sc_hd__decap_3
XFILLER_0_30_127 VGND VGND VPWR VPWR sky130_fd_sc_hd__decap_4
XFILLER_0_23_190 VGND VGND VPWR VPWR sky130_fd_sc_hd__decap_4
XFILLER_0_11_385 VGND VGND VPWR VPWR sky130_fd_sc_hd__decap_6
Xaccumulator._1518_ accumulator._0536_ accumulator._0583_ accumulator._0539_ VGND
+ VGND VPWR VPWR accumulator._0615_ sky130_fd_sc_hd__a21o_1
Xaccumulator._1449_ accumulator._0434_ accumulator._0453_ accumulator._0479_ VGND
+ VGND VPWR VPWR accumulator._0546_ sky130_fd_sc_hd__and3_1
Xhold48 accumulator.io_accOut\[26\] VGND VGND VPWR VPWR net105 sky130_fd_sc_hd__dlygate4sd3_1
XFILLER_0_38_227 VGND VGND VPWR VPWR sky130_fd_sc_hd__fill_1
XTAP_TAPCELL_ROW_26_347 VGND VPWR sky130_fd_sc_hd__tapvpwrvgnd_1
XFILLER_0_61_285 VGND VGND VPWR VPWR sky130_fd_sc_hd__fill_1
XFILLER_0_61_241 VPWR VGND VPWR VGND sky130_ef_sc_hd__decap_12
XPHY_EDGE_ROW_7_Left_78 VGND VGND VPWR VPWR sky130_fd_sc_hd__decap_3
XFILLER_0_69_385 VGND VGND VPWR VPWR sky130_fd_sc_hd__decap_6
XTAP_TAPCELL_ROW_60_604 VGND VPWR sky130_fd_sc_hd__tapvpwrvgnd_1
XscaleAdd._506_ scaleAdd._084_ VGND VGND VPWR VPWR scaleAdd._085_ sky130_fd_sc_hd__clkbuf_2
XFILLER_0_12_138 VGND VGND VPWR VPWR sky130_fd_sc_hd__fill_2
XscaleAdd._437_ scaleAdd._339_ scaleAdd._341_ scaleAdd._336_ VGND VGND VPWR VPWR scaleAdd._018_
+ sky130_fd_sc_hd__o21ba_1
Xaccumulator._2283_ accumulator._0216_ accumulator._0217_ accumulator._0093_ VGND
+ VGND VPWR VPWR accumulator._0019_ sky130_fd_sc_hd__o21a_1
Xaccumulator._2421_ clknet_2_3__leaf_clock accumulator._0022_ VGND VGND VPWR VPWR
+ accumulator.io_accOut\[20\] sky130_fd_sc_hd__dfxtp_1
X_08_ accumulator.io_accOut\[8\] VGND VGND VPWR VPWR net52 sky130_fd_sc_hd__buf_1
Xaccumulator._1303_ accumulator._0401_ VGND VGND VPWR VPWR accumulator._0402_ sky130_fd_sc_hd__buf_6
XFILLER_0_25_6 VPWR VGND VPWR VGND sky130_ef_sc_hd__decap_12
Xaccumulator._2352_ accumulator._1148_ accumulator._0272_ accumulator._0282_ VGND
+ VGND VPWR VPWR accumulator._0285_ sky130_fd_sc_hd__a21oi_1
XscaleAdd._368_ scaleAdd._303_ scaleAdd._313_ VGND VGND VPWR VPWR scaleAdd._314_ sky130_fd_sc_hd__and2_1
XTAP_TAPCELL_ROW_23_328 VGND VPWR sky130_fd_sc_hd__tapvpwrvgnd_1
Xaccumulator._1234_ accumulator.io_inMant\[11\] accumulator._0332_ accumulator.io_inMant\[12\]
+ VGND VGND VPWR VPWR accumulator._0333_ sky130_fd_sc_hd__o21ba_1
XFILLER_0_16_400 VPWR VGND VPWR VGND sky130_ef_sc_hd__decap_12
Xaccumulator._1998_ accumulator._0923_ accumulator._0865_ accumulator._1093_ accumulator._1094_
+ VGND VGND VPWR VPWR accumulator._1095_ sky130_fd_sc_hd__o31a_1
XTAP_TAPCELL_ROW_31_383 VGND VPWR sky130_fd_sc_hd__tapvpwrvgnd_1
XFILLER_0_7_176 VGND VGND VPWR VPWR sky130_fd_sc_hd__fill_1
Xoutput49 net49 VGND VGND VPWR VPWR io_accOut[5] sky130_fd_sc_hd__buf_2
Xoutput27 net27 VGND VGND VPWR VPWR io_accOut[14] sky130_fd_sc_hd__buf_2
Xoutput38 net38 VGND VGND VPWR VPWR io_accOut[24] sky130_fd_sc_hd__buf_2
XFILLER_0_3_393 VPWR VGND VPWR VGND sky130_ef_sc_hd__decap_12
XFILLER_0_66_377 VPWR VGND VPWR VGND sky130_ef_sc_hd__decap_12
XFILLER_0_34_285 VGND VGND VPWR VPWR sky130_fd_sc_hd__fill_2
XFILLER_0_27_57 VGND VGND VPWR VPWR sky130_fd_sc_hd__decap_8
Xaccumulator._1921_ accumulator._1015_ accumulator._1017_ VGND VGND VPWR VPWR accumulator._1018_
+ sky130_fd_sc_hd__xnor2_2
Xaccumulator._1852_ accumulator._0853_ accumulator._0855_ VGND VGND VPWR VPWR accumulator._0949_
+ sky130_fd_sc_hd__and2b_1
XFILLER_0_68_53 VPWR VGND VPWR VGND sky130_ef_sc_hd__decap_12
Xaccumulator._1783_ accumulator._0619_ accumulator._0733_ accumulator._0635_ VGND
+ VGND VPWR VPWR accumulator._0880_ sky130_fd_sc_hd__and3b_2
XFILLER_0_40_299 VGND VGND VPWR VPWR sky130_fd_sc_hd__decap_8
XPHY_EDGE_ROW_15_Right_15 VGND VGND VPWR VPWR sky130_fd_sc_hd__decap_3
Xaccumulator._2266_ accumulator._0110_ accumulator._0083_ accumulator._0137_ accumulator._0079_
+ VGND VGND VPWR VPWR accumulator._0200_ sky130_fd_sc_hd__o211a_1
XTAP_TAPCELL_ROW_36_420 VGND VPWR sky130_fd_sc_hd__tapvpwrvgnd_1
Xaccumulator._2404_ clknet_2_3__leaf_clock accumulator._0005_ VGND VGND VPWR VPWR
+ accumulator.io_accOut\[3\] sky130_fd_sc_hd__dfxtp_1
Xaccumulator._2335_ accumulator._0398_ accumulator._0266_ accumulator._0267_ accumulator._0177_
+ VGND VGND VPWR VPWR accumulator._0026_ sky130_fd_sc_hd__o211a_1
XPHY_EDGE_ROW_24_Right_24 VGND VGND VPWR VPWR sky130_fd_sc_hd__decap_3
XFILLER_0_23_3 VGND VGND VPWR VPWR sky130_fd_sc_hd__decap_8
Xaccumulator._2197_ accumulator._0117_ accumulator._0132_ accumulator._0400_ VGND
+ VGND VPWR VPWR accumulator._0009_ sky130_fd_sc_hd__a21boi_1
Xaccumulator._1217_ accumulator.io_inMant\[14\] accumulator.io_inMant\[15\] VGND VGND
+ VPWR VPWR accumulator._0195_ sky130_fd_sc_hd__nor2_1
XPHY_EDGE_ROW_33_Right_33 VGND VGND VPWR VPWR sky130_fd_sc_hd__decap_3
XFILLER_0_16_296 VGND VGND VPWR VPWR sky130_fd_sc_hd__fill_1
XFILLER_0_66_141 VGND VGND VPWR VPWR sky130_fd_sc_hd__decap_8
XPHY_EDGE_ROW_42_Right_42 VGND VGND VPWR VPWR sky130_fd_sc_hd__decap_3
XFILLER_0_39_333 VGND VGND VPWR VPWR sky130_fd_sc_hd__decap_3
XFILLER_0_13_26 VGND VGND VPWR VPWR sky130_fd_sc_hd__decap_8
XPHY_EDGE_ROW_51_Right_51 VGND VGND VPWR VPWR sky130_fd_sc_hd__decap_3
XTAP_TAPCELL_ROW_42_467 VGND VPWR sky130_fd_sc_hd__tapvpwrvgnd_1
XFILLER_0_39_388 VGND VGND VPWR VPWR sky130_fd_sc_hd__fill_1
XFILLER_0_22_299 VGND VGND VPWR VPWR sky130_fd_sc_hd__decap_8
XPHY_EDGE_ROW_60_Right_60 VGND VGND VPWR VPWR sky130_fd_sc_hd__decap_3
Xaccumulator._2120_ accumulator._0050_ accumulator._0035_ accumulator._0053_ VGND
+ VGND VPWR VPWR accumulator._0054_ sky130_fd_sc_hd__and3_1
XFILLER_0_45_369 VGND VGND VPWR VPWR sky130_fd_sc_hd__decap_8
XTAP_TAPCELL_ROW_33_401 VGND VPWR sky130_fd_sc_hd__tapvpwrvgnd_1
Xaccumulator._2051_ accumulator._1147_ VGND VGND VPWR VPWR accumulator._1148_ sky130_fd_sc_hd__clkbuf_4
XFILLER_0_9_205 VGND VGND VPWR VPWR sky130_fd_sc_hd__decap_8
XFILLER_0_60_339 VPWR VGND VPWR VGND sky130_ef_sc_hd__decap_12
Xaccumulator._1904_ accumulator._0922_ accumulator._0786_ accumulator._0795_ accumulator._1000_
+ VGND VGND VPWR VPWR accumulator._1001_ sky130_fd_sc_hd__a31o_1
Xaccumulator._1835_ accumulator._0779_ VGND VGND VPWR VPWR accumulator._0932_ sky130_fd_sc_hd__inv_2
Xaccumulator._1766_ accumulator._0740_ accumulator._0852_ accumulator._0741_ VGND
+ VGND VPWR VPWR accumulator._0863_ sky130_fd_sc_hd__or3_1
Xaccumulator._1697_ accumulator._0791_ accumulator._0792_ VGND VGND VPWR VPWR accumulator._0794_
+ sky130_fd_sc_hd__nand2_1
XFILLER_0_0_193 VGND VGND VPWR VPWR sky130_fd_sc_hd__decap_3
XFILLER_0_36_303 VGND VGND VPWR VPWR sky130_fd_sc_hd__decap_4
Xaccumulator._2249_ accumulator.io_accOut\[13\] accumulator._0167_ accumulator._0178_
+ accumulator._0183_ accumulator._0177_ VGND VGND VPWR VPWR accumulator._0015_ sky130_fd_sc_hd__o221a_1
Xaccumulator._2318_ accumulator.io_accOut\[22\] accumulator._0397_ VGND VGND VPWR
+ VPWR accumulator._0251_ sky130_fd_sc_hd__and2_1
XFILLER_0_48_163 VPWR VGND VPWR VGND sky130_ef_sc_hd__decap_12
XFILLER_0_44_391 VGND VGND VPWR VPWR sky130_fd_sc_hd__fill_1
XFILLER_0_36_325 VGND VGND VPWR VPWR sky130_fd_sc_hd__fill_1
XFILLER_0_59_417 VGND VGND VPWR VPWR sky130_fd_sc_hd__decap_4
XTAP_TAPCELL_ROW_47_504 VGND VPWR sky130_fd_sc_hd__tapvpwrvgnd_1
XTAP_TAPCELL_ROW_4_181 VGND VPWR sky130_fd_sc_hd__tapvpwrvgnd_1
XFILLER_0_54_133 VGND VGND VPWR VPWR sky130_fd_sc_hd__decap_6
XFILLER_0_54_111 VGND VGND VPWR VPWR sky130_fd_sc_hd__decap_8
XFILLER_0_39_141 VGND VGND VPWR VPWR sky130_fd_sc_hd__decap_8
XFILLER_0_27_303 VGND VGND VPWR VPWR sky130_fd_sc_hd__decap_8
XFILLER_0_49_55 VGND VGND VPWR VPWR sky130_fd_sc_hd__fill_1
XFILLER_0_42_317 VPWR VGND VPWR VGND sky130_ef_sc_hd__decap_12
XFILLER_0_35_391 VGND VGND VPWR VPWR sky130_fd_sc_hd__fill_1
XscaleAdd._685_ scaleAdd._256_ scaleAdd._257_ VGND VGND VPWR VPWR scaleAdd._258_ sky130_fd_sc_hd__or2_1
XFILLER_0_49_66 VGND VGND VPWR VPWR sky130_fd_sc_hd__decap_3
Xaccumulator._1620_ accumulator._0599_ accumulator._0545_ accumulator._0552_ VGND
+ VGND VPWR VPWR accumulator._0717_ sky130_fd_sc_hd__and3_1
Xaccumulator._1551_ accumulator._0644_ accumulator._0647_ accumulator._0475_ VGND
+ VGND VPWR VPWR accumulator._0648_ sky130_fd_sc_hd__mux2_1
XFILLER_0_4_24 VGND VGND VPWR VPWR sky130_fd_sc_hd__decap_4
Xaccumulator._1482_ accumulator.io_inMant\[13\] accumulator.io_inMant\[14\] accumulator._0436_
+ VGND VGND VPWR VPWR accumulator._0579_ sky130_fd_sc_hd__mux2_1
XFILLER_0_65_87 VGND VGND VPWR VPWR sky130_fd_sc_hd__fill_1
Xaccumulator._2103_ accumulator._0715_ accumulator._0035_ accumulator._0036_ VGND
+ VGND VPWR VPWR accumulator._0037_ sky130_fd_sc_hd__nand3_1
Xaccumulator._2034_ accumulator._0968_ accumulator._1118_ accumulator._1128_ VGND
+ VGND VPWR VPWR accumulator._1131_ sky130_fd_sc_hd__or3b_1
XFILLER_0_45_188 VPWR VGND VPWR VGND sky130_ef_sc_hd__decap_12
XFILLER_0_45_144 VGND VGND VPWR VPWR sky130_fd_sc_hd__decap_8
Xaccumulator._1818_ accumulator._0904_ accumulator._0905_ accumulator._0909_ accumulator._0914_
+ VGND VGND VPWR VPWR accumulator._0915_ sky130_fd_sc_hd__a22o_1
XTAP_TAPCELL_ROW_69_673 VGND VPWR sky130_fd_sc_hd__tapvpwrvgnd_1
Xaccumulator._1749_ accumulator._0651_ accumulator._0725_ VGND VGND VPWR VPWR accumulator._0846_
+ sky130_fd_sc_hd__nor2_1
XTAP_TAPCELL_ROW_52_540 VGND VPWR sky130_fd_sc_hd__tapvpwrvgnd_1
XTAP_TAPCELL_ROW_1_162 VGND VPWR sky130_fd_sc_hd__tapvpwrvgnd_1
XFILLER_0_51_169 VGND VGND VPWR VPWR sky130_fd_sc_hd__fill_2
XFILLER_0_36_188 VGND VGND VPWR VPWR sky130_fd_sc_hd__decap_8
XFILLER_0_36_177 VGND VGND VPWR VPWR sky130_fd_sc_hd__decap_4
XFILLER_0_24_317 VGND VGND VPWR VPWR sky130_fd_sc_hd__fill_1
XscaleAdd._470_ scaleAdd._335_ scaleAdd._009_ VGND VGND VPWR VPWR scaleAdd._050_ sky130_fd_sc_hd__nor2_1
XFILLER_0_19_14 VGND VGND VPWR VPWR sky130_fd_sc_hd__fill_1
XFILLER_0_59_225 VGND VGND VPWR VPWR sky130_fd_sc_hd__decap_3
XFILLER_0_35_57 VPWR VGND VPWR VGND sky130_ef_sc_hd__decap_12
XFILLER_0_27_188 VGND VGND VPWR VPWR sky130_fd_sc_hd__decap_3
XscaleAdd._737_ net57 scaleAdd._300_ VGND VGND VPWR VPWR scaleAdd._302_ sky130_fd_sc_hd__nand2_2
XTAP_TAPCELL_ROW_15_264 VGND VPWR sky130_fd_sc_hd__tapvpwrvgnd_1
XFILLER_0_42_147 VGND VGND VPWR VPWR sky130_fd_sc_hd__fill_1
XFILLER_0_30_309 VGND VGND VPWR VPWR sky130_fd_sc_hd__decap_6
XFILLER_0_23_372 VGND VGND VPWR VPWR sky130_fd_sc_hd__fill_2
XscaleAdd._668_ scaleAdd._230_ scaleAdd._241_ VGND VGND VPWR VPWR scaleAdd._242_ sky130_fd_sc_hd__xor2_1
XscaleAdd._599_ scaleAdd._144_ scaleAdd._146_ VGND VGND VPWR VPWR scaleAdd._176_ sky130_fd_sc_hd__nand2_1
XFILLER_0_2_266 VGND VGND VPWR VPWR sky130_fd_sc_hd__decap_8
XFILLER_0_2_233 VGND VGND VPWR VPWR sky130_fd_sc_hd__fill_1
Xaccumulator._1603_ accumulator._0698_ accumulator._0699_ accumulator._0428_ VGND
+ VGND VPWR VPWR accumulator._0700_ sky130_fd_sc_hd__a21oi_1
Xaccumulator._1534_ accumulator._0433_ accumulator._0518_ accumulator._0451_ VGND
+ VGND VPWR VPWR accumulator._0631_ sky130_fd_sc_hd__a21o_1
Xaccumulator._1465_ accumulator._0442_ accumulator._0561_ accumulator._0439_ VGND
+ VGND VPWR VPWR accumulator._0562_ sky130_fd_sc_hd__mux2_1
Xaccumulator._2017_ accumulator._1111_ accumulator._1113_ VGND VGND VPWR VPWR accumulator._1114_
+ sky130_fd_sc_hd__or2_1
XFILLER_0_65_217 VGND VGND VPWR VPWR sky130_fd_sc_hd__decap_6
Xaccumulator._1396_ accumulator._0491_ accumulator._0492_ accumulator._0263_ VGND
+ VGND VPWR VPWR accumulator._0493_ sky130_fd_sc_hd__mux2_1
XFILLER_0_33_169 VGND VGND VPWR VPWR sky130_fd_sc_hd__decap_6
XFILLER_0_33_125 VGND VGND VPWR VPWR sky130_fd_sc_hd__decap_4
XTAP_TAPCELL_ROW_29_367 VGND VPWR sky130_fd_sc_hd__tapvpwrvgnd_1
XFILLER_0_56_239 VGND VGND VPWR VPWR sky130_fd_sc_hd__decap_6
XTAP_TAPCELL_ROW_12_245 VGND VPWR sky130_fd_sc_hd__tapvpwrvgnd_1
XFILLER_0_21_37 VGND VGND VPWR VPWR sky130_fd_sc_hd__decap_4
XFILLER_0_24_158 VGND VGND VPWR VPWR sky130_fd_sc_hd__decap_8
XFILLER_0_12_309 VPWR VGND VPWR VGND sky130_ef_sc_hd__decap_12
XscaleAdd._522_ scaleAdd._056_ scaleAdd._058_ VGND VGND VPWR VPWR scaleAdd._101_ sky130_fd_sc_hd__xnor2_1
XscaleAdd._453_ operator.io_outMant\[2\] net55 scaleAdd._032_ scaleAdd._033_ VGND
+ VGND VPWR VPWR scaleAdd._034_ sky130_fd_sc_hd__nand4_1
XscaleAdd._384_ scaleAdd._325_ scaleAdd._326_ VGND VGND VPWR VPWR scaleAdd._327_ sky130_fd_sc_hd__nand2_1
XFILLER_0_20_331 VGND VGND VPWR VPWR sky130_fd_sc_hd__decap_4
X_24_ accumulator.io_accOut\[24\] VGND VGND VPWR VPWR net38 sky130_fd_sc_hd__clkbuf_1
XTAP_TAPCELL_ROW_63_624 VGND VPWR sky130_fd_sc_hd__tapvpwrvgnd_1
XFILLER_0_47_217 VGND VGND VPWR VPWR sky130_fd_sc_hd__fill_1
Xaccumulator._1250_ accumulator._0339_ accumulator._0105_ VGND VGND VPWR VPWR accumulator._0349_
+ sky130_fd_sc_hd__or2b_1
XPHY_EDGE_ROW_23_Left_94 VGND VGND VPWR VPWR sky130_fd_sc_hd__decap_3
XFILLER_0_70_253 VPWR VGND VPWR VGND sky130_ef_sc_hd__decap_12
XFILLER_0_15_103 VGND VGND VPWR VPWR sky130_fd_sc_hd__decap_3
XFILLER_0_15_125 VGND VGND VPWR VPWR sky130_fd_sc_hd__decap_8
XFILLER_0_15_169 VGND VGND VPWR VPWR sky130_fd_sc_hd__decap_6
XFILLER_0_53_3 VPWR VGND VPWR VGND sky130_ef_sc_hd__decap_12
Xaccumulator._1517_ accumulator._0612_ accumulator._0613_ VGND VGND VPWR VPWR accumulator._0614_
+ sky130_fd_sc_hd__nand2_1
Xaccumulator._1448_ accumulator._0540_ accumulator._0544_ accumulator._0476_ VGND
+ VGND VPWR VPWR accumulator._0545_ sky130_fd_sc_hd__a21o_1
Xaccumulator._1379_ accumulator._0475_ VGND VGND VPWR VPWR accumulator._0476_ sky130_fd_sc_hd__buf_2
Xhold49 accumulator.io_accOut\[14\] VGND VGND VPWR VPWR net106 sky130_fd_sc_hd__dlygate4sd3_1
XTAP_TAPCELL_ROW_26_348 VGND VPWR sky130_fd_sc_hd__tapvpwrvgnd_1
XFILLER_0_61_253 VPWR VGND VPWR VGND sky130_ef_sc_hd__decap_12
Xclkbuf_2_2__f_clock clknet_0_clock VGND VGND VPWR VPWR clknet_2_2__leaf_clock sky130_fd_sc_hd__clkbuf_16
XFILLER_0_69_331 VGND VGND VPWR VPWR sky130_fd_sc_hd__decap_4
XTAP_TAPCELL_ROW_60_605 VGND VPWR sky130_fd_sc_hd__tapvpwrvgnd_1
XFILLER_0_52_264 VGND VGND VPWR VPWR sky130_fd_sc_hd__decap_8
XFILLER_0_52_253 VGND VGND VPWR VPWR sky130_fd_sc_hd__decap_8
XFILLER_0_44_209 VPWR VGND VPWR VGND sky130_ef_sc_hd__decap_12
XFILLER_0_37_272 VGND VGND VPWR VPWR sky130_fd_sc_hd__decap_8
XFILLER_0_57_55 VGND VGND VPWR VPWR sky130_fd_sc_hd__fill_1
Xaccumulator._2420_ clknet_2_1__leaf_clock accumulator._0021_ VGND VGND VPWR VPWR
+ accumulator.io_accOut\[19\] sky130_fd_sc_hd__dfxtp_1
XscaleAdd._367_ operator.io_outMant\[0\] VGND VGND VPWR VPWR scaleAdd._313_ sky130_fd_sc_hd__buf_2
XscaleAdd._505_ net15 net16 VGND VGND VPWR VPWR scaleAdd._084_ sky130_fd_sc_hd__or2_1
XFILLER_0_12_128 VGND VGND VPWR VPWR sky130_fd_sc_hd__fill_1
XscaleAdd._436_ scaleAdd._016_ scaleAdd._003_ VGND VGND VPWR VPWR scaleAdd._017_ sky130_fd_sc_hd__xnor2_2
Xaccumulator._2282_ accumulator._0118_ accumulator._0056_ accumulator._0209_ accumulator._0091_
+ accumulator.io_accOut\[17\] VGND VGND VPWR VPWR accumulator._0217_ sky130_fd_sc_hd__a32o_1
X_07_ accumulator.io_accOut\[7\] VGND VGND VPWR VPWR net51 sky130_fd_sc_hd__clkbuf_1
Xaccumulator._1302_ accumulator._0392_ accumulator.io_accOut\[30\] VGND VGND VPWR
+ VPWR accumulator._0401_ sky130_fd_sc_hd__xor2_2
Xaccumulator._2351_ accumulator._1148_ accumulator._0272_ accumulator._0282_ VGND
+ VGND VPWR VPWR accumulator._0284_ sky130_fd_sc_hd__and3_1
Xaccumulator._1233_ accumulator.io_inMant\[9\] accumulator._0331_ accumulator.io_inMant\[10\]
+ VGND VGND VPWR VPWR accumulator._0332_ sky130_fd_sc_hd__o21ba_1
XFILLER_0_18_6 VGND VGND VPWR VPWR sky130_fd_sc_hd__decap_6
XFILLER_0_16_412 VGND VGND VPWR VPWR sky130_fd_sc_hd__decap_4
Xaccumulator._1997_ accumulator._0922_ accumulator._0876_ VGND VGND VPWR VPWR accumulator._1094_
+ sky130_fd_sc_hd__nand2_1
XFILLER_0_43_297 VGND VGND VPWR VPWR sky130_fd_sc_hd__fill_1
Xoutput28 net28 VGND VGND VPWR VPWR io_accOut[15] sky130_fd_sc_hd__buf_2
XTAP_TAPCELL_ROW_31_384 VGND VPWR sky130_fd_sc_hd__tapvpwrvgnd_1
XFILLER_0_3_361 VPWR VGND VPWR VGND sky130_ef_sc_hd__decap_12
Xoutput39 net39 VGND VGND VPWR VPWR io_accOut[25] sky130_fd_sc_hd__buf_2
XFILLER_0_66_389 VPWR VGND VPWR VGND sky130_ef_sc_hd__decap_12
XFILLER_0_34_253 VGND VGND VPWR VPWR sky130_fd_sc_hd__decap_3
XFILLER_0_34_231 VPWR VGND VPWR VGND sky130_ef_sc_hd__decap_12
XFILLER_0_19_261 VGND VGND VPWR VPWR sky130_fd_sc_hd__decap_6
XFILLER_0_57_312 VGND VGND VPWR VPWR sky130_fd_sc_hd__decap_6
XTAP_TAPCELL_ROW_45_487 VGND VPWR sky130_fd_sc_hd__tapvpwrvgnd_1
XFILLER_0_43_57 VPWR VGND VPWR VGND sky130_ef_sc_hd__decap_12
Xaccumulator._1920_ accumulator._0992_ accumulator._1016_ VGND VGND VPWR VPWR accumulator._1017_
+ sky130_fd_sc_hd__nor2_1
Xaccumulator._1851_ accumulator._0832_ accumulator._0834_ VGND VGND VPWR VPWR accumulator._0948_
+ sky130_fd_sc_hd__nand2_1
XFILLER_0_7_57 VGND VGND VPWR VPWR sky130_fd_sc_hd__decap_8
XFILLER_0_68_65 VPWR VGND VPWR VGND sky130_ef_sc_hd__decap_12
Xaccumulator._1782_ accumulator._0877_ accumulator._0878_ VGND VGND VPWR VPWR accumulator._0879_
+ sky130_fd_sc_hd__xnor2_2
Xaccumulator._2403_ clknet_2_3__leaf_clock accumulator._0004_ VGND VGND VPWR VPWR
+ accumulator.io_accOut\[2\] sky130_fd_sc_hd__dfxtp_1
XscaleAdd._419_ scaleAdd._311_ scaleAdd._327_ scaleAdd._359_ VGND VGND VPWR VPWR scaleAdd._000_
+ sky130_fd_sc_hd__or3_1
Xaccumulator._2196_ accumulator._0118_ accumulator._0127_ accumulator._0130_ accumulator._0131_
+ VGND VGND VPWR VPWR accumulator._0132_ sky130_fd_sc_hd__a211o_1
XTAP_TAPCELL_ROW_36_421 VGND VPWR sky130_fd_sc_hd__tapvpwrvgnd_1
Xaccumulator._2265_ accumulator._0192_ accumulator._0198_ accumulator._0199_ accumulator._0177_
+ VGND VGND VPWR VPWR accumulator._0017_ sky130_fd_sc_hd__o211a_1
Xaccumulator._2334_ accumulator.io_accOut\[24\] accumulator._0406_ VGND VGND VPWR
+ VPWR accumulator._0267_ sky130_fd_sc_hd__or2_1
Xaccumulator._1216_ accumulator.io_inMant\[8\] accumulator.io_inMant\[9\] accumulator._0166_
+ accumulator._0176_ VGND VGND VPWR VPWR accumulator._0185_ sky130_fd_sc_hd__o31a_1
XFILLER_0_63_337 VGND VGND VPWR VPWR sky130_fd_sc_hd__fill_2
XFILLER_0_16_231 VPWR VGND VPWR VGND sky130_ef_sc_hd__decap_12
XFILLER_0_16_253 VGND VGND VPWR VPWR sky130_fd_sc_hd__decap_6
XFILLER_0_31_267 VPWR VGND VPWR VGND sky130_ef_sc_hd__decap_12
XPHY_EDGE_ROW_10_Left_81 VGND VGND VPWR VPWR sky130_fd_sc_hd__decap_3
XFILLER_0_66_153 VGND VGND VPWR VPWR sky130_fd_sc_hd__decap_3
XFILLER_0_66_120 VPWR VGND VPWR VGND sky130_ef_sc_hd__decap_12
XTAP_TAPCELL_ROW_42_468 VGND VPWR sky130_fd_sc_hd__tapvpwrvgnd_1
XFILLER_0_22_201 VGND VGND VPWR VPWR sky130_fd_sc_hd__fill_1
XFILLER_0_1_106 VGND VGND VPWR VPWR sky130_fd_sc_hd__fill_2
Xaccumulator._2050_ accumulator._1138_ accumulator._1146_ VGND VGND VPWR VPWR accumulator._1147_
+ sky130_fd_sc_hd__or2_4
XTAP_TAPCELL_ROW_58_590 VGND VPWR sky130_fd_sc_hd__tapvpwrvgnd_1
XFILLER_0_57_120 VGND VGND VPWR VPWR sky130_fd_sc_hd__fill_1
XTAP_TAPCELL_ROW_33_402 VGND VPWR sky130_fd_sc_hd__tapvpwrvgnd_1
XFILLER_0_57_142 VGND VGND VPWR VPWR sky130_fd_sc_hd__fill_1
XFILLER_0_45_337 VGND VGND VPWR VPWR sky130_fd_sc_hd__decap_8
Xaccumulator._1903_ accumulator._0999_ accumulator._0796_ accumulator._0921_ VGND
+ VGND VPWR VPWR accumulator._1000_ sky130_fd_sc_hd__mux2_1
Xaccumulator._1834_ accumulator._0765_ accumulator._0764_ VGND VGND VPWR VPWR accumulator._0931_
+ sky130_fd_sc_hd__xnor2_4
Xaccumulator._1765_ accumulator.io_accOut\[16\] accumulator._0466_ accumulator._0404_
+ VGND VGND VPWR VPWR accumulator._0862_ sky130_fd_sc_hd__mux2_1
XFILLER_0_13_278 VGND VGND VPWR VPWR sky130_fd_sc_hd__fill_2
Xaccumulator._1696_ accumulator._0791_ accumulator._0792_ VGND VGND VPWR VPWR accumulator._0793_
+ sky130_fd_sc_hd__nor2_1
XFILLER_0_48_175 VGND VGND VPWR VPWR sky130_fd_sc_hd__decap_6
XFILLER_0_48_153 VGND VGND VPWR VPWR sky130_fd_sc_hd__fill_1
XFILLER_0_48_120 VGND VGND VPWR VPWR sky130_fd_sc_hd__fill_1
Xaccumulator._2248_ accumulator._0098_ accumulator._0182_ accumulator._1142_ VGND
+ VGND VPWR VPWR accumulator._0183_ sky130_fd_sc_hd__mux2_1
Xaccumulator._2179_ accumulator._0080_ accumulator._0109_ accumulator._0113_ accumulator._0089_
+ VGND VGND VPWR VPWR accumulator._0114_ sky130_fd_sc_hd__o211a_1
Xaccumulator._2317_ accumulator._0079_ accumulator._0109_ accumulator._0113_ accumulator._0209_
+ VGND VGND VPWR VPWR accumulator._0250_ sky130_fd_sc_hd__o211a_1
XFILLER_0_51_318 VPWR VGND VPWR VGND sky130_ef_sc_hd__decap_12
XFILLER_0_48_197 VGND VGND VPWR VPWR sky130_fd_sc_hd__decap_4
XFILLER_0_8_283 VGND VGND VPWR VPWR sky130_fd_sc_hd__decap_3
XFILLER_0_5_3 VGND VGND VPWR VPWR sky130_fd_sc_hd__decap_8
XTAP_TAPCELL_ROW_47_505 VGND VPWR sky130_fd_sc_hd__tapvpwrvgnd_1
XTAP_TAPCELL_ROW_4_182 VGND VPWR sky130_fd_sc_hd__tapvpwrvgnd_1
XFILLER_0_42_329 VPWR VGND VPWR VGND sky130_ef_sc_hd__decap_12
XFILLER_0_42_307 VGND VGND VPWR VPWR sky130_fd_sc_hd__fill_1
XFILLER_0_27_326 VGND VGND VPWR VPWR sky130_fd_sc_hd__decap_8
XFILLER_0_6_209 VGND VGND VPWR VPWR sky130_fd_sc_hd__decap_3
XscaleAdd._684_ scaleAdd._330_ scaleAdd._216_ scaleAdd._255_ VGND VGND VPWR VPWR scaleAdd._257_
+ sky130_fd_sc_hd__a21oi_1
XFILLER_0_65_55 VGND VGND VPWR VPWR sky130_fd_sc_hd__fill_1
XFILLER_0_49_89 VGND VGND VPWR VPWR sky130_fd_sc_hd__fill_2
Xaccumulator._1550_ accumulator._0469_ accumulator._0645_ accumulator._0646_ VGND
+ VGND VPWR VPWR accumulator._0647_ sky130_fd_sc_hd__o21ai_1
Xaccumulator._1481_ accumulator._0433_ accumulator._0577_ accumulator._0451_ VGND
+ VGND VPWR VPWR accumulator._0578_ sky130_fd_sc_hd__a21o_1
XFILLER_0_4_58 VPWR VGND VPWR VGND sky130_ef_sc_hd__decap_12
Xaccumulator._2033_ accumulator._1118_ accumulator._1129_ VGND VGND VPWR VPWR accumulator._1130_
+ sky130_fd_sc_hd__xnor2_1
Xaccumulator._2102_ net70 VGND VGND VPWR VPWR accumulator._0036_ sky130_fd_sc_hd__clkbuf_4
XFILLER_0_14_81 VGND VGND VPWR VPWR sky130_fd_sc_hd__decap_3
XTAP_TAPCELL_ROW_18_284 VGND VPWR sky130_fd_sc_hd__tapvpwrvgnd_1
XFILLER_0_60_137 VGND VGND VPWR VPWR sky130_fd_sc_hd__decap_3
XFILLER_0_45_167 VGND VGND VPWR VPWR sky130_fd_sc_hd__fill_1
XFILLER_0_33_307 VGND VGND VPWR VPWR sky130_fd_sc_hd__fill_1
XFILLER_0_26_370 VGND VGND VPWR VPWR sky130_fd_sc_hd__decap_8
XFILLER_0_5_297 VPWR VGND VPWR VGND sky130_ef_sc_hd__decap_12
Xaccumulator._1748_ accumulator._0809_ accumulator._0838_ accumulator._0843_ accumulator._0844_
+ VGND VGND VPWR VPWR accumulator._0845_ sky130_fd_sc_hd__a2bb2o_2
Xaccumulator._1817_ accumulator._0740_ accumulator._0852_ accumulator._0787_ accumulator._0910_
+ VGND VGND VPWR VPWR accumulator._0914_ sky130_fd_sc_hd__o31a_1
XFILLER_0_41_362 VGND VGND VPWR VPWR sky130_fd_sc_hd__fill_1
XFILLER_0_68_226 VGND VGND VPWR VPWR sky130_fd_sc_hd__decap_3
Xaccumulator._1679_ accumulator.io_accOut\[3\] accumulator._0395_ accumulator._0775_
+ VGND VGND VPWR VPWR accumulator._0776_ sky130_fd_sc_hd__and3_1
XTAP_TAPCELL_ROW_1_163 VGND VPWR sky130_fd_sc_hd__tapvpwrvgnd_1
XFILLER_0_68_248 VGND VGND VPWR VPWR sky130_fd_sc_hd__decap_4
XTAP_TAPCELL_ROW_52_541 VGND VPWR sky130_fd_sc_hd__tapvpwrvgnd_1
XFILLER_0_36_101 VGND VGND VPWR VPWR sky130_fd_sc_hd__decap_8
XFILLER_0_51_126 VGND VGND VPWR VPWR sky130_fd_sc_hd__decap_6
XFILLER_0_10_17 VGND VGND VPWR VPWR sky130_fd_sc_hd__decap_8
XFILLER_0_35_69 VPWR VGND VPWR VGND sky130_ef_sc_hd__decap_12
XFILLER_0_67_281 VGND VGND VPWR VPWR sky130_fd_sc_hd__decap_4
XFILLER_0_51_57 VPWR VGND VPWR VGND sky130_ef_sc_hd__decap_12
XFILLER_0_27_167 VGND VGND VPWR VPWR sky130_fd_sc_hd__fill_1
XFILLER_0_27_123 VGND VGND VPWR VPWR sky130_fd_sc_hd__fill_1
XscaleAdd._736_ net56 scaleAdd._300_ VGND VGND VPWR VPWR scaleAdd._301_ sky130_fd_sc_hd__or2_1
XTAP_TAPCELL_ROW_15_265 VGND VPWR sky130_fd_sc_hd__tapvpwrvgnd_1
Xaccumulator._1602_ accumulator._0621_ accumulator._0622_ accumulator._0498_ VGND
+ VGND VPWR VPWR accumulator._0699_ sky130_fd_sc_hd__a21o_1
XscaleAdd._667_ scaleAdd._239_ scaleAdd._240_ VGND VGND VPWR VPWR scaleAdd._241_ sky130_fd_sc_hd__nand2_1
XscaleAdd._598_ scaleAdd._174_ scaleAdd._153_ VGND VGND VPWR VPWR scaleAdd._175_ sky130_fd_sc_hd__xor2_1
XTAP_TAPCELL_ROW_66_644 VGND VPWR sky130_fd_sc_hd__tapvpwrvgnd_1
Xaccumulator._1533_ accumulator._0628_ accumulator._0629_ accumulator._0476_ VGND
+ VGND VPWR VPWR accumulator._0630_ sky130_fd_sc_hd__a21o_1
Xaccumulator._1395_ accumulator._0460_ accumulator._0462_ accumulator._0215_ VGND
+ VGND VPWR VPWR accumulator._0492_ sky130_fd_sc_hd__mux2_1
Xaccumulator._1464_ accumulator.io_inMant\[12\] accumulator.io_inMant\[13\] accumulator._0436_
+ VGND VGND VPWR VPWR accumulator._0561_ sky130_fd_sc_hd__mux2_1
Xaccumulator._2016_ accumulator._1108_ accumulator._1112_ VGND VGND VPWR VPWR accumulator._1113_
+ sky130_fd_sc_hd__xor2_2
XFILLER_0_41_181 VPWR VGND VPWR VGND sky130_ef_sc_hd__decap_12
XFILLER_0_14_351 VGND VGND VPWR VPWR sky130_fd_sc_hd__decap_6
XTAP_TAPCELL_ROW_6_200 VGND VPWR sky130_fd_sc_hd__tapvpwrvgnd_1
XFILLER_0_56_207 VGND VGND VPWR VPWR sky130_fd_sc_hd__decap_4
XTAP_TAPCELL_ROW_29_368 VGND VPWR sky130_fd_sc_hd__tapvpwrvgnd_1
XFILLER_0_49_281 VGND VGND VPWR VPWR sky130_fd_sc_hd__fill_1
XscaleAdd._521_ scaleAdd._044_ scaleAdd._020_ VGND VGND VPWR VPWR scaleAdd._100_ sky130_fd_sc_hd__nor2_1
XTAP_TAPCELL_ROW_12_246 VGND VPWR sky130_fd_sc_hd__tapvpwrvgnd_1
XFILLER_0_21_27 VGND VGND VPWR VPWR sky130_fd_sc_hd__decap_3
XscaleAdd._452_ scaleAdd._028_ scaleAdd._029_ scaleAdd._031_ VGND VGND VPWR VPWR scaleAdd._033_
+ sky130_fd_sc_hd__a21o_1
XscaleAdd._383_ scaleAdd._313_ net55 scaleAdd._324_ VGND VGND VPWR VPWR scaleAdd._326_
+ sky130_fd_sc_hd__a21o_1
XFILLER_0_20_365 VGND VGND VPWR VPWR sky130_fd_sc_hd__fill_2
X_23_ accumulator.io_accOut\[23\] VGND VGND VPWR VPWR net37 sky130_fd_sc_hd__buf_1
XFILLER_0_1_15 VPWR VGND VPWR VGND sky130_ef_sc_hd__decap_12
XTAP_TAPCELL_ROW_63_625 VGND VPWR sky130_fd_sc_hd__tapvpwrvgnd_1
XFILLER_0_47_229 VGND VGND VPWR VPWR sky130_fd_sc_hd__fill_1
XFILLER_0_7_337 VPWR VGND VPWR VGND sky130_ef_sc_hd__decap_12
XFILLER_0_70_265 VPWR VGND VPWR VGND sky130_ef_sc_hd__decap_12
XFILLER_0_70_221 VGND VGND VPWR VPWR sky130_fd_sc_hd__decap_3
XFILLER_0_55_273 VGND VGND VPWR VPWR sky130_fd_sc_hd__decap_6
XFILLER_0_43_413 VGND VGND VPWR VPWR sky130_fd_sc_hd__decap_4
XscaleAdd._719_ net16 net18 VGND VGND VPWR VPWR scaleAdd._286_ sky130_fd_sc_hd__or2_1
XFILLER_0_11_71 VPWR VGND VPWR VGND sky130_ef_sc_hd__decap_12
XFILLER_0_46_3 VPWR VGND VPWR VGND sky130_ef_sc_hd__decap_12
Xaccumulator._1516_ accumulator._0433_ accumulator._0450_ accumulator._0543_ VGND
+ VGND VPWR VPWR accumulator._0613_ sky130_fd_sc_hd__a21o_1
Xaccumulator._1447_ accumulator._0433_ accumulator._0542_ accumulator._0543_ VGND
+ VGND VPWR VPWR accumulator._0544_ sky130_fd_sc_hd__a21o_1
Xaccumulator._1378_ accumulator._0474_ VGND VGND VPWR VPWR accumulator._0475_ sky130_fd_sc_hd__buf_2
XTAP_TAPCELL_ROW_26_349 VGND VPWR sky130_fd_sc_hd__tapvpwrvgnd_1
XFILLER_0_61_210 VPWR VGND VPWR VGND sky130_ef_sc_hd__decap_12
XFILLER_0_46_251 VGND VGND VPWR VPWR sky130_fd_sc_hd__fill_1
XFILLER_0_61_265 VPWR VGND VPWR VGND sky130_ef_sc_hd__decap_12
XTAP_TAPCELL_ROW_60_606 VGND VPWR sky130_fd_sc_hd__tapvpwrvgnd_1
XFILLER_0_32_26 VGND VGND VPWR VPWR sky130_fd_sc_hd__fill_2
XFILLER_0_29_218 VGND VGND VPWR VPWR sky130_fd_sc_hd__decap_6
XFILLER_0_40_405 VGND VGND VPWR VPWR sky130_fd_sc_hd__fill_1
XFILLER_0_25_402 VGND VGND VPWR VPWR sky130_fd_sc_hd__fill_2
XFILLER_0_4_307 VGND VGND VPWR VPWR sky130_fd_sc_hd__fill_1
XscaleAdd._504_ scaleAdd._319_ scaleAdd._337_ scaleAdd._338_ VGND VGND VPWR VPWR scaleAdd._083_
+ sky130_fd_sc_hd__and3_1
XPHY_EDGE_ROW_29_Left_100 VGND VGND VPWR VPWR sky130_fd_sc_hd__decap_3
XscaleAdd._366_ operator.io_outMant\[3\] VGND VGND VPWR VPWR scaleAdd._312_ sky130_fd_sc_hd__buf_2
XscaleAdd._435_ scaleAdd._013_ scaleAdd._015_ VGND VGND VPWR VPWR scaleAdd._016_ sky130_fd_sc_hd__xor2_1
XFILLER_0_20_195 VGND VGND VPWR VPWR sky130_fd_sc_hd__fill_1
Xaccumulator._2281_ accumulator._0213_ accumulator._0214_ accumulator._0089_ VGND
+ VGND VPWR VPWR accumulator._0216_ sky130_fd_sc_hd__o21a_1
X_06_ accumulator.io_accOut\[6\] VGND VGND VPWR VPWR net50 sky130_fd_sc_hd__buf_1
Xaccumulator._1301_ accumulator._0399_ VGND VGND VPWR VPWR accumulator._0400_ sky130_fd_sc_hd__buf_2
Xaccumulator._2350_ accumulator._0079_ accumulator._0281_ VGND VGND VPWR VPWR accumulator._0282_
+ sky130_fd_sc_hd__xnor2_1
Xaccumulator._1232_ accumulator.io_inMant\[7\] accumulator._0330_ accumulator.io_inMant\[8\]
+ VGND VGND VPWR VPWR accumulator._0331_ sky130_fd_sc_hd__o21ba_1
XTAP_TAPCELL_ROW_31_385 VGND VPWR sky130_fd_sc_hd__tapvpwrvgnd_1
XFILLER_0_28_251 VGND VGND VPWR VPWR sky130_fd_sc_hd__fill_1
Xaccumulator._1996_ accumulator._0864_ accumulator._0952_ VGND VGND VPWR VPWR accumulator._1093_
+ sky130_fd_sc_hd__nor2_1
Xoutput29 net29 VGND VGND VPWR VPWR io_accOut[16] sky130_fd_sc_hd__buf_2
XFILLER_0_3_373 VPWR VGND VPWR VGND sky130_ef_sc_hd__decap_12
XFILLER_0_11_151 VPWR VGND VPWR VGND sky130_ef_sc_hd__decap_12
XFILLER_0_34_243 VGND VGND VPWR VPWR sky130_fd_sc_hd__decap_8
XFILLER_0_69_140 VGND VGND VPWR VPWR sky130_fd_sc_hd__decap_3
XFILLER_0_69_184 VGND VGND VPWR VPWR sky130_fd_sc_hd__fill_1
XFILLER_0_65_390 VGND VGND VPWR VPWR sky130_fd_sc_hd__fill_2
XFILLER_0_57_335 VGND VGND VPWR VPWR sky130_fd_sc_hd__fill_1
XTAP_TAPCELL_ROW_45_488 VGND VPWR sky130_fd_sc_hd__tapvpwrvgnd_1
XFILLER_0_43_69 VPWR VGND VPWR VGND sky130_ef_sc_hd__decap_12
XFILLER_0_68_77 VGND VGND VPWR VPWR sky130_fd_sc_hd__decap_6
Xaccumulator._1850_ accumulator._0869_ accumulator._0946_ accumulator._0870_ VGND
+ VGND VPWR VPWR accumulator._0947_ sky130_fd_sc_hd__o21ba_1
Xaccumulator._1781_ accumulator.io_accOut\[18\] accumulator._0569_ accumulator._0404_
+ VGND VGND VPWR VPWR accumulator._0878_ sky130_fd_sc_hd__mux2_2
XFILLER_0_4_148 VGND VGND VPWR VPWR sky130_fd_sc_hd__decap_8
XFILLER_0_0_321 VPWR VGND VPWR VGND sky130_ef_sc_hd__decap_12
XFILLER_0_13_405 VPWR VGND VPWR VGND sky130_ef_sc_hd__decap_12
Xaccumulator._2402_ clknet_2_2__leaf_clock accumulator._0003_ VGND VGND VPWR VPWR
+ accumulator.io_accOut\[1\] sky130_fd_sc_hd__dfxtp_1
Xaccumulator._2333_ accumulator._0260_ accumulator._0265_ VGND VGND VPWR VPWR accumulator._0266_
+ sky130_fd_sc_hd__xnor2_1
XFILLER_0_0_365 VPWR VGND VPWR VGND sky130_ef_sc_hd__decap_12
XscaleAdd._418_ scaleAdd._328_ scaleAdd._359_ VGND VGND VPWR VPWR accumulator.io_inMant\[5\]
+ sky130_fd_sc_hd__xnor2_2
Xaccumulator._2195_ accumulator._0396_ accumulator._0041_ VGND VGND VPWR VPWR accumulator._0131_
+ sky130_fd_sc_hd__or2_1
XTAP_TAPCELL_ROW_36_422 VGND VPWR sky130_fd_sc_hd__tapvpwrvgnd_1
Xaccumulator._2264_ accumulator.io_accOut\[15\] accumulator._0406_ VGND VGND VPWR
+ VPWR accumulator._0199_ sky130_fd_sc_hd__or2_1
XPHY_EDGE_ROW_5_Right_5 VGND VGND VPWR VPWR sky130_fd_sc_hd__decap_3
Xaccumulator._1215_ accumulator.io_inMant\[10\] accumulator.io_inMant\[11\] VGND VGND
+ VPWR VPWR accumulator._0176_ sky130_fd_sc_hd__nor2_1
XFILLER_0_17_81 VGND VGND VPWR VPWR sky130_fd_sc_hd__decap_3
XFILLER_0_16_243 VGND VGND VPWR VPWR sky130_fd_sc_hd__decap_8
Xaccumulator._1979_ accumulator._0866_ accumulator._1075_ VGND VGND VPWR VPWR accumulator._1076_
+ sky130_fd_sc_hd__xnor2_2
XFILLER_0_31_279 VGND VGND VPWR VPWR sky130_fd_sc_hd__fill_1
XFILLER_0_66_132 VGND VGND VPWR VPWR sky130_fd_sc_hd__decap_8
XFILLER_0_54_349 VGND VGND VPWR VPWR sky130_fd_sc_hd__decap_6
XTAP_TAPCELL_ROW_42_469 VGND VPWR sky130_fd_sc_hd__tapvpwrvgnd_1
XTAP_TAPCELL_ROW_58_591 VGND VPWR sky130_fd_sc_hd__tapvpwrvgnd_1
XFILLER_0_57_110 VGND VGND VPWR VPWR sky130_fd_sc_hd__fill_2
XTAP_TAPCELL_ROW_33_403 VGND VPWR sky130_fd_sc_hd__tapvpwrvgnd_1
Xaccumulator._1902_ accumulator._0794_ accumulator._0936_ VGND VGND VPWR VPWR accumulator._0999_
+ sky130_fd_sc_hd__nand2_1
Xaccumulator._1764_ accumulator._0845_ accumulator._0858_ accumulator._0860_ accumulator._0850_
+ VGND VGND VPWR VPWR accumulator._0861_ sky130_fd_sc_hd__a211oi_2
Xaccumulator._1833_ accumulator._0752_ accumulator._0753_ VGND VGND VPWR VPWR accumulator._0930_
+ sky130_fd_sc_hd__or2b_1
Xaccumulator._1695_ accumulator.io_accOut\[5\] accumulator._0395_ VGND VGND VPWR VPWR
+ accumulator._0792_ sky130_fd_sc_hd__nand2_1
XFILLER_0_68_419 VGND VGND VPWR VPWR sky130_fd_sc_hd__fill_1
Xaccumulator._2316_ accumulator.io_accOut\[21\] accumulator._0167_ accumulator._0400_
+ accumulator._0245_ accumulator._0249_ VGND VGND VPWR VPWR accumulator._0023_ sky130_fd_sc_hd__o2111a_1
XFILLER_0_63_146 VPWR VGND VPWR VGND sky130_ef_sc_hd__decap_12
XFILLER_0_63_113 VGND VGND VPWR VPWR sky130_fd_sc_hd__fill_2
Xaccumulator._2247_ accumulator._0179_ accumulator._0181_ accumulator._0110_ VGND
+ VGND VPWR VPWR accumulator._0182_ sky130_fd_sc_hd__mux2_2
Xaccumulator._2178_ accumulator._0110_ accumulator._0112_ accumulator._1141_ VGND
+ VGND VPWR VPWR accumulator._0113_ sky130_fd_sc_hd__a21o_1
XFILLER_0_51_308 VGND VGND VPWR VPWR sky130_fd_sc_hd__fill_1
XTAP_TAPCELL_ROW_47_506 VGND VPWR sky130_fd_sc_hd__tapvpwrvgnd_1
XFILLER_0_24_27 VGND VGND VPWR VPWR sky130_fd_sc_hd__fill_1
XTAP_TAPCELL_ROW_4_183 VGND VPWR sky130_fd_sc_hd__tapvpwrvgnd_1
XFILLER_0_54_168 VGND VGND VPWR VPWR sky130_fd_sc_hd__decap_6
XFILLER_0_40_15 VPWR VGND VPWR VGND sky130_ef_sc_hd__decap_12
XscaleAdd._683_ scaleAdd._330_ scaleAdd._216_ scaleAdd._255_ VGND VGND VPWR VPWR scaleAdd._256_
+ sky130_fd_sc_hd__and3_1
XFILLER_0_49_79 VGND VGND VPWR VPWR sky130_fd_sc_hd__decap_6
XFILLER_0_49_57 VGND VGND VPWR VPWR sky130_fd_sc_hd__decap_4
Xaccumulator._1480_ accumulator.io_accOut\[21\] accumulator._0576_ accumulator._0393_
+ VGND VGND VPWR VPWR accumulator._0577_ sky130_fd_sc_hd__mux2_1
Xaccumulator._2032_ accumulator._1054_ accumulator._1128_ VGND VGND VPWR VPWR accumulator._1129_
+ sky130_fd_sc_hd__nor2_1
Xaccumulator._2101_ accumulator._1196_ VGND VGND VPWR VPWR accumulator._0035_ sky130_fd_sc_hd__clkbuf_4
XFILLER_0_45_113 VGND VGND VPWR VPWR sky130_fd_sc_hd__decap_4
XTAP_TAPCELL_ROW_18_285 VGND VPWR sky130_fd_sc_hd__tapvpwrvgnd_1
XFILLER_0_18_305 VGND VGND VPWR VPWR sky130_fd_sc_hd__decap_3
XFILLER_0_41_374 VGND VGND VPWR VPWR sky130_fd_sc_hd__fill_1
Xaccumulator._1816_ accumulator._0911_ accumulator._0912_ VGND VGND VPWR VPWR accumulator._0913_
+ sky130_fd_sc_hd__nand2_2
Xaccumulator._1747_ accumulator._0836_ VGND VGND VPWR VPWR accumulator._0844_ sky130_fd_sc_hd__inv_2
Xaccumulator._1678_ accumulator._0651_ accumulator._0769_ accumulator._0771_ accumulator._0620_
+ accumulator._0774_ VGND VGND VPWR VPWR accumulator._0775_ sky130_fd_sc_hd__o32a_1
XFILLER_0_41_396 VPWR VGND VPWR VGND sky130_ef_sc_hd__decap_12
XTAP_TAPCELL_ROW_52_542 VGND VPWR sky130_fd_sc_hd__tapvpwrvgnd_1
XFILLER_0_51_105 VGND VGND VPWR VPWR sky130_fd_sc_hd__decap_6
XTAP_TAPCELL_ROW_9_220 VGND VPWR sky130_fd_sc_hd__tapvpwrvgnd_1
XFILLER_0_10_29 VPWR VGND VPWR VGND sky130_ef_sc_hd__decap_12
XFILLER_0_35_15 VPWR VGND VPWR VGND sky130_ef_sc_hd__decap_12
XFILLER_0_67_293 VPWR VGND VPWR VGND sky130_ef_sc_hd__decap_12
XFILLER_0_51_69 VPWR VGND VPWR VGND sky130_ef_sc_hd__decap_12
XFILLER_0_27_135 VPWR VGND VPWR VGND sky130_ef_sc_hd__decap_12
XTAP_TAPCELL_ROW_15_266 VGND VPWR sky130_fd_sc_hd__tapvpwrvgnd_1
XFILLER_0_42_105 VPWR VGND VPWR VGND sky130_ef_sc_hd__decap_12
XscaleAdd._735_ scaleAdd._281_ scaleAdd._286_ VGND VGND VPWR VPWR scaleAdd._300_ sky130_fd_sc_hd__nor2_1
XscaleAdd._666_ scaleAdd._231_ scaleAdd._232_ scaleAdd._238_ VGND VGND VPWR VPWR scaleAdd._240_
+ sky130_fd_sc_hd__or3b_1
Xaccumulator._1601_ accumulator._0612_ accumulator._0613_ accumulator._0476_ VGND
+ VGND VPWR VPWR accumulator._0698_ sky130_fd_sc_hd__a21o_1
Xaccumulator._1532_ accumulator._0433_ accumulator._0514_ accumulator._0543_ VGND
+ VGND VPWR VPWR accumulator._0629_ sky130_fd_sc_hd__a21o_1
XscaleAdd._597_ scaleAdd._172_ scaleAdd._173_ VGND VGND VPWR VPWR scaleAdd._174_ sky130_fd_sc_hd__xor2_1
XTAP_TAPCELL_ROW_66_645 VGND VPWR sky130_fd_sc_hd__tapvpwrvgnd_1
Xaccumulator._1463_ accumulator._0434_ accumulator._0481_ VGND VGND VPWR VPWR accumulator._0560_
+ sky130_fd_sc_hd__or2_1
Xaccumulator._1394_ accumulator._0454_ accumulator._0459_ accumulator._0215_ VGND
+ VGND VPWR VPWR accumulator._0491_ sky130_fd_sc_hd__mux2_1
Xaccumulator._2015_ accumulator._1092_ accumulator._1097_ accumulator._0992_ VGND
+ VGND VPWR VPWR accumulator._1112_ sky130_fd_sc_hd__a21o_1
XFILLER_0_18_179 VGND VGND VPWR VPWR sky130_fd_sc_hd__decap_8
XFILLER_0_41_193 VPWR VGND VPWR VGND sky130_ef_sc_hd__decap_12
XTAP_TAPCELL_ROW_6_201 VGND VPWR sky130_fd_sc_hd__tapvpwrvgnd_1
XFILLER_0_5_91 VPWR VGND VPWR VGND sky130_ef_sc_hd__decap_12
XTAP_TAPCELL_ROW_29_369 VGND VPWR sky130_fd_sc_hd__tapvpwrvgnd_1
XFILLER_0_24_138 VGND VGND VPWR VPWR sky130_fd_sc_hd__fill_2
XscaleAdd._520_ scaleAdd._080_ scaleAdd._098_ VGND VGND VPWR VPWR scaleAdd._099_ sky130_fd_sc_hd__xnor2_2
XscaleAdd._451_ scaleAdd._028_ scaleAdd._029_ scaleAdd._031_ VGND VGND VPWR VPWR scaleAdd._032_
+ sky130_fd_sc_hd__nand3_1
XscaleAdd._382_ operator.io_outMant\[0\] net55 scaleAdd._324_ VGND VGND VPWR VPWR
+ scaleAdd._325_ sky130_fd_sc_hd__nand3_1
XFILLER_0_20_377 VPWR VGND VPWR VGND sky130_ef_sc_hd__decap_12
XTAP_TAPCELL_ROW_63_626 VGND VPWR sky130_fd_sc_hd__tapvpwrvgnd_1
X_22_ accumulator.io_accOut\[22\] VGND VGND VPWR VPWR net36 sky130_fd_sc_hd__buf_1
XFILLER_0_1_27 VPWR VGND VPWR VGND sky130_ef_sc_hd__decap_12
XFILLER_0_28_411 VGND VGND VPWR VPWR sky130_fd_sc_hd__decap_8
XFILLER_0_7_316 VPWR VGND VPWR VGND sky130_ef_sc_hd__decap_12
XFILLER_0_7_349 VPWR VGND VPWR VGND sky130_ef_sc_hd__decap_12
XFILLER_0_70_277 VGND VGND VPWR VPWR sky130_fd_sc_hd__decap_3
XscaleAdd._649_ scaleAdd._199_ scaleAdd._201_ VGND VGND VPWR VPWR scaleAdd._224_ sky130_fd_sc_hd__or2_1
XFILLER_0_11_61 VGND VGND VPWR VPWR sky130_fd_sc_hd__fill_1
XFILLER_0_11_83 VPWR VGND VPWR VGND sky130_ef_sc_hd__decap_12
XFILLER_0_15_149 VPWR VGND VPWR VGND sky130_ef_sc_hd__decap_12
XscaleAdd._718_ scaleAdd._285_ VGND VGND VPWR VPWR accumulator.io_inExp\[0\] sky130_fd_sc_hd__buf_1
Xaccumulator._1515_ accumulator._0536_ accumulator._0570_ accumulator._0539_ VGND
+ VGND VPWR VPWR accumulator._0612_ sky130_fd_sc_hd__a21o_1
XFILLER_0_39_3 VPWR VGND VPWR VGND sky130_ef_sc_hd__decap_12
Xaccumulator._1377_ accumulator._0472_ accumulator._0473_ VGND VGND VPWR VPWR accumulator._0474_
+ sky130_fd_sc_hd__or2_1
Xaccumulator._1446_ accumulator._0468_ VGND VGND VPWR VPWR accumulator._0543_ sky130_fd_sc_hd__buf_2
XFILLER_0_61_277 VGND VGND VPWR VPWR sky130_fd_sc_hd__decap_3
XFILLER_0_61_233 VGND VGND VPWR VPWR sky130_fd_sc_hd__fill_1
XFILLER_0_61_222 VGND VGND VPWR VPWR sky130_fd_sc_hd__fill_2
XFILLER_0_46_285 VPWR VGND VPWR VGND sky130_ef_sc_hd__decap_12
XFILLER_0_46_263 VGND VGND VPWR VPWR sky130_fd_sc_hd__fill_2
XFILLER_0_52_200 VPWR VGND VPWR VGND sky130_ef_sc_hd__decap_12
XFILLER_0_37_252 VPWR VGND VPWR VGND sky130_ef_sc_hd__decap_12
XFILLER_0_40_417 VGND VGND VPWR VPWR sky130_fd_sc_hd__decap_3
XscaleAdd._503_ scaleAdd._051_ scaleAdd._053_ scaleAdd._081_ VGND VGND VPWR VPWR scaleAdd._082_
+ sky130_fd_sc_hd__a21o_1
XscaleAdd._434_ scaleAdd._316_ scaleAdd._014_ scaleAdd._333_ VGND VGND VPWR VPWR scaleAdd._015_
+ sky130_fd_sc_hd__or3b_1
Xaccumulator._1300_ net19 net21 VGND VGND VPWR VPWR accumulator._0399_ sky130_fd_sc_hd__nor2_1
XscaleAdd._365_ operator.io_outMant\[0\] scaleAdd._310_ VGND VGND VPWR VPWR scaleAdd._311_
+ sky130_fd_sc_hd__nand2_1
XFILLER_0_20_174 VGND VGND VPWR VPWR sky130_fd_sc_hd__fill_2
XFILLER_0_20_185 VGND VGND VPWR VPWR sky130_fd_sc_hd__fill_1
X_05_ accumulator.io_accOut\[5\] VGND VGND VPWR VPWR net49 sky130_fd_sc_hd__buf_1
Xaccumulator._2280_ accumulator._0086_ accumulator._0142_ accumulator._0145_ accumulator._1142_
+ VGND VGND VPWR VPWR accumulator._0214_ sky130_fd_sc_hd__a211oi_1
Xaccumulator._1231_ accumulator.io_inMant\[5\] accumulator._0323_ accumulator.io_inMant\[6\]
+ VGND VGND VPWR VPWR accumulator._0330_ sky130_fd_sc_hd__o21ba_1
XFILLER_0_43_277 VGND VGND VPWR VPWR sky130_fd_sc_hd__decap_3
XTAP_TAPCELL_ROW_31_386 VGND VPWR sky130_fd_sc_hd__tapvpwrvgnd_1
XFILLER_0_28_230 VGND VGND VPWR VPWR sky130_fd_sc_hd__decap_4
Xaccumulator._1995_ accumulator._0879_ accumulator._1091_ VGND VGND VPWR VPWR accumulator._1092_
+ sky130_fd_sc_hd__xnor2_2
XFILLER_0_3_385 VGND VGND VPWR VPWR sky130_fd_sc_hd__decap_6
XFILLER_0_11_130 VGND VGND VPWR VPWR sky130_fd_sc_hd__decap_8
XFILLER_0_11_163 VGND VGND VPWR VPWR sky130_fd_sc_hd__decap_4
Xaccumulator._1429_ accumulator._0475_ VGND VGND VPWR VPWR accumulator._0526_ sky130_fd_sc_hd__buf_2
XTAP_TAPCELL_ROW_39_442 VGND VPWR sky130_fd_sc_hd__tapvpwrvgnd_1
XTAP_TAPCELL_ROW_22_320 VGND VPWR sky130_fd_sc_hd__tapvpwrvgnd_1
XFILLER_0_34_277 VGND VGND VPWR VPWR sky130_fd_sc_hd__decap_8
XFILLER_0_43_15 VPWR VGND VPWR VGND sky130_ef_sc_hd__decap_12
XTAP_TAPCELL_ROW_45_489 VGND VPWR sky130_fd_sc_hd__tapvpwrvgnd_1
XFILLER_0_4_105 VGND VGND VPWR VPWR sky130_fd_sc_hd__fill_2
XFILLER_0_13_417 VGND VGND VPWR VPWR sky130_fd_sc_hd__decap_4
Xaccumulator._1780_ accumulator._0733_ accumulator._0601_ VGND VGND VPWR VPWR accumulator._0877_
+ sky130_fd_sc_hd__nand2_1
XFILLER_0_0_377 VPWR VGND VPWR VGND sky130_ef_sc_hd__decap_12
XFILLER_0_0_333 VGND VGND VPWR VPWR sky130_fd_sc_hd__decap_3
XscaleAdd._417_ scaleAdd._357_ scaleAdd._358_ VGND VGND VPWR VPWR scaleAdd._359_ sky130_fd_sc_hd__or2_1
Xaccumulator._2263_ accumulator._0118_ accumulator._0127_ accumulator._0196_ accumulator._0197_
+ VGND VGND VPWR VPWR accumulator._0198_ sky130_fd_sc_hd__o22ai_1
Xaccumulator._2401_ clknet_2_2__leaf_clock accumulator._0002_ VGND VGND VPWR VPWR
+ accumulator.io_accOut\[0\] sky130_fd_sc_hd__dfxtp_1
Xaccumulator._2332_ accumulator._1196_ accumulator._0264_ VGND VGND VPWR VPWR accumulator._0265_
+ sky130_fd_sc_hd__xnor2_1
XFILLER_0_63_328 VGND VGND VPWR VPWR sky130_fd_sc_hd__decap_8
XFILLER_0_63_306 VGND VGND VPWR VPWR sky130_fd_sc_hd__decap_3
Xaccumulator._2194_ accumulator._0128_ accumulator._0129_ accumulator._0118_ VGND
+ VGND VPWR VPWR accumulator._0130_ sky130_fd_sc_hd__a21oi_1
XTAP_TAPCELL_ROW_36_423 VGND VPWR sky130_fd_sc_hd__tapvpwrvgnd_1
XFILLER_0_33_81 VGND VGND VPWR VPWR sky130_fd_sc_hd__decap_4
Xaccumulator._1214_ accumulator.io_inMant\[4\] accumulator.io_inMant\[5\] accumulator._0146_
+ accumulator._0156_ VGND VGND VPWR VPWR accumulator._0166_ sky130_fd_sc_hd__o31a_1
XFILLER_0_16_266 VGND VGND VPWR VPWR sky130_fd_sc_hd__decap_3
Xaccumulator._1978_ accumulator._0919_ accumulator._0952_ accumulator._1060_ accumulator._0871_
+ accumulator._1074_ VGND VGND VPWR VPWR accumulator._1075_ sky130_fd_sc_hd__a221o_1
XPHY_EDGE_ROW_48_Left_119 VGND VGND VPWR VPWR sky130_fd_sc_hd__decap_3
XFILLER_0_39_325 VGND VGND VPWR VPWR sky130_fd_sc_hd__decap_8
XFILLER_0_66_177 VGND VGND VPWR VPWR sky130_fd_sc_hd__fill_1
XPHY_EDGE_ROW_57_Left_128 VGND VGND VPWR VPWR sky130_fd_sc_hd__decap_3
XFILLER_0_54_306 VGND VGND VPWR VPWR sky130_fd_sc_hd__fill_2
XFILLER_0_47_391 VGND VGND VPWR VPWR sky130_fd_sc_hd__fill_1
XPHY_EDGE_ROW_11_Right_11 VGND VGND VPWR VPWR sky130_fd_sc_hd__decap_3
XFILLER_0_62_394 VGND VGND VPWR VPWR sky130_fd_sc_hd__decap_6
XFILLER_0_38_15 VPWR VGND VPWR VGND sky130_ef_sc_hd__decap_12
XPHY_EDGE_ROW_20_Right_20 VGND VGND VPWR VPWR sky130_fd_sc_hd__decap_3
XPHY_EDGE_ROW_66_Left_137 VGND VGND VPWR VPWR sky130_fd_sc_hd__decap_3
XFILLER_0_70_57 VPWR VGND VPWR VGND sky130_ef_sc_hd__decap_12
XFILLER_0_54_69 VGND VGND VPWR VPWR sky130_fd_sc_hd__decap_6
Xaccumulator._1901_ accumulator._0981_ accumulator._0997_ VGND VGND VPWR VPWR accumulator._0998_
+ sky130_fd_sc_hd__nand2_1
XFILLER_0_57_199 VGND VGND VPWR VPWR sky130_fd_sc_hd__fill_1
Xaccumulator._1832_ accumulator._0802_ accumulator._0803_ VGND VGND VPWR VPWR accumulator._0929_
+ sky130_fd_sc_hd__or2_1
XFILLER_0_13_225 VGND VGND VPWR VPWR sky130_fd_sc_hd__decap_6
Xaccumulator._1763_ accumulator._0849_ accumulator._0859_ VGND VGND VPWR VPWR accumulator._0860_
+ sky130_fd_sc_hd__nor2_1
Xaccumulator._1694_ accumulator._0734_ accumulator._0620_ accumulator._0787_ accumulator._0790_
+ accumulator._0651_ VGND VGND VPWR VPWR accumulator._0791_ sky130_fd_sc_hd__o32a_1
Xaccumulator._2246_ accumulator._0161_ accumulator._0180_ accumulator._0035_ VGND
+ VGND VPWR VPWR accumulator._0181_ sky130_fd_sc_hd__mux2_2
Xaccumulator._2315_ accumulator._0080_ accumulator._0182_ accumulator._0248_ VGND
+ VGND VPWR VPWR accumulator._0249_ sky130_fd_sc_hd__a21o_1
XFILLER_0_63_158 VGND VGND VPWR VPWR sky130_fd_sc_hd__decap_4
XFILLER_0_63_103 VGND VGND VPWR VPWR sky130_fd_sc_hd__fill_1
Xaccumulator._2177_ accumulator._0111_ accumulator._0062_ accumulator._0063_ VGND
+ VGND VPWR VPWR accumulator._0112_ sky130_fd_sc_hd__a21oi_1
XFILLER_0_44_350 VGND VGND VPWR VPWR sky130_fd_sc_hd__fill_2
XFILLER_0_29_380 VPWR VGND VPWR VGND sky130_ef_sc_hd__decap_12
XTAP_TAPCELL_ROW_47_507 VGND VPWR sky130_fd_sc_hd__tapvpwrvgnd_1
XTAP_TAPCELL_ROW_4_184 VGND VPWR sky130_fd_sc_hd__tapvpwrvgnd_1
XTAP_TAPCELL_ROW_55_562 VGND VPWR sky130_fd_sc_hd__tapvpwrvgnd_1
XFILLER_0_39_166 VGND VGND VPWR VPWR sky130_fd_sc_hd__fill_2
XFILLER_0_50_331 VPWR VGND VPWR VGND sky130_ef_sc_hd__decap_12
XFILLER_0_40_27 VGND VGND VPWR VPWR sky130_fd_sc_hd__fill_1
XFILLER_0_35_350 VGND VGND VPWR VPWR sky130_fd_sc_hd__decap_3
XscaleAdd._682_ scaleAdd._253_ scaleAdd._254_ VGND VGND VPWR VPWR scaleAdd._255_ sky130_fd_sc_hd__xor2_1
XFILLER_0_10_217 VGND VGND VPWR VPWR sky130_fd_sc_hd__decap_3
XFILLER_0_65_57 VPWR VGND VPWR VGND sky130_ef_sc_hd__decap_12
Xaccumulator._2100_ accumulator._1182_ accumulator._1187_ accumulator._1197_ VGND
+ VGND VPWR VPWR accumulator._1198_ sky130_fd_sc_hd__mux2_2
Xaccumulator._2031_ accumulator._1124_ accumulator._1127_ VGND VGND VPWR VPWR accumulator._1128_
+ sky130_fd_sc_hd__and2_1
XFILLER_0_14_61 VGND VGND VPWR VPWR sky130_fd_sc_hd__decap_3
XFILLER_0_14_72 VGND VGND VPWR VPWR sky130_fd_sc_hd__fill_1
XTAP_TAPCELL_ROW_18_286 VGND VPWR sky130_fd_sc_hd__tapvpwrvgnd_1
XFILLER_0_69_3 VPWR VGND VPWR VGND sky130_ef_sc_hd__decap_12
XFILLER_0_60_117 VPWR VGND VPWR VGND sky130_ef_sc_hd__decap_12
Xaccumulator._1815_ accumulator._0635_ accumulator._0525_ accumulator._0610_ accumulator._0733_
+ accumulator._0910_ VGND VGND VPWR VPWR accumulator._0912_ sky130_fd_sc_hd__a41o_1
XFILLER_0_41_342 VGND VGND VPWR VPWR sky130_fd_sc_hd__fill_1
XFILLER_0_5_233 VPWR VGND VPWR VGND sky130_ef_sc_hd__decap_12
XFILLER_0_5_277 VGND VGND VPWR VPWR sky130_fd_sc_hd__decap_3
Xaccumulator._1746_ accumulator._0835_ accumulator._0841_ accumulator._0842_ VGND
+ VGND VPWR VPWR accumulator._0843_ sky130_fd_sc_hd__or3_1
Xaccumulator._1677_ accumulator._0606_ accumulator._0773_ VGND VGND VPWR VPWR accumulator._0774_
+ sky130_fd_sc_hd__or2_1
XFILLER_0_39_91 VGND VGND VPWR VPWR sky130_fd_sc_hd__decap_3
XTAP_TAPCELL_ROW_52_543 VGND VPWR sky130_fd_sc_hd__tapvpwrvgnd_1
Xaccumulator._2229_ accumulator._0128_ accumulator._0071_ accumulator._0074_ accumulator._1141_
+ VGND VGND VPWR VPWR accumulator._0164_ sky130_fd_sc_hd__a211o_1
XFILLER_0_24_309 VGND VGND VPWR VPWR sky130_fd_sc_hd__decap_8
XTAP_TAPCELL_ROW_9_221 VGND VPWR sky130_fd_sc_hd__tapvpwrvgnd_1
XFILLER_0_35_27 VPWR VGND VPWR VGND sky130_ef_sc_hd__decap_12
XFILLER_0_55_412 VGND VGND VPWR VPWR sky130_fd_sc_hd__decap_4
XFILLER_0_55_401 VGND VGND VPWR VPWR sky130_fd_sc_hd__fill_2
XFILLER_0_51_15 VPWR VGND VPWR VGND sky130_ef_sc_hd__decap_12
XFILLER_0_27_147 VGND VGND VPWR VPWR sky130_fd_sc_hd__fill_2
XTAP_TAPCELL_ROW_15_267 VGND VPWR sky130_fd_sc_hd__tapvpwrvgnd_1
XFILLER_0_42_117 VPWR VGND VPWR VGND sky130_ef_sc_hd__decap_12
XscaleAdd._734_ scaleAdd._299_ VGND VGND VPWR VPWR accumulator.io_inExp\[2\] sky130_fd_sc_hd__buf_1
XscaleAdd._665_ scaleAdd._231_ scaleAdd._232_ scaleAdd._238_ VGND VGND VPWR VPWR scaleAdd._239_
+ sky130_fd_sc_hd__o21bai_1
XFILLER_0_2_225 VGND VGND VPWR VPWR sky130_fd_sc_hd__decap_8
XscaleAdd._596_ scaleAdd._318_ net64 scaleAdd._142_ scaleAdd._141_ VGND VGND VPWR
+ VPWR scaleAdd._173_ sky130_fd_sc_hd__a31o_1
Xaccumulator._1462_ accumulator._0558_ VGND VGND VPWR VPWR accumulator._0559_ sky130_fd_sc_hd__clkbuf_4
Xaccumulator._1600_ accumulator._0695_ accumulator._0696_ accumulator._0558_ VGND
+ VGND VPWR VPWR accumulator._0697_ sky130_fd_sc_hd__o21a_1
Xaccumulator._1531_ accumulator._0536_ accumulator._0509_ accumulator._0539_ VGND
+ VGND VPWR VPWR accumulator._0628_ sky130_fd_sc_hd__a21o_1
XTAP_TAPCELL_ROW_66_646 VGND VPWR sky130_fd_sc_hd__tapvpwrvgnd_1
XFILLER_0_65_209 VGND VGND VPWR VPWR sky130_fd_sc_hd__fill_1
XFILLER_0_58_250 VGND VGND VPWR VPWR sky130_fd_sc_hd__fill_2
Xaccumulator._1393_ accumulator._0489_ VGND VGND VPWR VPWR accumulator._0490_ sky130_fd_sc_hd__inv_2
Xaccumulator._2014_ accumulator._1105_ accumulator._1110_ VGND VGND VPWR VPWR accumulator._1111_
+ sky130_fd_sc_hd__xnor2_2
XFILLER_0_41_81 VGND VGND VPWR VPWR sky130_fd_sc_hd__fill_1
XFILLER_0_33_139 VGND VGND VPWR VPWR sky130_fd_sc_hd__decap_4
XFILLER_0_18_114 VGND VGND VPWR VPWR sky130_fd_sc_hd__fill_1
Xaccumulator._1729_ accumulator._0824_ accumulator._0825_ VGND VGND VPWR VPWR accumulator._0826_
+ sky130_fd_sc_hd__nor2_1
XFILLER_0_49_272 VGND VGND VPWR VPWR sky130_fd_sc_hd__decap_8
XFILLER_0_52_415 VGND VGND VPWR VPWR sky130_fd_sc_hd__fill_1
XFILLER_0_9_391 VGND VGND VPWR VPWR sky130_fd_sc_hd__fill_1
XscaleAdd._450_ operator.io_outMant\[3\] scaleAdd._317_ scaleAdd._351_ scaleAdd._030_
+ VGND VGND VPWR VPWR scaleAdd._031_ sky130_fd_sc_hd__a31o_1
XFILLER_0_46_15 VPWR VGND VPWR VGND sky130_ef_sc_hd__decap_12
X_21_ accumulator.io_accOut\[21\] VGND VGND VPWR VPWR net35 sky130_fd_sc_hd__buf_1
XscaleAdd._381_ scaleAdd._309_ accumulator.io_inMant\[1\] VGND VGND VPWR VPWR scaleAdd._324_
+ sky130_fd_sc_hd__and2_1
XFILLER_0_20_389 VPWR VGND VPWR VGND sky130_ef_sc_hd__decap_12
XTAP_TAPCELL_ROW_63_627 VGND VPWR sky130_fd_sc_hd__tapvpwrvgnd_1
XFILLER_0_1_39 VPWR VGND VPWR VGND sky130_ef_sc_hd__decap_12
XscaleAdd._717_ scaleAdd._283_ scaleAdd._284_ VGND VGND VPWR VPWR scaleAdd._285_ sky130_fd_sc_hd__and2_1
XFILLER_0_7_328 VGND VGND VPWR VPWR sky130_fd_sc_hd__decap_8
XPHY_EDGE_ROW_49_Right_49 VGND VGND VPWR VPWR sky130_fd_sc_hd__decap_3
XscaleAdd._648_ scaleAdd._209_ scaleAdd._222_ VGND VGND VPWR VPWR scaleAdd._223_ sky130_fd_sc_hd__xor2_1
XscaleAdd._579_ scaleAdd._014_ scaleAdd._337_ VGND VGND VPWR VPWR scaleAdd._156_ sky130_fd_sc_hd__and2_1
XFILLER_0_11_95 VPWR VGND VPWR VGND sky130_ef_sc_hd__decap_12
XPHY_EDGE_ROW_58_Right_58 VGND VGND VPWR VPWR sky130_fd_sc_hd__decap_3
Xaccumulator._1514_ accumulator._0497_ VGND VGND VPWR VPWR accumulator._0611_ sky130_fd_sc_hd__buf_2
Xaccumulator._1445_ accumulator.io_accOut\[8\] accumulator._0541_ net78 VGND VGND
+ VPWR VPWR accumulator._0542_ sky130_fd_sc_hd__mux2_1
Xaccumulator._1376_ accumulator._0401_ accumulator._0468_ accumulator._0471_ VGND
+ VGND VPWR VPWR accumulator._0473_ sky130_fd_sc_hd__and3_1
XFILLER_0_19_412 VGND VGND VPWR VPWR sky130_fd_sc_hd__decap_4
XPHY_EDGE_ROW_67_Right_67 VGND VGND VPWR VPWR sky130_fd_sc_hd__decap_3
XFILLER_0_61_289 VPWR VGND VPWR VGND sky130_ef_sc_hd__decap_12
XFILLER_0_46_297 VGND VGND VPWR VPWR sky130_fd_sc_hd__decap_4
XFILLER_0_46_253 VGND VGND VPWR VPWR sky130_fd_sc_hd__decap_3
XFILLER_0_21_109 VGND VGND VPWR VPWR sky130_fd_sc_hd__decap_3
XFILLER_0_14_161 VGND VGND VPWR VPWR sky130_fd_sc_hd__decap_3
XFILLER_0_16_29 VGND VGND VPWR VPWR sky130_fd_sc_hd__decap_6
XFILLER_0_37_264 VGND VGND VPWR VPWR sky130_fd_sc_hd__fill_2
XTAP_TAPCELL_ROW_25_340 VGND VPWR sky130_fd_sc_hd__tapvpwrvgnd_1
XFILLER_0_4_309 VPWR VGND VPWR VGND sky130_ef_sc_hd__decap_12
XscaleAdd._502_ scaleAdd._049_ scaleAdd._054_ VGND VGND VPWR VPWR scaleAdd._081_ sky130_fd_sc_hd__and2_1
XscaleAdd._433_ net13 VGND VGND VPWR VPWR scaleAdd._014_ sky130_fd_sc_hd__inv_2
X_04_ accumulator.io_accOut\[4\] VGND VGND VPWR VPWR net48 sky130_fd_sc_hd__buf_1
XPHY_EDGE_ROW_27_Left_98 VGND VGND VPWR VPWR sky130_fd_sc_hd__decap_3
XscaleAdd._364_ operator.io_outMant\[3\] scaleAdd._303_ scaleAdd._309_ VGND VGND VPWR
+ VPWR scaleAdd._310_ sky130_fd_sc_hd__and3_1
Xaccumulator._1230_ accumulator.io_inMant\[3\] accumulator._0313_ accumulator.io_inMant\[4\]
+ VGND VGND VPWR VPWR accumulator._0323_ sky130_fd_sc_hd__o21ba_1
Xaccumulator._1994_ accumulator._1089_ accumulator._1090_ accumulator._0919_ VGND
+ VGND VPWR VPWR accumulator._1091_ sky130_fd_sc_hd__mux2_1
XFILLER_0_43_212 VPWR VGND VPWR VGND sky130_ef_sc_hd__decap_12
XTAP_TAPCELL_ROW_31_387 VGND VPWR sky130_fd_sc_hd__tapvpwrvgnd_1
XFILLER_0_28_253 VGND VGND VPWR VPWR sky130_fd_sc_hd__decap_6
XFILLER_0_22_83 VGND VGND VPWR VPWR sky130_fd_sc_hd__fill_1
XFILLER_0_51_3 VPWR VGND VPWR VGND sky130_ef_sc_hd__decap_12
Xaccumulator._1428_ accumulator._0501_ VGND VGND VPWR VPWR accumulator._0525_ sky130_fd_sc_hd__clkbuf_4
XTAP_TAPCELL_ROW_39_443 VGND VPWR sky130_fd_sc_hd__tapvpwrvgnd_1
XFILLER_0_2_71 VGND VGND VPWR VPWR sky130_fd_sc_hd__decap_8
XTAP_TAPCELL_ROW_22_321 VGND VPWR sky130_fd_sc_hd__tapvpwrvgnd_1
Xaccumulator._1359_ accumulator.io_inMant\[0\] accumulator._0436_ accumulator._0455_
+ VGND VGND VPWR VPWR accumulator._0456_ sky130_fd_sc_hd__and3_1
XFILLER_0_6_191 VGND VGND VPWR VPWR sky130_fd_sc_hd__decap_4
XFILLER_0_43_27 VPWR VGND VPWR VGND sky130_ef_sc_hd__decap_12
XFILLER_0_65_370 VPWR VGND VPWR VGND sky130_ef_sc_hd__decap_12
XFILLER_0_25_223 VGND VGND VPWR VPWR sky130_fd_sc_hd__fill_1
XFILLER_0_40_248 VGND VGND VPWR VPWR sky130_fd_sc_hd__fill_1
Xaccumulator._2400_ clknet_2_1__leaf_clock accumulator._0001_ VGND VGND VPWR VPWR
+ accumulator.state\[1\] sky130_fd_sc_hd__dfxtp_1
XFILLER_0_0_389 VGND VGND VPWR VPWR sky130_fd_sc_hd__decap_3
XscaleAdd._416_ scaleAdd._355_ scaleAdd._356_ VGND VGND VPWR VPWR scaleAdd._358_ sky130_fd_sc_hd__nor2_1
Xaccumulator._2262_ accumulator._0128_ accumulator._0162_ accumulator._0118_ VGND
+ VGND VPWR VPWR accumulator._0197_ sky130_fd_sc_hd__o21ai_1
XTAP_TAPCELL_ROW_36_424 VGND VPWR sky130_fd_sc_hd__tapvpwrvgnd_1
Xaccumulator._2331_ accumulator.io_accOut\[24\] accumulator._0370_ accumulator._0405_
+ VGND VGND VPWR VPWR accumulator._0264_ sky130_fd_sc_hd__mux2_1
Xaccumulator._1213_ accumulator.io_inMant\[6\] accumulator.io_inMant\[7\] VGND VGND
+ VPWR VPWR accumulator._0156_ sky130_fd_sc_hd__nor2_1
XFILLER_0_17_94 VGND VGND VPWR VPWR sky130_fd_sc_hd__fill_1
XFILLER_0_48_337 VGND VGND VPWR VPWR sky130_fd_sc_hd__decap_3
Xaccumulator._2193_ accumulator._0072_ accumulator._0048_ accumulator._0073_ VGND
+ VGND VPWR VPWR accumulator._0129_ sky130_fd_sc_hd__o21a_1
XFILLER_0_8_401 VPWR VGND VPWR VGND sky130_ef_sc_hd__decap_12
Xaccumulator._1977_ accumulator._0919_ accumulator._0874_ VGND VGND VPWR VPWR accumulator._1074_
+ sky130_fd_sc_hd__nor2_1
XFILLER_0_39_337 VGND VGND VPWR VPWR sky130_fd_sc_hd__fill_1
XFILLER_0_13_19 VGND VGND VPWR VPWR sky130_fd_sc_hd__decap_4
XFILLER_0_54_318 VPWR VGND VPWR VGND sky130_ef_sc_hd__decap_12
XFILLER_0_38_27 VGND VGND VPWR VPWR sky130_fd_sc_hd__fill_1
XFILLER_0_54_15 VPWR VGND VPWR VGND sky130_ef_sc_hd__decap_12
XFILLER_0_70_69 VPWR VGND VPWR VGND sky130_ef_sc_hd__decap_12
XFILLER_0_57_167 VGND VGND VPWR VPWR sky130_fd_sc_hd__fill_1
XTAP_TAPCELL_ROW_41_460 VGND VPWR sky130_fd_sc_hd__tapvpwrvgnd_1
Xaccumulator._1831_ accumulator._0799_ accumulator._0745_ VGND VGND VPWR VPWR accumulator._0928_
+ sky130_fd_sc_hd__nand2_1
Xaccumulator._1900_ accumulator._0994_ accumulator._0996_ VGND VGND VPWR VPWR accumulator._0997_
+ sky130_fd_sc_hd__nor2_1
XFILLER_0_13_259 VGND VGND VPWR VPWR sky130_fd_sc_hd__decap_3
Xaccumulator._1762_ accumulator._0855_ accumulator._0853_ VGND VGND VPWR VPWR accumulator._0859_
+ sky130_fd_sc_hd__nand2_1
Xaccumulator._1693_ accumulator._0635_ accumulator._0788_ accumulator._0789_ VGND
+ VGND VPWR VPWR accumulator._0790_ sky130_fd_sc_hd__a21bo_1
XFILLER_0_21_292 VPWR VGND VPWR VGND sky130_ef_sc_hd__decap_12
XFILLER_0_0_197 VPWR VGND VPWR VGND sky130_ef_sc_hd__decap_12
Xaccumulator._2245_ accumulator._1085_ accumulator._1083_ accumulator._1184_ VGND
+ VGND VPWR VPWR accumulator._0180_ sky130_fd_sc_hd__mux2_2
Xaccumulator._2314_ accumulator._0086_ accumulator._0212_ accumulator._0247_ accumulator._0131_
+ VGND VGND VPWR VPWR accumulator._0248_ sky130_fd_sc_hd__a211o_1
Xaccumulator._2176_ accumulator._0035_ VGND VGND VPWR VPWR accumulator._0111_ sky130_fd_sc_hd__buf_2
XFILLER_0_44_70 VGND VGND VPWR VPWR sky130_fd_sc_hd__decap_8
XFILLER_0_14_3 VGND VGND VPWR VPWR sky130_fd_sc_hd__decap_6
XFILLER_0_36_307 VGND VGND VPWR VPWR sky130_fd_sc_hd__fill_1
XPHY_EDGE_ROW_14_Left_85 VGND VGND VPWR VPWR sky130_fd_sc_hd__decap_3
XTAP_TAPCELL_ROW_47_508 VGND VPWR sky130_fd_sc_hd__tapvpwrvgnd_1
XTAP_TAPCELL_ROW_4_185 VGND VPWR sky130_fd_sc_hd__tapvpwrvgnd_1
XTAP_TAPCELL_ROW_55_563 VGND VPWR sky130_fd_sc_hd__tapvpwrvgnd_1
XFILLER_0_24_29 VPWR VGND VPWR VGND sky130_ef_sc_hd__decap_12
XFILLER_0_50_343 VGND VGND VPWR VPWR sky130_fd_sc_hd__decap_4
XFILLER_0_49_15 VPWR VGND VPWR VGND sky130_ef_sc_hd__decap_12
XscaleAdd._681_ scaleAdd._318_ scaleAdd._216_ scaleAdd._237_ scaleAdd._235_ VGND VGND
+ VPWR VPWR scaleAdd._254_ sky130_fd_sc_hd__a31o_1
XFILLER_0_4_39 VPWR VGND VPWR VGND sky130_ef_sc_hd__decap_12
XFILLER_0_65_69 VPWR VGND VPWR VGND sky130_ef_sc_hd__decap_12
Xaccumulator._2030_ accumulator._0909_ accumulator._1126_ VGND VGND VPWR VPWR accumulator._1127_
+ sky130_fd_sc_hd__xnor2_1
XFILLER_0_60_129 VGND VGND VPWR VPWR sky130_fd_sc_hd__decap_8
XFILLER_0_5_245 VPWR VGND VPWR VGND sky130_ef_sc_hd__decap_12
XTAP_TAPCELL_ROW_18_287 VGND VPWR sky130_fd_sc_hd__tapvpwrvgnd_1
Xaccumulator._1745_ accumulator._0824_ accumulator._0825_ VGND VGND VPWR VPWR accumulator._0842_
+ sky130_fd_sc_hd__and2b_1
Xaccumulator._1814_ accumulator._0740_ accumulator._0852_ accumulator._0787_ accumulator._0910_
+ VGND VGND VPWR VPWR accumulator._0911_ sky130_fd_sc_hd__or4b_2
XFILLER_0_53_181 VPWR VGND VPWR VGND sky130_ef_sc_hd__decap_12
XFILLER_0_30_83 VGND VGND VPWR VPWR sky130_fd_sc_hd__fill_1
XFILLER_0_5_289 VGND VGND VPWR VPWR sky130_fd_sc_hd__fill_2
Xaccumulator._1676_ accumulator._0558_ accumulator._0695_ accumulator._0696_ accumulator._0772_
+ VGND VGND VPWR VPWR accumulator._0773_ sky130_fd_sc_hd__o31a_1
XFILLER_0_64_402 VPWR VGND VPWR VGND sky130_ef_sc_hd__decap_12
XTAP_TAPCELL_ROW_52_544 VGND VPWR sky130_fd_sc_hd__tapvpwrvgnd_1
Xaccumulator._2228_ accumulator._0159_ accumulator._0162_ accumulator._1149_ VGND
+ VGND VPWR VPWR accumulator._0163_ sky130_fd_sc_hd__mux2_2
Xaccumulator._2159_ accumulator._0090_ accumulator._0092_ accumulator._0093_ VGND
+ VGND VPWR VPWR accumulator._0006_ sky130_fd_sc_hd__o21a_1
XFILLER_0_44_181 VGND VGND VPWR VPWR sky130_fd_sc_hd__decap_6
XFILLER_0_32_376 VPWR VGND VPWR VGND sky130_ef_sc_hd__decap_12
XFILLER_0_32_365 VGND VGND VPWR VPWR sky130_fd_sc_hd__decap_3
XFILLER_0_3_3 VPWR VGND VPWR VGND sky130_ef_sc_hd__decap_12
XTAP_TAPCELL_ROW_9_222 VGND VPWR sky130_fd_sc_hd__tapvpwrvgnd_1
XFILLER_0_59_207 VGND VGND VPWR VPWR sky130_fd_sc_hd__decap_8
XFILLER_0_35_39 VPWR VGND VPWR VGND sky130_ef_sc_hd__decap_12
XFILLER_0_70_405 VPWR VGND VPWR VGND sky130_ef_sc_hd__decap_12
XFILLER_0_67_262 VGND VGND VPWR VPWR sky130_fd_sc_hd__decap_3
XFILLER_0_51_27 VPWR VGND VPWR VGND sky130_ef_sc_hd__decap_12
XscaleAdd._733_ scaleAdd._297_ scaleAdd._298_ VGND VGND VPWR VPWR scaleAdd._299_ sky130_fd_sc_hd__and2_1
XTAP_TAPCELL_ROW_15_268 VGND VPWR sky130_fd_sc_hd__tapvpwrvgnd_1
XFILLER_0_50_195 VGND VGND VPWR VPWR sky130_fd_sc_hd__fill_1
XFILLER_0_42_129 VGND VGND VPWR VPWR sky130_fd_sc_hd__decap_4
XFILLER_0_23_354 VGND VGND VPWR VPWR sky130_fd_sc_hd__decap_6
XFILLER_0_23_332 VGND VGND VPWR VPWR sky130_fd_sc_hd__decap_4
XscaleAdd._664_ scaleAdd._233_ scaleAdd._237_ VGND VGND VPWR VPWR scaleAdd._238_ sky130_fd_sc_hd__xor2_1
XscaleAdd._595_ scaleAdd._154_ scaleAdd._171_ VGND VGND VPWR VPWR scaleAdd._172_ sky130_fd_sc_hd__xnor2_2
Xaccumulator._1530_ accumulator._0623_ accumulator._0626_ accumulator._0599_ VGND
+ VGND VPWR VPWR accumulator._0627_ sky130_fd_sc_hd__a21o_1
Xaccumulator._1461_ accumulator._0427_ VGND VGND VPWR VPWR accumulator._0558_ sky130_fd_sc_hd__buf_2
Xaccumulator._1392_ accumulator._0263_ accumulator._0488_ VGND VGND VPWR VPWR accumulator._0489_
+ sky130_fd_sc_hd__nand2_1
Xaccumulator._2013_ accumulator._1054_ accumulator._1109_ VGND VGND VPWR VPWR accumulator._1110_
+ sky130_fd_sc_hd__nor2_1
XTAP_TAPCELL_ROW_66_647 VGND VPWR sky130_fd_sc_hd__tapvpwrvgnd_1
XFILLER_0_25_50 VGND VGND VPWR VPWR sky130_fd_sc_hd__decap_6
XFILLER_0_61_405 VPWR VGND VPWR VGND sky130_ef_sc_hd__decap_12
XFILLER_0_33_129 VGND VGND VPWR VPWR sky130_fd_sc_hd__fill_1
XFILLER_0_33_107 VGND VGND VPWR VPWR sky130_fd_sc_hd__decap_4
XFILLER_0_14_343 VGND VGND VPWR VPWR sky130_fd_sc_hd__fill_1
XFILLER_0_18_148 VGND VGND VPWR VPWR sky130_fd_sc_hd__decap_6
Xaccumulator._1728_ accumulator.io_accOut\[11\] accumulator._0513_ accumulator._0403_
+ VGND VGND VPWR VPWR accumulator._0825_ sky130_fd_sc_hd__mux2_1
XFILLER_0_1_281 VPWR VGND VPWR VGND sky130_ef_sc_hd__decap_12
Xaccumulator._1659_ accumulator._0665_ accumulator._0666_ VGND VGND VPWR VPWR accumulator._0756_
+ sky130_fd_sc_hd__or2_1
XFILLER_0_64_276 VGND VGND VPWR VPWR sky130_fd_sc_hd__decap_6
XFILLER_0_64_298 VGND VGND VPWR VPWR sky130_fd_sc_hd__decap_8
XscaleAdd._380_ scaleAdd._323_ VGND VGND VPWR VPWR accumulator.io_inMant\[1\] sky130_fd_sc_hd__buf_1
XFILLER_0_46_27 VGND VGND VPWR VPWR sky130_fd_sc_hd__fill_1
X_20_ accumulator.io_accOut\[20\] VGND VGND VPWR VPWR net34 sky130_fd_sc_hd__clkbuf_1
XTAP_TAPCELL_ROW_63_628 VGND VPWR sky130_fd_sc_hd__tapvpwrvgnd_1
XFILLER_0_62_15 VPWR VGND VPWR VGND sky130_ef_sc_hd__decap_12
XTAP_TAPCELL_ROW_28_360 VGND VPWR sky130_fd_sc_hd__tapvpwrvgnd_1
XscaleAdd._716_ scaleAdd._281_ scaleAdd._282_ operator.io_outExp\[0\] VGND VGND VPWR
+ VPWR scaleAdd._284_ sky130_fd_sc_hd__o21bai_1
XscaleAdd._578_ scaleAdd._312_ scaleAdd._077_ VGND VGND VPWR VPWR scaleAdd._155_ sky130_fd_sc_hd__and2_1
XscaleAdd._647_ scaleAdd._219_ scaleAdd._221_ VGND VGND VPWR VPWR scaleAdd._222_ sky130_fd_sc_hd__xor2_1
XFILLER_0_11_335 VGND VGND VPWR VPWR sky130_fd_sc_hd__fill_1
Xaccumulator._1513_ accumulator._0475_ accumulator._0607_ accumulator._0608_ accumulator._0609_
+ VGND VGND VPWR VPWR accumulator._0610_ sky130_fd_sc_hd__a31o_1
Xaccumulator._1375_ accumulator._0401_ accumulator._0468_ accumulator._0471_ VGND
+ VGND VPWR VPWR accumulator._0472_ sky130_fd_sc_hd__a21oi_1
Xaccumulator._1444_ accumulator._0453_ accumulator._0458_ VGND VGND VPWR VPWR accumulator._0541_
+ sky130_fd_sc_hd__and2_1
Xinput1 io_inA[0] VGND VGND VPWR VPWR net1 sky130_fd_sc_hd__buf_1
XFILLER_0_69_335 VGND VGND VPWR VPWR sky130_fd_sc_hd__fill_1
XFILLER_0_32_29 VPWR VGND VPWR VGND sky130_ef_sc_hd__decap_12
XFILLER_0_32_18 VGND VGND VPWR VPWR sky130_fd_sc_hd__decap_8
XTAP_TAPCELL_ROW_25_341 VGND VPWR sky130_fd_sc_hd__tapvpwrvgnd_1
XFILLER_0_52_224 VPWR VGND VPWR VGND sky130_ef_sc_hd__decap_12
XPHY_EDGE_ROW_2_Left_73 VGND VGND VPWR VPWR sky130_fd_sc_hd__decap_3
XFILLER_0_57_15 VPWR VGND VPWR VGND sky130_ef_sc_hd__decap_12
XscaleAdd._432_ scaleAdd._008_ scaleAdd._012_ VGND VGND VPWR VPWR scaleAdd._013_ sky130_fd_sc_hd__xnor2_1
XscaleAdd._501_ scaleAdd._048_ scaleAdd._055_ VGND VGND VPWR VPWR scaleAdd._080_ sky130_fd_sc_hd__or2b_1
XscaleAdd._363_ scaleAdd._307_ scaleAdd._308_ VGND VGND VPWR VPWR scaleAdd._309_ sky130_fd_sc_hd__xor2_1
X_03_ accumulator.io_accOut\[3\] VGND VGND VPWR VPWR net47 sky130_fd_sc_hd__buf_1
XFILLER_0_28_221 VGND VGND VPWR VPWR sky130_fd_sc_hd__decap_6
Xaccumulator._1993_ accumulator._0866_ accumulator._0882_ accumulator._0952_ accumulator._0958_
+ VGND VGND VPWR VPWR accumulator._1090_ sky130_fd_sc_hd__o31ai_1
XFILLER_0_51_290 VPWR VGND VPWR VGND sky130_ef_sc_hd__decap_12
XFILLER_0_31_419 VGND VGND VPWR VPWR sky130_fd_sc_hd__fill_2
XTAP_TAPCELL_ROW_31_388 VGND VPWR sky130_fd_sc_hd__tapvpwrvgnd_1
XFILLER_0_3_321 VPWR VGND VPWR VGND sky130_ef_sc_hd__decap_12
XFILLER_0_44_3 VPWR VGND VPWR VGND sky130_ef_sc_hd__decap_12
Xaccumulator._1427_ accumulator._0428_ accumulator._0500_ accumulator._0521_ accumulator._0523_
+ VGND VGND VPWR VPWR accumulator._0524_ sky130_fd_sc_hd__a211o_1
XTAP_TAPCELL_ROW_39_444 VGND VPWR sky130_fd_sc_hd__tapvpwrvgnd_1
XFILLER_0_2_94 VGND VGND VPWR VPWR sky130_fd_sc_hd__decap_4
XFILLER_0_2_83 VGND VGND VPWR VPWR sky130_fd_sc_hd__fill_1
Xaccumulator._1358_ accumulator._0215_ VGND VGND VPWR VPWR accumulator._0455_ sky130_fd_sc_hd__inv_2
Xaccumulator._1289_ accumulator.io_accOut\[28\] accumulator._0386_ VGND VGND VPWR
+ VPWR accumulator._0388_ sky130_fd_sc_hd__and2_1
XFILLER_0_27_18 VPWR VGND VPWR VGND sky130_ef_sc_hd__decap_12
XFILLER_0_69_198 VPWR VGND VPWR VGND sky130_ef_sc_hd__decap_12
XFILLER_0_69_165 VGND VGND VPWR VPWR sky130_fd_sc_hd__decap_3
XFILLER_0_69_132 VGND VGND VPWR VPWR sky130_fd_sc_hd__decap_8
XFILLER_0_57_349 VGND VGND VPWR VPWR sky130_fd_sc_hd__decap_3
XFILLER_0_57_327 VGND VGND VPWR VPWR sky130_fd_sc_hd__decap_8
XFILLER_0_43_39 VPWR VGND VPWR VGND sky130_ef_sc_hd__decap_12
XFILLER_0_65_393 VPWR VGND VPWR VGND sky130_ef_sc_hd__decap_12
XFILLER_0_65_382 VGND VGND VPWR VPWR sky130_fd_sc_hd__decap_8
XFILLER_0_40_216 VPWR VGND VPWR VGND sky130_ef_sc_hd__decap_12
XFILLER_0_25_268 VPWR VGND VPWR VGND sky130_ef_sc_hd__decap_12
XscaleAdd._415_ scaleAdd._355_ scaleAdd._356_ VGND VGND VPWR VPWR scaleAdd._357_ sky130_fd_sc_hd__and2_1
Xaccumulator._2261_ accumulator._0086_ accumulator._0194_ VGND VGND VPWR VPWR accumulator._0196_
+ sky130_fd_sc_hd__nor2_1
Xaccumulator._2192_ accumulator._1148_ VGND VGND VPWR VPWR accumulator._0128_ sky130_fd_sc_hd__buf_2
XTAP_TAPCELL_ROW_36_425 VGND VPWR sky130_fd_sc_hd__tapvpwrvgnd_1
Xaccumulator._2330_ net107 accumulator._0167_ accumulator._0177_ accumulator._0262_
+ VGND VGND VPWR VPWR accumulator._0025_ sky130_fd_sc_hd__o211a_1
XFILLER_0_16_7 VGND VGND VPWR VPWR sky130_fd_sc_hd__decap_8
XFILLER_0_17_62 VGND VGND VPWR VPWR sky130_fd_sc_hd__fill_2
XFILLER_0_17_73 VGND VGND VPWR VPWR sky130_fd_sc_hd__decap_8
Xaccumulator._1212_ accumulator.io_inMant\[3\] accumulator.io_inMant\[2\] VGND VGND
+ VPWR VPWR accumulator._0146_ sky130_fd_sc_hd__nor2_1
XFILLER_0_56_371 VGND VGND VPWR VPWR sky130_fd_sc_hd__decap_3
XFILLER_0_48_349 VGND VGND VPWR VPWR sky130_fd_sc_hd__decap_3
XTAP_TAPCELL_ROW_44_480 VGND VPWR sky130_fd_sc_hd__tapvpwrvgnd_1
XFILLER_0_8_413 VGND VGND VPWR VPWR sky130_fd_sc_hd__decap_6
Xaccumulator._1976_ accumulator._1072_ VGND VGND VPWR VPWR accumulator._1073_ sky130_fd_sc_hd__inv_2
XFILLER_0_3_162 VGND VGND VPWR VPWR sky130_fd_sc_hd__decap_6
XFILLER_0_62_374 VGND VGND VPWR VPWR sky130_fd_sc_hd__fill_1
XFILLER_0_30_271 VPWR VGND VPWR VGND sky130_ef_sc_hd__decap_12
XFILLER_0_57_102 VGND VGND VPWR VPWR sky130_fd_sc_hd__fill_2
XFILLER_0_54_49 VGND VGND VPWR VPWR sky130_fd_sc_hd__decap_3
XFILLER_0_54_27 VGND VGND VPWR VPWR sky130_fd_sc_hd__fill_1
XFILLER_0_70_15 VPWR VGND VPWR VGND sky130_ef_sc_hd__decap_12
XTAP_TAPCELL_ROW_41_461 VGND VPWR sky130_fd_sc_hd__tapvpwrvgnd_1
XFILLER_0_5_405 VPWR VGND VPWR VGND sky130_ef_sc_hd__decap_12
Xaccumulator._1761_ accumulator._0851_ accumulator._0857_ VGND VGND VPWR VPWR accumulator._0858_
+ sky130_fd_sc_hd__and2b_1
Xaccumulator._1830_ accumulator._0811_ accumulator._0812_ VGND VGND VPWR VPWR accumulator._0927_
+ sky130_fd_sc_hd__nand2_1
XPHY_EDGE_ROW_9_Right_9 VGND VGND VPWR VPWR sky130_fd_sc_hd__decap_3
Xaccumulator._2313_ accumulator._0111_ accumulator._0229_ accumulator._0246_ VGND
+ VGND VPWR VPWR accumulator._0247_ sky130_fd_sc_hd__o21a_1
Xaccumulator._1692_ accumulator._0706_ accumulator._0707_ accumulator._0606_ VGND
+ VGND VPWR VPWR accumulator._0789_ sky130_fd_sc_hd__o21ai_1
XFILLER_0_28_83 VGND VGND VPWR VPWR sky130_fd_sc_hd__fill_1
Xaccumulator._2244_ accumulator._0111_ accumulator._0124_ accumulator._0144_ VGND
+ VGND VPWR VPWR accumulator._0179_ sky130_fd_sc_hd__o21ai_1
XFILLER_0_48_135 VGND VGND VPWR VPWR sky130_fd_sc_hd__decap_4
Xaccumulator._2175_ accumulator._1148_ VGND VGND VPWR VPWR accumulator._0110_ sky130_fd_sc_hd__clkbuf_4
XFILLER_0_8_210 VGND VGND VPWR VPWR sky130_fd_sc_hd__decap_3
XFILLER_0_60_81 VGND VGND VPWR VPWR sky130_fd_sc_hd__decap_3
Xaccumulator._1959_ accumulator._1046_ accumulator._1055_ VGND VGND VPWR VPWR accumulator._1056_
+ sky130_fd_sc_hd__xnor2_2
XTAP_TAPCELL_ROW_4_186 VGND VPWR sky130_fd_sc_hd__tapvpwrvgnd_1
XTAP_TAPCELL_ROW_55_564 VGND VPWR sky130_fd_sc_hd__tapvpwrvgnd_1
XFILLER_0_54_127 VGND VGND VPWR VPWR sky130_fd_sc_hd__fill_1
XFILLER_0_40_29 VPWR VGND VPWR VGND sky130_ef_sc_hd__decap_12
XFILLER_0_50_300 VGND VGND VPWR VPWR sky130_fd_sc_hd__decap_8
XFILLER_0_49_27 VPWR VGND VPWR VGND sky130_ef_sc_hd__decap_12
XFILLER_0_2_419 VGND VGND VPWR VPWR sky130_fd_sc_hd__fill_1
XscaleAdd._680_ scaleAdd._251_ scaleAdd._252_ VGND VGND VPWR VPWR scaleAdd._253_ sky130_fd_sc_hd__nor2_1
XFILLER_0_65_15 VPWR VGND VPWR VGND sky130_ef_sc_hd__decap_12
XFILLER_0_4_29 VGND VGND VPWR VPWR sky130_fd_sc_hd__decap_4
XFILLER_0_58_400 VGND VGND VPWR VPWR sky130_fd_sc_hd__fill_1
XFILLER_0_14_41 VPWR VGND VPWR VGND sky130_ef_sc_hd__decap_12
XTAP_TAPCELL_ROW_18_288 VGND VPWR sky130_fd_sc_hd__tapvpwrvgnd_1
XFILLER_0_53_193 VGND VGND VPWR VPWR sky130_fd_sc_hd__decap_4
XFILLER_0_45_105 VGND VGND VPWR VPWR sky130_fd_sc_hd__fill_1
XFILLER_0_5_257 VPWR VGND VPWR VGND sky130_ef_sc_hd__decap_12
XFILLER_0_14_85 VPWR VGND VPWR VGND sky130_ef_sc_hd__decap_12
Xaccumulator._1744_ accumulator._0829_ accumulator._0840_ VGND VGND VPWR VPWR accumulator._0841_
+ sky130_fd_sc_hd__nor2_1
XFILLER_0_41_366 VGND VGND VPWR VPWR sky130_fd_sc_hd__decap_8
XFILLER_0_39_71 VPWR VGND VPWR VGND sky130_ef_sc_hd__decap_12
Xaccumulator._1813_ accumulator.io_accOut\[21\] accumulator._0576_ accumulator._0405_
+ VGND VGND VPWR VPWR accumulator._0910_ sky130_fd_sc_hd__mux2_1
XTAP_TAPCELL_ROW_69_667 VGND VPWR sky130_fd_sc_hd__tapvpwrvgnd_1
Xaccumulator._1675_ accumulator._0501_ accumulator._0701_ VGND VGND VPWR VPWR accumulator._0772_
+ sky130_fd_sc_hd__or2_1
XFILLER_0_64_414 VGND VGND VPWR VPWR sky130_fd_sc_hd__decap_6
Xaccumulator._2227_ accumulator._0160_ accumulator._0161_ accumulator._0035_ VGND
+ VGND VPWR VPWR accumulator._0162_ sky130_fd_sc_hd__mux2_1
XTAP_TAPCELL_ROW_52_545 VGND VPWR sky130_fd_sc_hd__tapvpwrvgnd_1
Xaccumulator._2089_ accumulator._1183_ net69 accumulator._1186_ VGND VGND VPWR VPWR
+ accumulator._1187_ sky130_fd_sc_hd__o21ba_1
Xaccumulator._2158_ accumulator._0400_ VGND VGND VPWR VPWR accumulator._0093_ sky130_fd_sc_hd__buf_2
XTAP_TAPCELL_ROW_9_223 VGND VPWR sky130_fd_sc_hd__tapvpwrvgnd_1
XFILLER_0_17_352 VPWR VGND VPWR VGND sky130_ef_sc_hd__decap_12
XFILLER_0_19_19 VPWR VGND VPWR VGND sky130_ef_sc_hd__decap_12
XFILLER_0_70_417 VGND VGND VPWR VPWR sky130_fd_sc_hd__decap_3
XFILLER_0_67_285 VGND VGND VPWR VPWR sky130_fd_sc_hd__fill_1
XFILLER_0_51_39 VPWR VGND VPWR VGND sky130_ef_sc_hd__decap_12
XscaleAdd._732_ scaleAdd._290_ scaleAdd._293_ scaleAdd._296_ VGND VGND VPWR VPWR scaleAdd._298_
+ sky130_fd_sc_hd__or3_1
XscaleAdd._663_ scaleAdd._235_ scaleAdd._236_ VGND VGND VPWR VPWR scaleAdd._237_ sky130_fd_sc_hd__nor2_1
XFILLER_0_50_141 VGND VGND VPWR VPWR sky130_fd_sc_hd__decap_3
XscaleAdd._594_ scaleAdd._155_ scaleAdd._170_ VGND VGND VPWR VPWR scaleAdd._171_ sky130_fd_sc_hd__xnor2_2
XTAP_TAPCELL_ROW_66_648 VGND VPWR sky130_fd_sc_hd__tapvpwrvgnd_1
Xaccumulator._1460_ accumulator._0419_ accumulator._0556_ VGND VGND VPWR VPWR accumulator._0557_
+ sky130_fd_sc_hd__and2_2
Xaccumulator._1391_ accumulator.io_inMant\[0\] accumulator._0436_ accumulator._0215_
+ VGND VGND VPWR VPWR accumulator._0488_ sky130_fd_sc_hd__and3_1
Xaccumulator._2012_ accumulator._1092_ accumulator._1097_ accumulator._1108_ VGND
+ VGND VPWR VPWR accumulator._1109_ sky130_fd_sc_hd__and3_1
XFILLER_0_58_230 VPWR VGND VPWR VGND sky130_ef_sc_hd__decap_12
XFILLER_0_18_127 VPWR VGND VPWR VGND sky130_ef_sc_hd__decap_12
XFILLER_0_61_417 VGND VGND VPWR VPWR sky130_fd_sc_hd__decap_4
XFILLER_0_14_322 VGND VGND VPWR VPWR sky130_fd_sc_hd__fill_1
XFILLER_0_14_377 VPWR VGND VPWR VGND sky130_ef_sc_hd__decap_12
Xaccumulator._1727_ accumulator._0734_ accumulator._0767_ accumulator._0768_ accumulator._0823_
+ accumulator._0733_ VGND VGND VPWR VPWR accumulator._0824_ sky130_fd_sc_hd__o311a_1
Xaccumulator._1658_ accumulator._0526_ accumulator._0658_ accumulator._0659_ VGND
+ VGND VPWR VPWR accumulator._0755_ sky130_fd_sc_hd__a21o_1
XFILLER_0_1_293 VPWR VGND VPWR VGND sky130_ef_sc_hd__decap_12
Xaccumulator._1589_ accumulator._0637_ accumulator._0638_ accumulator._0498_ VGND
+ VGND VPWR VPWR accumulator._0686_ sky130_fd_sc_hd__a21o_1
XFILLER_0_64_200 VGND VGND VPWR VPWR sky130_fd_sc_hd__fill_1
XFILLER_0_9_393 VPWR VGND VPWR VGND sky130_ef_sc_hd__decap_12
XTAP_TAPCELL_ROW_12_239 VGND VPWR sky130_fd_sc_hd__tapvpwrvgnd_1
XFILLER_0_32_141 VPWR VGND VPWR VGND sky130_ef_sc_hd__decap_12
XFILLER_0_17_193 VPWR VGND VPWR VGND sky130_ef_sc_hd__decap_12
XFILLER_0_20_358 VGND VGND VPWR VPWR sky130_fd_sc_hd__fill_2
XFILLER_0_62_27 VGND VGND VPWR VPWR sky130_fd_sc_hd__fill_1
XTAP_TAPCELL_ROW_28_361 VGND VPWR sky130_fd_sc_hd__tapvpwrvgnd_1
XFILLER_0_70_225 VPWR VGND VPWR VGND sky130_ef_sc_hd__decap_12
XscaleAdd._715_ scaleAdd._281_ scaleAdd._282_ operator.io_outExp\[0\] VGND VGND VPWR
+ VPWR scaleAdd._283_ sky130_fd_sc_hd__or3b_1
XscaleAdd._646_ scaleAdd._318_ scaleAdd._188_ scaleAdd._197_ scaleAdd._220_ VGND VGND
+ VPWR VPWR scaleAdd._221_ sky130_fd_sc_hd__a31o_1
Xaccumulator._1512_ accumulator._0414_ accumulator._0471_ net72 accumulator._0592_
+ VGND VGND VPWR VPWR accumulator._0609_ sky130_fd_sc_hd__and4_1
XscaleAdd._577_ operator.io_outMant\[1\] scaleAdd._140_ VGND VGND VPWR VPWR scaleAdd._154_
+ sky130_fd_sc_hd__nand2_1
Xaccumulator._1443_ accumulator._0536_ accumulator._0538_ accumulator._0539_ VGND
+ VGND VPWR VPWR accumulator._0540_ sky130_fd_sc_hd__a21o_1
XFILLER_0_36_83 VGND VGND VPWR VPWR sky130_fd_sc_hd__fill_1
Xinput2 io_inA[1] VGND VGND VPWR VPWR net2 sky130_fd_sc_hd__buf_1
Xaccumulator._1374_ accumulator._0371_ net66 VGND VGND VPWR VPWR accumulator._0471_
+ sky130_fd_sc_hd__xor2_2
XFILLER_0_61_225 VGND VGND VPWR VPWR sky130_fd_sc_hd__decap_8
XFILLER_0_6_363 VGND VGND VPWR VPWR sky130_fd_sc_hd__fill_1
XFILLER_0_14_141 VPWR VGND VPWR VGND sky130_ef_sc_hd__decap_12
XFILLER_0_37_233 VPWR VGND VPWR VGND sky130_ef_sc_hd__decap_12
XTAP_TAPCELL_ROW_25_342 VGND VPWR sky130_fd_sc_hd__tapvpwrvgnd_1
XFILLER_0_52_236 VPWR VGND VPWR VGND sky130_ef_sc_hd__decap_12
XscaleAdd._500_ operator.io_outMant\[3\] scaleAdd._350_ VGND VGND VPWR VPWR scaleAdd._079_
+ sky130_fd_sc_hd__nand2_1
XFILLER_0_57_27 VPWR VGND VPWR VGND sky130_ef_sc_hd__decap_12
XscaleAdd._431_ scaleAdd._011_ scaleAdd._010_ VGND VGND VPWR VPWR scaleAdd._012_ sky130_fd_sc_hd__xnor2_1
XscaleAdd._362_ net11 VGND VGND VPWR VPWR scaleAdd._308_ sky130_fd_sc_hd__buf_2
XFILLER_0_20_166 VGND VGND VPWR VPWR sky130_fd_sc_hd__decap_8
X_02_ accumulator.io_accOut\[2\] VGND VGND VPWR VPWR net44 sky130_fd_sc_hd__buf_1
XFILLER_0_43_225 VGND VGND VPWR VPWR sky130_fd_sc_hd__decap_4
XFILLER_0_22_85 VGND VGND VPWR VPWR sky130_fd_sc_hd__decap_3
XFILLER_0_22_41 VGND VGND VPWR VPWR sky130_fd_sc_hd__decap_8
XFILLER_0_7_138 VGND VGND VPWR VPWR sky130_fd_sc_hd__fill_2
Xaccumulator._1992_ accumulator._0876_ accumulator._0882_ accumulator._0896_ VGND
+ VGND VPWR VPWR accumulator._1089_ sky130_fd_sc_hd__a21oi_1
XFILLER_0_3_333 VGND VGND VPWR VPWR sky130_fd_sc_hd__decap_3
XscaleAdd._629_ scaleAdd._184_ scaleAdd._185_ scaleAdd._203_ VGND VGND VPWR VPWR scaleAdd._205_
+ sky130_fd_sc_hd__a21o_1
XFILLER_0_11_111 VGND VGND VPWR VPWR sky130_fd_sc_hd__fill_1
XFILLER_0_37_3 VPWR VGND VPWR VGND sky130_ef_sc_hd__decap_12
XTAP_TAPCELL_ROW_39_445 VGND VPWR sky130_fd_sc_hd__tapvpwrvgnd_1
Xaccumulator._1426_ accumulator._0410_ accumulator._0522_ VGND VGND VPWR VPWR accumulator._0523_
+ sky130_fd_sc_hd__xnor2_4
Xaccumulator._1288_ accumulator.io_accOut\[28\] accumulator._0386_ VGND VGND VPWR
+ VPWR accumulator._0387_ sky130_fd_sc_hd__or2_1
Xaccumulator._1357_ accumulator.io_inMant\[1\] accumulator.io_inMant\[2\] accumulator._0345_
+ VGND VGND VPWR VPWR accumulator._0454_ sky130_fd_sc_hd__mux2_1
XFILLER_0_25_225 VGND VGND VPWR VPWR sky130_fd_sc_hd__decap_4
XFILLER_0_68_15 VPWR VGND VPWR VGND sky130_ef_sc_hd__decap_12
XFILLER_0_40_228 VGND VGND VPWR VPWR sky130_fd_sc_hd__decap_4
XFILLER_0_21_420 VGND VGND VPWR VPWR sky130_fd_sc_hd__fill_1
XFILLER_0_7_29 VPWR VGND VPWR VGND sky130_ef_sc_hd__decap_12
XscaleAdd._414_ scaleAdd._303_ operator.io_outMant\[2\] scaleAdd._309_ VGND VGND VPWR
+ VPWR scaleAdd._356_ sky130_fd_sc_hd__and3_1
Xaccumulator._2260_ accumulator._0180_ accumulator._0193_ accumulator._0035_ VGND
+ VGND VPWR VPWR accumulator._0194_ sky130_fd_sc_hd__mux2_4
Xaccumulator._2191_ accumulator._0121_ accumulator._0125_ accumulator._0110_ VGND
+ VGND VPWR VPWR accumulator._0127_ sky130_fd_sc_hd__mux2_1
XFILLER_0_48_306 VGND VGND VPWR VPWR sky130_fd_sc_hd__fill_2
XTAP_TAPCELL_ROW_36_426 VGND VPWR sky130_fd_sc_hd__tapvpwrvgnd_1
XFILLER_0_33_51 VGND VGND VPWR VPWR sky130_fd_sc_hd__decap_4
Xaccumulator._1211_ accumulator.io_inExp\[4\] accumulator._0126_ VGND VGND VPWR VPWR
+ accumulator._0136_ sky130_fd_sc_hd__xor2_1
XFILLER_0_56_383 VPWR VGND VPWR VGND sky130_ef_sc_hd__decap_12
XTAP_TAPCELL_ROW_44_481 VGND VPWR sky130_fd_sc_hd__tapvpwrvgnd_1
Xaccumulator._1975_ accumulator._1062_ accumulator._1071_ VGND VGND VPWR VPWR accumulator._1072_
+ sky130_fd_sc_hd__xnor2_2
XFILLER_0_58_70 VGND VGND VPWR VPWR sky130_fd_sc_hd__fill_1
Xaccumulator._1409_ accumulator._0461_ VGND VGND VPWR VPWR accumulator._0506_ sky130_fd_sc_hd__inv_2
Xaccumulator._2389_ accumulator._0041_ accumulator._0316_ VGND VGND VPWR VPWR accumulator._0321_
+ sky130_fd_sc_hd__or2_1
XFILLER_0_38_29 VPWR VGND VPWR VGND sky130_ef_sc_hd__decap_12
XTAP_TAPCELL_ROW_58_584 VGND VPWR sky130_fd_sc_hd__tapvpwrvgnd_1
XPHY_EDGE_ROW_35_Left_106 VGND VGND VPWR VPWR sky130_fd_sc_hd__decap_3
XFILLER_0_70_27 VGND VGND VPWR VPWR sky130_fd_sc_hd__fill_1
XFILLER_0_57_169 VGND VGND VPWR VPWR sky130_fd_sc_hd__decap_4
XTAP_TAPCELL_ROW_41_462 VGND VPWR sky130_fd_sc_hd__tapvpwrvgnd_1
XFILLER_0_5_417 VGND VGND VPWR VPWR sky130_fd_sc_hd__decap_4
Xaccumulator._1760_ accumulator._0854_ accumulator._0856_ VGND VGND VPWR VPWR accumulator._0857_
+ sky130_fd_sc_hd__nand2_4
Xaccumulator._1691_ accumulator._0710_ accumulator._0711_ VGND VGND VPWR VPWR accumulator._0788_
+ sky130_fd_sc_hd__and2_1
XPHY_EDGE_ROW_44_Left_115 VGND VGND VPWR VPWR sky130_fd_sc_hd__decap_3
XFILLER_0_21_261 VGND VGND VPWR VPWR sky130_fd_sc_hd__decap_4
Xaccumulator._2312_ accumulator._0103_ accumulator._1137_ accumulator._0104_ accumulator._0072_
+ VGND VGND VPWR VPWR accumulator._0246_ sky130_fd_sc_hd__a31o_1
XPHY_EDGE_ROW_53_Left_124 VGND VGND VPWR VPWR sky130_fd_sc_hd__decap_3
Xaccumulator._2174_ accumulator._0060_ accumulator._0108_ accumulator._1149_ VGND
+ VGND VPWR VPWR accumulator._0109_ sky130_fd_sc_hd__mux2_2
Xaccumulator._2243_ accumulator._0128_ accumulator._0111_ accumulator._0053_ accumulator._0169_
+ accumulator._0397_ VGND VGND VPWR VPWR accumulator._0178_ sky130_fd_sc_hd__a41o_1
XFILLER_0_63_139 VGND VGND VPWR VPWR sky130_fd_sc_hd__fill_1
XPHY_EDGE_ROW_62_Left_133 VGND VGND VPWR VPWR sky130_fd_sc_hd__decap_3
XFILLER_0_44_375 VPWR VGND VPWR VGND sky130_ef_sc_hd__decap_12
XFILLER_0_44_342 VGND VGND VPWR VPWR sky130_fd_sc_hd__decap_8
Xaccumulator._1958_ accumulator._1054_ accumulator._1041_ VGND VGND VPWR VPWR accumulator._1055_
+ sky130_fd_sc_hd__nor2_1
Xaccumulator._1889_ accumulator._0976_ accumulator._0732_ VGND VGND VPWR VPWR accumulator._0986_
+ sky130_fd_sc_hd__and2_1
XTAP_TAPCELL_ROW_55_565 VGND VPWR sky130_fd_sc_hd__tapvpwrvgnd_1
XFILLER_0_54_139 VGND VGND VPWR VPWR sky130_fd_sc_hd__fill_1
XFILLER_0_54_106 VGND VGND VPWR VPWR sky130_fd_sc_hd__fill_2
XFILLER_0_39_169 VGND VGND VPWR VPWR sky130_fd_sc_hd__decap_3
XFILLER_0_39_158 VGND VGND VPWR VPWR sky130_fd_sc_hd__decap_8
XFILLER_0_35_342 VGND VGND VPWR VPWR sky130_fd_sc_hd__decap_8
XFILLER_0_35_320 VGND VGND VPWR VPWR sky130_fd_sc_hd__decap_8
XFILLER_0_50_389 VPWR VGND VPWR VGND sky130_ef_sc_hd__decap_12
XFILLER_0_50_356 VGND VGND VPWR VPWR sky130_fd_sc_hd__decap_8
XFILLER_0_49_39 VPWR VGND VPWR VGND sky130_ef_sc_hd__decap_12
XFILLER_0_10_209 VGND VGND VPWR VPWR sky130_fd_sc_hd__decap_8
XFILLER_0_65_27 VPWR VGND VPWR VGND sky130_ef_sc_hd__decap_12
XFILLER_0_14_53 VGND VGND VPWR VPWR sky130_fd_sc_hd__decap_4
XTAP_TAPCELL_ROW_18_289 VGND VPWR sky130_fd_sc_hd__tapvpwrvgnd_1
Xaccumulator._1812_ accumulator._0908_ VGND VGND VPWR VPWR accumulator._0909_ sky130_fd_sc_hd__dlymetal6s2s_1
XFILLER_0_30_85 VPWR VGND VPWR VGND sky130_ef_sc_hd__decap_12
XFILLER_0_30_41 VPWR VGND VPWR VGND sky130_ef_sc_hd__decap_12
XFILLER_0_5_269 VGND VGND VPWR VPWR sky130_fd_sc_hd__decap_8
XFILLER_0_14_97 VPWR VGND VPWR VGND sky130_ef_sc_hd__decap_12
Xaccumulator._1743_ accumulator._0830_ accumulator._0839_ VGND VGND VPWR VPWR accumulator._0840_
+ sky130_fd_sc_hd__nor2_1
Xaccumulator._1674_ accumulator._0428_ accumulator._0690_ accumulator._0770_ VGND
+ VGND VPWR VPWR accumulator._0771_ sky130_fd_sc_hd__o21ba_1
XFILLER_0_39_83 VGND VGND VPWR VPWR sky130_fd_sc_hd__decap_8
XTAP_TAPCELL_ROW_69_668 VGND VPWR sky130_fd_sc_hd__tapvpwrvgnd_1
Xaccumulator._2226_ accumulator._1056_ accumulator._1053_ accumulator._1181_ VGND
+ VGND VPWR VPWR accumulator._0161_ sky130_fd_sc_hd__mux2_1
XTAP_TAPCELL_ROW_1_157 VGND VPWR sky130_fd_sc_hd__tapvpwrvgnd_1
XTAP_TAPCELL_ROW_52_546 VGND VPWR sky130_fd_sc_hd__tapvpwrvgnd_1
Xaccumulator._2088_ accumulator._1132_ accumulator._1180_ accumulator._1185_ VGND
+ VGND VPWR VPWR accumulator._1186_ sky130_fd_sc_hd__a21oi_1
Xaccumulator._2157_ accumulator.io_accOut\[4\] accumulator._0091_ VGND VGND VPWR VPWR
+ accumulator._0092_ sky130_fd_sc_hd__and2_1
XFILLER_0_36_128 VPWR VGND VPWR VGND sky130_ef_sc_hd__decap_12
XFILLER_0_17_364 VPWR VGND VPWR VGND sky130_ef_sc_hd__decap_12
XFILLER_0_4_291 VPWR VGND VPWR VGND sky130_ef_sc_hd__decap_12
XFILLER_0_67_231 VGND VGND VPWR VPWR sky130_fd_sc_hd__fill_1
XFILLER_0_35_150 VGND VGND VPWR VPWR sky130_fd_sc_hd__decap_8
XscaleAdd._731_ scaleAdd._290_ scaleAdd._293_ scaleAdd._296_ VGND VGND VPWR VPWR scaleAdd._297_
+ sky130_fd_sc_hd__o21ai_1
XscaleAdd._662_ scaleAdd._312_ scaleAdd._188_ scaleAdd._234_ scaleAdd._313_ VGND VGND
+ VPWR VPWR scaleAdd._236_ sky130_fd_sc_hd__a22oi_1
XscaleAdd._593_ operator.io_outMant\[0\] scaleAdd._168_ scaleAdd._169_ VGND VGND VPWR
+ VPWR scaleAdd._170_ sky130_fd_sc_hd__and3_1
XFILLER_0_50_197 VGND VGND VPWR VPWR sky130_fd_sc_hd__decap_4
XFILLER_0_50_175 VPWR VGND VPWR VGND sky130_ef_sc_hd__decap_12
XFILLER_0_23_389 VGND VGND VPWR VPWR sky130_fd_sc_hd__decap_3
XTAP_TAPCELL_ROW_66_649 VGND VPWR sky130_fd_sc_hd__tapvpwrvgnd_1
Xaccumulator._1390_ accumulator._0478_ accumulator._0486_ accumulator._0451_ VGND
+ VGND VPWR VPWR accumulator._0487_ sky130_fd_sc_hd__a21o_1
Xaccumulator._2011_ accumulator._0887_ accumulator._1107_ VGND VGND VPWR VPWR accumulator._1108_
+ sky130_fd_sc_hd__xnor2_2
XFILLER_0_58_253 VGND VGND VPWR VPWR sky130_fd_sc_hd__decap_4
XFILLER_0_58_242 VGND VGND VPWR VPWR sky130_fd_sc_hd__decap_8
XFILLER_0_46_415 VGND VGND VPWR VPWR sky130_fd_sc_hd__fill_1
XFILLER_0_41_73 VGND VGND VPWR VPWR sky130_fd_sc_hd__fill_2
XFILLER_0_41_51 VGND VGND VPWR VPWR sky130_fd_sc_hd__decap_4
XFILLER_0_25_74 VGND VGND VPWR VPWR sky130_fd_sc_hd__fill_2
XFILLER_0_18_106 VGND VGND VPWR VPWR sky130_fd_sc_hd__decap_8
XFILLER_0_18_139 VGND VGND VPWR VPWR sky130_fd_sc_hd__fill_1
XFILLER_0_67_3 VPWR VGND VPWR VGND sky130_ef_sc_hd__decap_12
XFILLER_0_14_389 VPWR VGND VPWR VGND sky130_ef_sc_hd__decap_12
Xaccumulator._1657_ accumulator._0752_ accumulator._0753_ VGND VGND VPWR VPWR accumulator._0754_
+ sky130_fd_sc_hd__and2b_1
Xaccumulator._1726_ accumulator._0734_ accumulator._0773_ VGND VGND VPWR VPWR accumulator._0823_
+ sky130_fd_sc_hd__nand2_1
Xaccumulator._1588_ accumulator._0631_ accumulator._0632_ accumulator._0476_ VGND
+ VGND VPWR VPWR accumulator._0685_ sky130_fd_sc_hd__a21o_1
Xaccumulator._2209_ accumulator._1038_ accumulator._0036_ accumulator._0143_ accumulator._0072_
+ VGND VGND VPWR VPWR accumulator._0144_ sky130_fd_sc_hd__a211o_1
XFILLER_0_64_256 VGND VGND VPWR VPWR sky130_fd_sc_hd__decap_8
XFILLER_0_24_109 VGND VGND VPWR VPWR sky130_fd_sc_hd__fill_2
XFILLER_0_9_361 VPWR VGND VPWR VGND sky130_ef_sc_hd__decap_12
XFILLER_0_32_175 VPWR VGND VPWR VGND sky130_ef_sc_hd__decap_12
XFILLER_0_32_153 VGND VGND VPWR VPWR sky130_fd_sc_hd__fill_1
XFILLER_0_46_29 VPWR VGND VPWR VGND sky130_ef_sc_hd__decap_12
XTAP_TAPCELL_ROW_28_362 VGND VPWR sky130_fd_sc_hd__tapvpwrvgnd_1
XFILLER_0_15_109 VGND VGND VPWR VPWR sky130_fd_sc_hd__decap_3
XFILLER_0_70_237 VPWR VGND VPWR VGND sky130_ef_sc_hd__decap_12
XFILLER_0_23_164 VGND VGND VPWR VPWR sky130_fd_sc_hd__decap_4
XFILLER_0_23_120 VPWR VGND VPWR VGND sky130_ef_sc_hd__decap_12
XscaleAdd._714_ net15 net17 VGND VGND VPWR VPWR scaleAdd._282_ sky130_fd_sc_hd__nor2_1
XscaleAdd._645_ scaleAdd._108_ scaleAdd._196_ VGND VGND VPWR VPWR scaleAdd._220_ sky130_fd_sc_hd__nor2_1
XscaleAdd._576_ scaleAdd._330_ net64 VGND VGND VPWR VPWR scaleAdd._153_ sky130_fd_sc_hd__nand2_1
XFILLER_0_11_337 VPWR VGND VPWR VGND sky130_ef_sc_hd__decap_12
Xaccumulator._1442_ accumulator._0414_ VGND VGND VPWR VPWR accumulator._0539_ sky130_fd_sc_hd__buf_2
Xaccumulator._1511_ net72 accumulator._0577_ accumulator._0468_ VGND VGND VPWR VPWR
+ accumulator._0608_ sky130_fd_sc_hd__a21o_1
XPHY_EDGE_ROW_18_Right_18 VGND VGND VPWR VPWR sky130_fd_sc_hd__decap_3
Xaccumulator._1373_ accumulator._0433_ accumulator._0467_ accumulator._0469_ VGND
+ VGND VPWR VPWR accumulator._0470_ sky130_fd_sc_hd__a21o_1
Xinput3 io_inA[2] VGND VGND VPWR VPWR net3 sky130_fd_sc_hd__buf_1
XPHY_EDGE_ROW_27_Right_27 VGND VGND VPWR VPWR sky130_fd_sc_hd__decap_3
XFILLER_0_52_83 VGND VGND VPWR VPWR sky130_fd_sc_hd__fill_1
XFILLER_0_52_61 VGND VGND VPWR VPWR sky130_fd_sc_hd__fill_2
XFILLER_0_46_245 VGND VGND VPWR VPWR sky130_fd_sc_hd__decap_6
XPHY_EDGE_ROW_36_Right_36 VGND VGND VPWR VPWR sky130_fd_sc_hd__decap_3
XFILLER_0_14_153 VGND VGND VPWR VPWR sky130_fd_sc_hd__decap_8
Xaccumulator._1709_ accumulator._0803_ accumulator._0802_ VGND VGND VPWR VPWR accumulator._0806_
+ sky130_fd_sc_hd__and2b_1
XFILLER_0_69_337 VPWR VGND VPWR VGND sky130_ef_sc_hd__decap_12
XPHY_EDGE_ROW_45_Right_45 VGND VGND VPWR VPWR sky130_fd_sc_hd__decap_3
XFILLER_0_37_223 VGND VGND VPWR VPWR sky130_fd_sc_hd__fill_1
XTAP_TAPCELL_ROW_25_343 VGND VPWR sky130_fd_sc_hd__tapvpwrvgnd_1
Xoperator._29_ operator._10_ VGND VGND VPWR VPWR operator.io_outMant\[3\] sky130_fd_sc_hd__clkbuf_2
XPHY_EDGE_ROW_54_Right_54 VGND VGND VPWR VPWR sky130_fd_sc_hd__decap_3
XFILLER_0_52_248 VGND VGND VPWR VPWR sky130_fd_sc_hd__decap_4
XscaleAdd._430_ scaleAdd._332_ scaleAdd._004_ VGND VGND VPWR VPWR scaleAdd._011_ sky130_fd_sc_hd__nor2_1
XFILLER_0_57_39 VPWR VGND VPWR VGND sky130_ef_sc_hd__decap_12
X_01_ accumulator.io_accOut\[1\] VGND VGND VPWR VPWR net33 sky130_fd_sc_hd__buf_1
XscaleAdd._361_ net10 VGND VGND VPWR VPWR scaleAdd._307_ sky130_fd_sc_hd__buf_2
XPHY_EDGE_ROW_63_Right_63 VGND VGND VPWR VPWR sky130_fd_sc_hd__decap_3
Xaccumulator._1991_ accumulator._0998_ accumulator._1025_ accumulator._1087_ VGND
+ VGND VPWR VPWR accumulator._1088_ sky130_fd_sc_hd__o21a_1
XFILLER_0_28_234 VGND VGND VPWR VPWR sky130_fd_sc_hd__fill_1
XFILLER_0_22_75 VGND VGND VPWR VPWR sky130_fd_sc_hd__decap_8
XFILLER_0_51_281 VGND VGND VPWR VPWR sky130_fd_sc_hd__fill_2
XscaleAdd._559_ scaleAdd._135_ scaleAdd._136_ VGND VGND VPWR VPWR scaleAdd._137_ sky130_fd_sc_hd__nor2_2
XscaleAdd._628_ scaleAdd._184_ scaleAdd._185_ scaleAdd._203_ VGND VGND VPWR VPWR scaleAdd._204_
+ sky130_fd_sc_hd__and3_1
XFILLER_0_11_167 VGND VGND VPWR VPWR sky130_fd_sc_hd__fill_1
XTAP_TAPCELL_ROW_39_446 VGND VPWR sky130_fd_sc_hd__tapvpwrvgnd_1
Xaccumulator._1425_ accumulator._0415_ accumulator._0416_ accumulator._0403_ VGND
+ VGND VPWR VPWR accumulator._0522_ sky130_fd_sc_hd__o21a_2
XFILLER_0_66_307 VGND VGND VPWR VPWR sky130_fd_sc_hd__fill_1
Xaccumulator._1356_ accumulator._0085_ VGND VGND VPWR VPWR accumulator._0453_ sky130_fd_sc_hd__clkbuf_2
XFILLER_0_2_85 VGND VGND VPWR VPWR sky130_fd_sc_hd__decap_4
Xaccumulator._1287_ accumulator._0362_ accumulator._0385_ VGND VGND VPWR VPWR accumulator._0386_
+ sky130_fd_sc_hd__or2_1
XFILLER_0_19_223 VGND VGND VPWR VPWR sky130_fd_sc_hd__fill_1
XFILLER_0_34_226 VGND VGND VPWR VPWR sky130_fd_sc_hd__fill_1
XFILLER_0_65_340 VPWR VGND VPWR VGND sky130_ef_sc_hd__decap_12
XFILLER_0_68_27 VGND VGND VPWR VPWR sky130_fd_sc_hd__fill_1
XFILLER_0_0_337 VPWR VGND VPWR VGND sky130_ef_sc_hd__decap_12
XscaleAdd._413_ scaleAdd._325_ scaleAdd._354_ VGND VGND VPWR VPWR scaleAdd._355_ sky130_fd_sc_hd__xnor2_1
Xaccumulator._2190_ accumulator._0122_ accumulator._0124_ accumulator._0061_ VGND
+ VGND VPWR VPWR accumulator._0125_ sky130_fd_sc_hd__mux2_1
XTAP_TAPCELL_ROW_44_482 VGND VPWR sky130_fd_sc_hd__tapvpwrvgnd_1
Xaccumulator._1210_ accumulator._0055_ accumulator._0116_ VGND VGND VPWR VPWR accumulator._0126_
+ sky130_fd_sc_hd__nand2_2
Xaccumulator._1974_ accumulator._0992_ accumulator._1070_ VGND VGND VPWR VPWR accumulator._1071_
+ sky130_fd_sc_hd__or2_1
XFILLER_0_56_395 VGND VGND VPWR VPWR sky130_fd_sc_hd__decap_8
XFILLER_0_56_362 VGND VGND VPWR VPWR sky130_fd_sc_hd__fill_2
XFILLER_0_58_82 VGND VGND VPWR VPWR sky130_fd_sc_hd__fill_2
Xaccumulator._1408_ accumulator._0478_ accumulator._0504_ accumulator._0451_ VGND
+ VGND VPWR VPWR accumulator._0505_ sky130_fd_sc_hd__a21o_1
Xaccumulator._2388_ accumulator._0307_ accumulator._0311_ accumulator._0312_ accumulator._0300_
+ accumulator._0317_ VGND VGND VPWR VPWR accumulator._0320_ sky130_fd_sc_hd__o221ai_2
XFILLER_0_62_332 VGND VGND VPWR VPWR sky130_fd_sc_hd__fill_1
XPHY_EDGE_ROW_0_Right_0 VGND VGND VPWR VPWR sky130_fd_sc_hd__decap_3
Xaccumulator._1339_ accumulator._0345_ VGND VGND VPWR VPWR accumulator._0436_ sky130_fd_sc_hd__clkbuf_4
XFILLER_0_54_29 VPWR VGND VPWR VGND sky130_ef_sc_hd__decap_12
XTAP_TAPCELL_ROW_58_585 VGND VPWR sky130_fd_sc_hd__tapvpwrvgnd_1
XFILLER_0_65_181 VGND VGND VPWR VPWR sky130_fd_sc_hd__decap_8
XTAP_TAPCELL_ROW_41_463 VGND VPWR sky130_fd_sc_hd__tapvpwrvgnd_1
Xaccumulator._1690_ accumulator._0525_ accumulator._0610_ VGND VGND VPWR VPWR accumulator._0787_
+ sky130_fd_sc_hd__nand2_1
XFILLER_0_28_41 VPWR VGND VPWR VGND sky130_ef_sc_hd__decap_12
XFILLER_0_0_167 VGND VGND VPWR VPWR sky130_fd_sc_hd__fill_1
Xaccumulator._2311_ accumulator._0118_ accumulator._0098_ accumulator._0243_ accumulator._0236_
+ VGND VGND VPWR VPWR accumulator._0245_ sky130_fd_sc_hd__a211o_1
Xaccumulator._2242_ accumulator.io_accOut\[12\] accumulator._0167_ accumulator._0170_
+ accumulator._0175_ accumulator._0177_ VGND VGND VPWR VPWR accumulator._0014_ sky130_fd_sc_hd__o221a_1
XFILLER_0_28_85 VPWR VGND VPWR VGND sky130_ef_sc_hd__decap_12
XFILLER_0_60_61 VGND VGND VPWR VPWR sky130_fd_sc_hd__fill_2
Xaccumulator._2173_ accumulator._0082_ accumulator._0107_ accumulator._0035_ VGND
+ VGND VPWR VPWR accumulator._0108_ sky130_fd_sc_hd__mux2_1
XFILLER_0_44_321 VGND VGND VPWR VPWR sky130_fd_sc_hd__decap_6
XFILLER_0_44_95 VGND VGND VPWR VPWR sky130_fd_sc_hd__decap_4
XFILLER_0_8_234 VGND VGND VPWR VPWR sky130_fd_sc_hd__fill_2
XFILLER_0_69_81 VPWR VGND VPWR VGND sky130_ef_sc_hd__decap_12
Xaccumulator._1957_ accumulator._0992_ VGND VGND VPWR VPWR accumulator._1054_ sky130_fd_sc_hd__buf_2
XFILLER_0_44_387 VGND VGND VPWR VPWR sky130_fd_sc_hd__decap_4
XFILLER_0_44_365 VGND VGND VPWR VPWR sky130_fd_sc_hd__fill_1
XFILLER_0_12_251 VGND VGND VPWR VPWR sky130_fd_sc_hd__fill_1
Xaccumulator._1888_ accumulator._0931_ accumulator._0984_ VGND VGND VPWR VPWR accumulator._0985_
+ sky130_fd_sc_hd__xnor2_2
XFILLER_0_12_284 VPWR VGND VPWR VGND sky130_ef_sc_hd__decap_12
XTAP_TAPCELL_ROW_55_566 VGND VPWR sky130_fd_sc_hd__tapvpwrvgnd_1
XFILLER_0_65_39 VPWR VGND VPWR VGND sky130_ef_sc_hd__decap_12
XTAP_TAPCELL_ROW_46_500 VGND VPWR sky130_fd_sc_hd__tapvpwrvgnd_1
XFILLER_0_45_129 VGND VGND VPWR VPWR sky130_fd_sc_hd__decap_8
Xaccumulator._1811_ accumulator._0906_ accumulator._0907_ VGND VGND VPWR VPWR accumulator._0908_
+ sky130_fd_sc_hd__or2_1
XFILLER_0_41_335 VGND VGND VPWR VPWR sky130_fd_sc_hd__fill_1
XFILLER_0_30_97 VGND VGND VPWR VPWR sky130_fd_sc_hd__decap_6
XFILLER_0_30_53 VPWR VGND VPWR VGND sky130_ef_sc_hd__decap_12
XFILLER_0_26_398 VGND VGND VPWR VPWR sky130_fd_sc_hd__decap_4
XTAP_TAPCELL_ROW_69_669 VGND VPWR sky130_fd_sc_hd__tapvpwrvgnd_1
Xaccumulator._1742_ accumulator._0811_ accumulator._0812_ VGND VGND VPWR VPWR accumulator._0839_
+ sky130_fd_sc_hd__and2b_1
Xaccumulator._1673_ accumulator._0558_ accumulator._0685_ accumulator._0686_ accumulator._0553_
+ VGND VGND VPWR VPWR accumulator._0770_ sky130_fd_sc_hd__a31o_1
XFILLER_0_39_51 VGND VGND VPWR VPWR sky130_fd_sc_hd__decap_4
XPHY_EDGE_ROW_18_Left_89 VGND VGND VPWR VPWR sky130_fd_sc_hd__decap_3
Xaccumulator._2225_ accumulator._1038_ accumulator._0051_ accumulator._0143_ VGND
+ VGND VPWR VPWR accumulator._0160_ sky130_fd_sc_hd__a21oi_1
Xaccumulator._2156_ accumulator._0396_ VGND VGND VPWR VPWR accumulator._0091_ sky130_fd_sc_hd__buf_2
XTAP_TAPCELL_ROW_1_158 VGND VPWR sky130_fd_sc_hd__tapvpwrvgnd_1
XFILLER_0_12_3 VGND VGND VPWR VPWR sky130_fd_sc_hd__decap_8
Xaccumulator._2087_ accumulator._1159_ accumulator._1160_ VGND VGND VPWR VPWR accumulator._1185_
+ sky130_fd_sc_hd__nor2_1
XFILLER_0_29_181 VGND VGND VPWR VPWR sky130_fd_sc_hd__decap_3
XFILLER_0_17_343 VGND VGND VPWR VPWR sky130_fd_sc_hd__fill_1
XFILLER_0_17_376 VGND VGND VPWR VPWR sky130_fd_sc_hd__decap_6
XFILLER_0_55_416 VGND VGND VPWR VPWR sky130_fd_sc_hd__fill_1
XscaleAdd._730_ operator.io_outExp\[2\] scaleAdd._295_ VGND VGND VPWR VPWR scaleAdd._296_
+ sky130_fd_sc_hd__xnor2_1
XFILLER_0_23_379 VGND VGND VPWR VPWR sky130_fd_sc_hd__fill_2
XscaleAdd._661_ scaleAdd._312_ scaleAdd._170_ scaleAdd._234_ VGND VGND VPWR VPWR scaleAdd._235_
+ sky130_fd_sc_hd__and3_1
XscaleAdd._592_ scaleAdd._136_ scaleAdd._167_ scaleAdd._166_ VGND VGND VPWR VPWR scaleAdd._169_
+ sky130_fd_sc_hd__o21ai_1
XFILLER_0_50_187 VGND VGND VPWR VPWR sky130_fd_sc_hd__decap_8
Xaccumulator._2010_ accumulator._0923_ accumulator._0960_ accumulator._1106_ accumulator._1102_
+ VGND VGND VPWR VPWR accumulator._1107_ sky130_fd_sc_hd__o31a_1
XFILLER_0_58_221 VGND VGND VPWR VPWR sky130_fd_sc_hd__decap_4
XFILLER_0_25_42 VGND VGND VPWR VPWR sky130_fd_sc_hd__decap_4
XFILLER_0_58_287 VPWR VGND VPWR VGND sky130_ef_sc_hd__decap_12
XTAP_TAPCELL_ROW_14_260 VGND VPWR sky130_fd_sc_hd__tapvpwrvgnd_1
Xaccumulator._1725_ accumulator._0819_ accumulator._0821_ VGND VGND VPWR VPWR accumulator._0822_
+ sky130_fd_sc_hd__and2_1
XFILLER_0_41_154 VGND VGND VPWR VPWR sky130_fd_sc_hd__decap_3
XFILLER_0_26_195 VGND VGND VPWR VPWR sky130_fd_sc_hd__fill_1
XFILLER_0_14_335 VGND VGND VPWR VPWR sky130_fd_sc_hd__fill_1
Xaccumulator._1656_ accumulator._0751_ accumulator._0750_ VGND VGND VPWR VPWR accumulator._0753_
+ sky130_fd_sc_hd__or2b_1
Xaccumulator._1587_ accumulator._0682_ accumulator._0683_ VGND VGND VPWR VPWR accumulator._0684_
+ sky130_fd_sc_hd__and2_1
XFILLER_0_5_74 VGND VGND VPWR VPWR sky130_fd_sc_hd__decap_4
Xaccumulator._2208_ accumulator._1031_ accumulator._0103_ accumulator._0104_ VGND
+ VGND VPWR VPWR accumulator._0143_ sky130_fd_sc_hd__and3_1
Xaccumulator._2139_ accumulator._1183_ accumulator._0051_ accumulator._0052_ accumulator._1196_
+ VGND VGND VPWR VPWR accumulator._0073_ sky130_fd_sc_hd__a211o_1
XFILLER_0_37_405 VPWR VGND VPWR VGND sky130_ef_sc_hd__decap_12
XFILLER_0_9_373 VPWR VGND VPWR VGND sky130_ef_sc_hd__decap_12
XFILLER_0_1_3 VPWR VGND VPWR VGND sky130_ef_sc_hd__decap_12
XFILLER_0_13_390 VGND VGND VPWR VPWR sky130_fd_sc_hd__fill_2
XFILLER_0_20_338 VPWR VGND VPWR VGND sky130_ef_sc_hd__decap_12
XFILLER_0_62_29 VPWR VGND VPWR VGND sky130_ef_sc_hd__decap_12
XTAP_TAPCELL_ROW_28_363 VGND VPWR sky130_fd_sc_hd__tapvpwrvgnd_1
XFILLER_0_55_279 VGND VGND VPWR VPWR sky130_fd_sc_hd__fill_1
XscaleAdd._713_ scaleAdd._280_ VGND VGND VPWR VPWR scaleAdd._281_ sky130_fd_sc_hd__dlymetal6s2s_1
XFILLER_0_70_249 VGND VGND VPWR VPWR sky130_fd_sc_hd__decap_3
XFILLER_0_23_132 VGND VGND VPWR VPWR sky130_fd_sc_hd__decap_3
XscaleAdd._644_ scaleAdd._218_ scaleAdd._210_ VGND VGND VPWR VPWR scaleAdd._219_ sky130_fd_sc_hd__xor2_1
XscaleAdd._575_ scaleAdd._151_ scaleAdd._152_ VGND VGND VPWR VPWR accumulator.io_inMant\[9\]
+ sky130_fd_sc_hd__nand2_1
XFILLER_0_11_55 VGND VGND VPWR VPWR sky130_fd_sc_hd__fill_1
XFILLER_0_11_305 VPWR VGND VPWR VGND sky130_ef_sc_hd__decap_12
XFILLER_0_11_349 VPWR VGND VPWR VGND sky130_ef_sc_hd__decap_12
Xaccumulator._1372_ accumulator._0468_ VGND VGND VPWR VPWR accumulator._0469_ sky130_fd_sc_hd__buf_2
XFILLER_0_36_41 VPWR VGND VPWR VGND sky130_ef_sc_hd__decap_12
Xaccumulator._1510_ net72 accumulator._0596_ accumulator._0414_ VGND VGND VPWR VPWR
+ accumulator._0607_ sky130_fd_sc_hd__a21o_1
Xaccumulator._1441_ accumulator.io_accOut\[9\] accumulator._0537_ net78 VGND VGND
+ VPWR VPWR accumulator._0538_ sky130_fd_sc_hd__mux2_1
Xinput4 io_inA[3] VGND VGND VPWR VPWR net4 sky130_fd_sc_hd__buf_1
XTAP_TAPCELL_ROW_62_620 VGND VPWR sky130_fd_sc_hd__tapvpwrvgnd_1
XFILLER_0_46_224 VGND VGND VPWR VPWR sky130_fd_sc_hd__decap_3
XFILLER_0_19_416 VGND VGND VPWR VPWR sky130_fd_sc_hd__fill_1
XFILLER_0_34_419 VGND VGND VPWR VPWR sky130_fd_sc_hd__fill_1
XFILLER_0_6_321 VPWR VGND VPWR VGND sky130_ef_sc_hd__decap_12
XFILLER_0_6_365 VPWR VGND VPWR VGND sky130_ef_sc_hd__decap_12
Xaccumulator._1708_ accumulator._0799_ accumulator._0804_ VGND VGND VPWR VPWR accumulator._0805_
+ sky130_fd_sc_hd__nand2_1
XFILLER_0_14_176 VPWR VGND VPWR VGND sky130_ef_sc_hd__decap_12
XFILLER_0_69_349 VPWR VGND VPWR VGND sky130_ef_sc_hd__decap_12
Xaccumulator._1639_ accumulator._0733_ accumulator._0735_ VGND VGND VPWR VPWR accumulator._0736_
+ sky130_fd_sc_hd__and2_1
Xoperator._28_ net1 operator._07_ operator._06_ VGND VGND VPWR VPWR operator._10_
+ sky130_fd_sc_hd__and3_1
XFILLER_0_45_290 VGND VGND VPWR VPWR sky130_fd_sc_hd__fill_1
XscaleAdd._360_ net9 VGND VGND VPWR VPWR scaleAdd._303_ sky130_fd_sc_hd__buf_2
XFILLER_0_20_124 VPWR VGND VPWR VGND sky130_ef_sc_hd__decap_12
X_00_ accumulator.io_accOut\[0\] VGND VGND VPWR VPWR net22 sky130_fd_sc_hd__buf_1
Xaccumulator._1990_ accumulator._1040_ accumulator._1057_ accumulator._1081_ accumulator._1086_
+ VGND VGND VPWR VPWR accumulator._1087_ sky130_fd_sc_hd__and4_1
XFILLER_0_28_268 VPWR VGND VPWR VGND sky130_ef_sc_hd__decap_12
XFILLER_0_7_118 VPWR VGND VPWR VGND sky130_ef_sc_hd__decap_12
XscaleAdd._558_ scaleAdd._126_ scaleAdd._134_ VGND VGND VPWR VPWR scaleAdd._136_ sky130_fd_sc_hd__nor2_1
XscaleAdd._627_ scaleAdd._186_ scaleAdd._202_ VGND VGND VPWR VPWR scaleAdd._203_ sky130_fd_sc_hd__xnor2_1
XscaleAdd._489_ scaleAdd._067_ scaleAdd._068_ VGND VGND VPWR VPWR scaleAdd._069_ sky130_fd_sc_hd__xor2_1
XFILLER_0_47_84 VGND VGND VPWR VPWR sky130_fd_sc_hd__decap_6
XFILLER_0_47_51 VGND VGND VPWR VPWR sky130_fd_sc_hd__decap_4
Xaccumulator._1424_ accumulator._0501_ accumulator._0511_ accumulator._0520_ VGND
+ VGND VPWR VPWR accumulator._0521_ sky130_fd_sc_hd__and3_1
XTAP_TAPCELL_ROW_39_447 VGND VPWR sky130_fd_sc_hd__tapvpwrvgnd_1
Xaccumulator._1355_ accumulator._0433_ accumulator._0450_ accumulator._0451_ VGND
+ VGND VPWR VPWR accumulator._0452_ sky130_fd_sc_hd__a21o_1
XFILLER_0_59_393 VPWR VGND VPWR VGND sky130_ef_sc_hd__decap_12
XTAP_TAPCELL_ROW_22_314 VGND VPWR sky130_fd_sc_hd__tapvpwrvgnd_1
Xaccumulator._1286_ net62 accumulator._0343_ VGND VGND VPWR VPWR accumulator._0385_
+ sky130_fd_sc_hd__nor2_1
XFILLER_0_42_282 VGND VGND VPWR VPWR sky130_fd_sc_hd__fill_1
XTAP_TAPCELL_ROW_30_380 VGND VPWR sky130_fd_sc_hd__tapvpwrvgnd_1
XFILLER_0_6_195 VGND VGND VPWR VPWR sky130_fd_sc_hd__fill_1
XFILLER_0_69_113 VGND VGND VPWR VPWR sky130_fd_sc_hd__decap_6
XPHY_EDGE_ROW_6_Left_77 VGND VGND VPWR VPWR sky130_fd_sc_hd__decap_3
Xmax_cap55 scaleAdd._322_ VGND VGND VPWR VPWR net55 sky130_fd_sc_hd__clkbuf_2
XFILLER_0_65_352 VPWR VGND VPWR VGND sky130_ef_sc_hd__decap_12
XFILLER_0_25_205 VGND VGND VPWR VPWR sky130_fd_sc_hd__decap_6
XFILLER_0_21_411 VGND VGND VPWR VPWR sky130_fd_sc_hd__fill_1
XFILLER_0_0_349 VPWR VGND VPWR VGND sky130_ef_sc_hd__decap_12
XFILLER_0_0_305 VGND VGND VPWR VPWR sky130_fd_sc_hd__decap_3
XscaleAdd._412_ scaleAdd._352_ scaleAdd._353_ VGND VGND VPWR VPWR scaleAdd._354_ sky130_fd_sc_hd__xnor2_1
XFILLER_0_17_43 VPWR VGND VPWR VGND sky130_ef_sc_hd__decap_12
XFILLER_0_68_190 VGND VGND VPWR VPWR sky130_fd_sc_hd__decap_6
XTAP_TAPCELL_ROW_44_483 VGND VPWR sky130_fd_sc_hd__tapvpwrvgnd_1
XFILLER_0_33_97 VGND VGND VPWR VPWR sky130_fd_sc_hd__fill_1
Xaccumulator._1973_ accumulator._1063_ accumulator._1066_ accumulator._1069_ VGND
+ VGND VPWR VPWR accumulator._1070_ sky130_fd_sc_hd__and3_1
XFILLER_0_58_94 VGND VGND VPWR VPWR sky130_fd_sc_hd__decap_6
XFILLER_0_42_3 VPWR VGND VPWR VGND sky130_ef_sc_hd__decap_12
Xaccumulator._1407_ accumulator.io_accOut\[13\] accumulator._0503_ accumulator._0485_
+ VGND VGND VPWR VPWR accumulator._0504_ sky130_fd_sc_hd__mux2_1
Xaccumulator._1338_ accumulator._0055_ net80 VGND VGND VPWR VPWR accumulator._0435_
+ sky130_fd_sc_hd__nor2_2
Xaccumulator._2387_ accumulator._0398_ accumulator._0318_ accumulator._0319_ accumulator._0177_
+ VGND VGND VPWR VPWR accumulator._0031_ sky130_fd_sc_hd__o211a_1
XFILLER_0_66_149 VGND VGND VPWR VPWR sky130_fd_sc_hd__fill_1
XFILLER_0_47_396 VGND VGND VPWR VPWR sky130_fd_sc_hd__decap_8
Xaccumulator._1269_ accumulator.io_accOut\[25\] accumulator._0367_ VGND VGND VPWR
+ VPWR accumulator._0368_ sky130_fd_sc_hd__xor2_4
XFILLER_0_70_29 VPWR VGND VPWR VGND sky130_ef_sc_hd__decap_12
XTAP_TAPCELL_ROW_58_586 VGND VPWR sky130_fd_sc_hd__tapvpwrvgnd_1
XFILLER_0_57_149 VPWR VGND VPWR VGND sky130_ef_sc_hd__decap_12
XFILLER_0_57_116 VGND VGND VPWR VPWR sky130_fd_sc_hd__decap_4
XFILLER_0_53_377 VGND VGND VPWR VPWR sky130_fd_sc_hd__fill_1
XFILLER_0_38_385 VGND VGND VPWR VPWR sky130_fd_sc_hd__decap_3
XFILLER_0_28_75 VGND VGND VPWR VPWR sky130_fd_sc_hd__fill_2
XFILLER_0_28_53 VPWR VGND VPWR VGND sky130_ef_sc_hd__decap_12
XFILLER_0_0_113 VPWR VGND VPWR VGND sky130_ef_sc_hd__decap_12
Xaccumulator._2172_ accumulator._0094_ accumulator._0051_ accumulator._0106_ VGND
+ VGND VPWR VPWR accumulator._0107_ sky130_fd_sc_hd__o21a_1
XTAP_TAPCELL_ROW_49_520 VGND VPWR sky130_fd_sc_hd__tapvpwrvgnd_1
XFILLER_0_44_41 VPWR VGND VPWR VGND sky130_ef_sc_hd__decap_12
Xaccumulator._2310_ accumulator._1142_ accumulator._0099_ VGND VGND VPWR VPWR accumulator._0243_
+ sky130_fd_sc_hd__nor2_1
Xaccumulator._2241_ accumulator._0399_ VGND VGND VPWR VPWR accumulator._0177_ sky130_fd_sc_hd__buf_2
XFILLER_0_28_97 VPWR VGND VPWR VGND sky130_ef_sc_hd__decap_12
XFILLER_0_48_149 VGND VGND VPWR VPWR sky130_fd_sc_hd__decap_4
XFILLER_0_8_202 VGND VGND VPWR VPWR sky130_fd_sc_hd__decap_8
XFILLER_0_69_93 VGND VGND VPWR VPWR sky130_fd_sc_hd__decap_4
Xaccumulator._1956_ accumulator._1052_ VGND VGND VPWR VPWR accumulator._1053_ sky130_fd_sc_hd__inv_2
Xaccumulator._1887_ accumulator._0918_ accumulator._0982_ accumulator._0983_ VGND
+ VGND VPWR VPWR accumulator._0984_ sky130_fd_sc_hd__a21bo_1
XFILLER_0_8_85 VGND VGND VPWR VPWR sky130_fd_sc_hd__decap_4
XFILLER_0_12_296 VPWR VGND VPWR VGND sky130_ef_sc_hd__decap_12
XTAP_TAPCELL_ROW_55_567 VGND VPWR sky130_fd_sc_hd__tapvpwrvgnd_1
XFILLER_0_54_119 VGND VGND VPWR VPWR sky130_fd_sc_hd__fill_2
XFILLER_0_62_141 VGND VGND VPWR VPWR sky130_fd_sc_hd__decap_8
XFILLER_0_35_399 VGND VGND VPWR VPWR sky130_fd_sc_hd__decap_8
Xclone21 accumulator._0393_ VGND VGND VPWR VPWR net78 sky130_fd_sc_hd__buf_4
XTAP_TAPCELL_ROW_46_501 VGND VPWR sky130_fd_sc_hd__tapvpwrvgnd_1
XFILLER_0_38_193 VGND VGND VPWR VPWR sky130_fd_sc_hd__decap_3
XFILLER_0_5_205 VGND VGND VPWR VPWR sky130_fd_sc_hd__decap_6
XPHY_EDGE_ROW_9_Left_80 VGND VGND VPWR VPWR sky130_fd_sc_hd__decap_3
Xaccumulator._1810_ accumulator._0905_ accumulator._0904_ VGND VGND VPWR VPWR accumulator._0907_
+ sky130_fd_sc_hd__and2b_1
Xaccumulator._1741_ accumulator._0815_ accumulator._0829_ accumulator._0830_ accumulator._0837_
+ VGND VGND VPWR VPWR accumulator._0838_ sky130_fd_sc_hd__or4b_1
XFILLER_0_41_358 VGND VGND VPWR VPWR sky130_fd_sc_hd__decap_4
XFILLER_0_30_65 VGND VGND VPWR VPWR sky130_fd_sc_hd__decap_8
XFILLER_0_55_51 VGND VGND VPWR VPWR sky130_fd_sc_hd__decap_4
Xaccumulator._1672_ accumulator._0523_ accumulator._0767_ accumulator._0768_ VGND
+ VGND VPWR VPWR accumulator._0769_ sky130_fd_sc_hd__nor3_1
Xaccumulator._2224_ accumulator._0096_ accumulator._0158_ accumulator._0061_ VGND
+ VGND VPWR VPWR accumulator._0159_ sky130_fd_sc_hd__mux2_2
Xaccumulator._2155_ accumulator._0080_ accumulator._0084_ accumulator._0088_ accumulator._0089_
+ VGND VGND VPWR VPWR accumulator._0090_ sky130_fd_sc_hd__o211a_1
XTAP_TAPCELL_ROW_1_159 VGND VPWR sky130_fd_sc_hd__tapvpwrvgnd_1
XTAP_TAPCELL_ROW_17_280 VGND VPWR sky130_fd_sc_hd__tapvpwrvgnd_1
Xaccumulator._2086_ accumulator._1181_ VGND VGND VPWR VPWR accumulator._1184_ sky130_fd_sc_hd__buf_8
XFILLER_0_44_141 VGND VGND VPWR VPWR sky130_fd_sc_hd__decap_4
XFILLER_0_44_130 VGND VGND VPWR VPWR sky130_fd_sc_hd__fill_2
XFILLER_0_32_303 VGND VGND VPWR VPWR sky130_fd_sc_hd__decap_4
XFILLER_0_29_160 VGND VGND VPWR VPWR sky130_fd_sc_hd__decap_8
Xaccumulator._1939_ accumulator._0942_ accumulator._1035_ VGND VGND VPWR VPWR accumulator._1036_
+ sky130_fd_sc_hd__xnor2_2
XFILLER_0_67_277 VGND VGND VPWR VPWR sky130_fd_sc_hd__decap_3
XFILLER_0_27_108 VGND VGND VPWR VPWR sky130_fd_sc_hd__decap_4
XscaleAdd._591_ scaleAdd._136_ scaleAdd._166_ scaleAdd._167_ VGND VGND VPWR VPWR scaleAdd._168_
+ sky130_fd_sc_hd__or3_1
XFILLER_0_2_208 VGND VGND VPWR VPWR sky130_fd_sc_hd__fill_1
XscaleAdd._660_ scaleAdd._337_ scaleAdd._214_ scaleAdd._085_ VGND VGND VPWR VPWR scaleAdd._234_
+ sky130_fd_sc_hd__o21a_1
XFILLER_0_25_87 VGND VGND VPWR VPWR sky130_fd_sc_hd__decap_4
XFILLER_0_58_299 VGND VGND VPWR VPWR sky130_fd_sc_hd__decap_8
XFILLER_0_41_111 VGND VGND VPWR VPWR sky130_fd_sc_hd__fill_1
XFILLER_0_26_141 VGND VGND VPWR VPWR sky130_fd_sc_hd__decap_8
XTAP_TAPCELL_ROW_14_261 VGND VPWR sky130_fd_sc_hd__tapvpwrvgnd_1
XFILLER_0_41_166 VGND VGND VPWR VPWR sky130_fd_sc_hd__fill_2
Xaccumulator._1724_ accumulator.io_accOut\[10\] accumulator._0403_ accumulator._0820_
+ VGND VGND VPWR VPWR accumulator._0821_ sky130_fd_sc_hd__o21ai_2
XFILLER_0_1_274 VGND VGND VPWR VPWR sky130_fd_sc_hd__decap_6
XFILLER_0_66_83 VGND VGND VPWR VPWR sky130_fd_sc_hd__fill_1
XTAP_TAPCELL_ROW_65_640 VGND VPWR sky130_fd_sc_hd__tapvpwrvgnd_1
Xaccumulator._1655_ accumulator._0750_ accumulator._0751_ VGND VGND VPWR VPWR accumulator._0752_
+ sky130_fd_sc_hd__and2b_1
Xaccumulator._1586_ accumulator._0628_ accumulator._0629_ accumulator._0498_ VGND
+ VGND VPWR VPWR accumulator._0683_ sky130_fd_sc_hd__a21o_1
XPHY_EDGE_ROW_59_Left_130 VGND VGND VPWR VPWR sky130_fd_sc_hd__decap_3
Xaccumulator._2138_ accumulator._1197_ VGND VGND VPWR VPWR accumulator._0072_ sky130_fd_sc_hd__buf_2
Xaccumulator._2069_ accumulator._1159_ accumulator._1160_ accumulator._1164_ accumulator._1165_
+ VGND VGND VPWR VPWR accumulator._1166_ sky130_fd_sc_hd__o211a_1
Xaccumulator._2207_ accumulator._0120_ accumulator._0122_ accumulator._0111_ VGND
+ VGND VPWR VPWR accumulator._0142_ sky130_fd_sc_hd__mux2_1
XFILLER_0_9_385 VGND VGND VPWR VPWR sky130_fd_sc_hd__decap_6
XTAP_TAPCELL_ROW_28_364 VGND VPWR sky130_fd_sc_hd__tapvpwrvgnd_1
XFILLER_0_55_247 VGND VGND VPWR VPWR sky130_fd_sc_hd__fill_1
XFILLER_0_55_225 VPWR VGND VPWR VGND sky130_ef_sc_hd__decap_12
XscaleAdd._712_ net15 net17 VGND VGND VPWR VPWR scaleAdd._280_ sky130_fd_sc_hd__and2_1
XscaleAdd._643_ scaleAdd._211_ scaleAdd._217_ VGND VGND VPWR VPWR scaleAdd._218_ sky130_fd_sc_hd__xnor2_2
XscaleAdd._574_ scaleAdd._120_ scaleAdd._118_ scaleAdd._149_ scaleAdd._150_ VGND VGND
+ VPWR VPWR scaleAdd._152_ sky130_fd_sc_hd__or4_1
XFILLER_0_11_317 VPWR VGND VPWR VGND sky130_ef_sc_hd__decap_12
XFILLER_0_36_53 VGND VGND VPWR VPWR sky130_fd_sc_hd__decap_6
Xaccumulator._1371_ accumulator._0373_ accumulator._0412_ VGND VGND VPWR VPWR accumulator._0468_
+ sky130_fd_sc_hd__nand2_2
Xaccumulator._1440_ accumulator._0434_ accumulator._0453_ accumulator._0440_ VGND
+ VGND VPWR VPWR accumulator._0537_ sky130_fd_sc_hd__and3_1
Xinput5 io_inB[0] VGND VGND VPWR VPWR net5 sky130_fd_sc_hd__clkbuf_1
XTAP_TAPCELL_ROW_62_621 VGND VPWR sky130_fd_sc_hd__tapvpwrvgnd_1
XFILLER_0_52_85 VGND VGND VPWR VPWR sky130_fd_sc_hd__decap_8
XFILLER_0_52_41 VPWR VGND VPWR VGND sky130_ef_sc_hd__decap_12
XFILLER_0_6_333 VPWR VGND VPWR VGND sky130_ef_sc_hd__decap_12
XFILLER_0_6_377 VPWR VGND VPWR VGND sky130_ef_sc_hd__decap_12
XFILLER_0_14_188 VGND VGND VPWR VPWR sky130_fd_sc_hd__decap_8
Xaccumulator._1707_ accumulator._0802_ accumulator._0803_ VGND VGND VPWR VPWR accumulator._0804_
+ sky130_fd_sc_hd__and2b_1
Xaccumulator._1638_ accumulator._0734_ accumulator._0702_ VGND VGND VPWR VPWR accumulator._0735_
+ sky130_fd_sc_hd__nor2_1
Xaccumulator._1569_ accumulator._0497_ accumulator._0487_ accumulator._0496_ VGND
+ VGND VPWR VPWR accumulator._0666_ sky130_fd_sc_hd__and3_1
Xoperator._27_ operator._09_ VGND VGND VPWR VPWR operator.io_outMant\[2\] sky130_fd_sc_hd__clkbuf_2
XFILLER_0_9_182 VGND VGND VPWR VPWR sky130_fd_sc_hd__fill_1
XFILLER_0_20_136 VGND VGND VPWR VPWR sky130_fd_sc_hd__decap_4
XFILLER_0_28_247 VGND VGND VPWR VPWR sky130_fd_sc_hd__decap_4
XFILLER_0_36_280 VGND VGND VPWR VPWR sky130_fd_sc_hd__fill_1
XscaleAdd._626_ scaleAdd._199_ scaleAdd._201_ VGND VGND VPWR VPWR scaleAdd._202_ sky130_fd_sc_hd__xnor2_1
XPHY_EDGE_ROW_22_Left_93 VGND VGND VPWR VPWR sky130_fd_sc_hd__decap_3
XscaleAdd._557_ scaleAdd._126_ scaleAdd._134_ VGND VGND VPWR VPWR scaleAdd._135_ sky130_fd_sc_hd__and2_1
XscaleAdd._488_ operator.io_outMant\[2\] scaleAdd._350_ VGND VGND VPWR VPWR scaleAdd._068_
+ sky130_fd_sc_hd__nand2_1
XFILLER_0_66_309 VGND VGND VPWR VPWR sky130_fd_sc_hd__fill_1
XFILLER_0_63_51 VGND VGND VPWR VPWR sky130_fd_sc_hd__decap_4
XTAP_TAPCELL_ROW_39_448 VGND VPWR sky130_fd_sc_hd__tapvpwrvgnd_1
Xaccumulator._1423_ accumulator._0515_ accumulator._0519_ accumulator._0497_ VGND
+ VGND VPWR VPWR accumulator._0520_ sky130_fd_sc_hd__a21o_1
Xaccumulator._1354_ accumulator._0414_ VGND VGND VPWR VPWR accumulator._0451_ sky130_fd_sc_hd__buf_2
Xaccumulator._1285_ accumulator._0361_ accumulator._0383_ accumulator._0358_ VGND
+ VGND VPWR VPWR accumulator._0384_ sky130_fd_sc_hd__a21o_4
XFILLER_0_34_206 VPWR VGND VPWR VGND sky130_ef_sc_hd__decap_12
XTAP_TAPCELL_ROW_22_315 VGND VPWR sky130_fd_sc_hd__tapvpwrvgnd_1
XFILLER_0_19_225 VGND VGND VPWR VPWR sky130_fd_sc_hd__decap_4
XTAP_TAPCELL_ROW_30_381 VGND VPWR sky130_fd_sc_hd__tapvpwrvgnd_1
XFILLER_0_6_174 VGND VGND VPWR VPWR sky130_fd_sc_hd__decap_4
XFILLER_0_69_169 VGND VGND VPWR VPWR sky130_fd_sc_hd__fill_2
XFILLER_0_65_364 VGND VGND VPWR VPWR sky130_fd_sc_hd__decap_3
XFILLER_0_40_209 VGND VGND VPWR VPWR sky130_fd_sc_hd__fill_2
XFILLER_0_33_261 VPWR VGND VPWR VGND sky130_ef_sc_hd__decap_12
XFILLER_0_68_29 VPWR VGND VPWR VGND sky130_ef_sc_hd__decap_12
XscaleAdd._411_ operator.io_outMant\[1\] net55 VGND VGND VPWR VPWR scaleAdd._353_
+ sky130_fd_sc_hd__and2_1
XFILLER_0_48_309 VPWR VGND VPWR VGND sky130_ef_sc_hd__decap_12
XFILLER_0_17_55 VGND VGND VPWR VPWR sky130_fd_sc_hd__fill_1
XTAP_TAPCELL_ROW_44_484 VGND VPWR sky130_fd_sc_hd__tapvpwrvgnd_1
Xaccumulator._1972_ accumulator._0851_ accumulator._1068_ VGND VGND VPWR VPWR accumulator._1069_
+ sky130_fd_sc_hd__xor2_2
XFILLER_0_24_261 VGND VGND VPWR VPWR sky130_fd_sc_hd__fill_2
XFILLER_0_3_177 VGND VGND VPWR VPWR sky130_fd_sc_hd__fill_1
XscaleAdd._609_ scaleAdd._153_ scaleAdd._174_ VGND VGND VPWR VPWR scaleAdd._185_ sky130_fd_sc_hd__or2_1
XFILLER_0_12_401 VPWR VGND VPWR VGND sky130_ef_sc_hd__decap_12
XFILLER_0_58_62 VGND VGND VPWR VPWR sky130_fd_sc_hd__decap_8
XFILLER_0_35_3 VPWR VGND VPWR VGND sky130_ef_sc_hd__decap_12
Xaccumulator._1406_ accumulator._0453_ accumulator._0502_ VGND VGND VPWR VPWR accumulator._0503_
+ sky130_fd_sc_hd__and2_1
Xaccumulator._1337_ accumulator._0263_ VGND VGND VPWR VPWR accumulator._0434_ sky130_fd_sc_hd__buf_2
Xaccumulator._1268_ accumulator._0362_ accumulator._0366_ VGND VGND VPWR VPWR accumulator._0367_
+ sky130_fd_sc_hd__or2_2
Xaccumulator._2386_ accumulator.io_accOut\[29\] accumulator._0406_ VGND VGND VPWR
+ VPWR accumulator._0319_ sky130_fd_sc_hd__or2_1
XFILLER_0_62_323 VGND VGND VPWR VPWR sky130_fd_sc_hd__fill_1
Xaccumulator._1199_ accumulator.state\[0\] accumulator.state\[1\] VGND VGND VPWR VPWR
+ accumulator._1178_ sky130_fd_sc_hd__and2b_1
XFILLER_0_30_253 VGND VGND VPWR VPWR sky130_fd_sc_hd__fill_2
XTAP_TAPCELL_ROW_58_587 VGND VPWR sky130_fd_sc_hd__tapvpwrvgnd_1
XFILLER_0_38_397 VGND VGND VPWR VPWR sky130_fd_sc_hd__fill_2
XFILLER_0_53_334 VGND VGND VPWR VPWR sky130_fd_sc_hd__fill_2
XFILLER_0_0_125 VPWR VGND VPWR VGND sky130_ef_sc_hd__decap_12
XFILLER_0_13_209 VPWR VGND VPWR VGND sky130_ef_sc_hd__decap_12
XTAP_TAPCELL_ROW_49_521 VGND VPWR sky130_fd_sc_hd__tapvpwrvgnd_1
XFILLER_0_28_65 VGND VGND VPWR VPWR sky130_fd_sc_hd__decap_4
XFILLER_0_0_147 VPWR VGND VPWR VGND sky130_ef_sc_hd__decap_12
XFILLER_0_0_169 VPWR VGND VPWR VGND sky130_ef_sc_hd__decap_12
Xaccumulator._2171_ accumulator._0103_ accumulator._0104_ accumulator._1018_ VGND
+ VGND VPWR VPWR accumulator._0106_ sky130_fd_sc_hd__a21o_1
XFILLER_0_48_139 VGND VGND VPWR VPWR sky130_fd_sc_hd__fill_1
XFILLER_0_44_53 VGND VGND VPWR VPWR sky130_fd_sc_hd__decap_4
Xaccumulator._2240_ accumulator._0084_ accumulator._0174_ accumulator._1142_ VGND
+ VGND VPWR VPWR accumulator._0175_ sky130_fd_sc_hd__mux2_1
XFILLER_0_21_9 VGND VGND VPWR VPWR sky130_fd_sc_hd__decap_3
XFILLER_0_60_85 VPWR VGND VPWR VGND sky130_ef_sc_hd__decap_12
XFILLER_0_60_41 VPWR VGND VPWR VGND sky130_ef_sc_hd__decap_12
XFILLER_0_44_356 VGND VGND VPWR VPWR sky130_fd_sc_hd__decap_8
XFILLER_0_29_353 VGND VGND VPWR VPWR sky130_fd_sc_hd__fill_2
XFILLER_0_8_258 VPWR VGND VPWR VGND sky130_ef_sc_hd__decap_12
Xaccumulator._1955_ accumulator._1047_ accumulator._1051_ VGND VGND VPWR VPWR accumulator._1052_
+ sky130_fd_sc_hd__xnor2_1
Xaccumulator._1886_ accumulator._0605_ accumulator._0776_ accumulator._0784_ VGND
+ VGND VPWR VPWR accumulator._0983_ sky130_fd_sc_hd__or3_1
XPHY_EDGE_ROW_31_Left_102 VGND VGND VPWR VPWR sky130_fd_sc_hd__decap_3
XPHY_EDGE_ROW_40_Left_111 VGND VGND VPWR VPWR sky130_fd_sc_hd__decap_3
XTAP_TAPCELL_ROW_4_179 VGND VPWR sky130_fd_sc_hd__tapvpwrvgnd_1
XTAP_TAPCELL_ROW_55_568 VGND VPWR sky130_fd_sc_hd__tapvpwrvgnd_1
Xaccumulator._2369_ accumulator._0300_ accumulator._0301_ VGND VGND VPWR VPWR accumulator._0302_
+ sky130_fd_sc_hd__nor2_1
XFILLER_0_35_334 VGND VGND VPWR VPWR sky130_fd_sc_hd__fill_2
Xclone22 accumulator._0343_ accumulator._0356_ VGND VGND VPWR VPWR net79 sky130_fd_sc_hd__and2_2
XFILLER_0_41_315 VGND VGND VPWR VPWR sky130_fd_sc_hd__decap_8
Xaccumulator._1740_ accumulator._0835_ accumulator._0836_ VGND VGND VPWR VPWR accumulator._0837_
+ sky130_fd_sc_hd__nor2_1
Xaccumulator._1671_ accumulator._0428_ accumulator._0698_ accumulator._0699_ VGND
+ VGND VPWR VPWR accumulator._0768_ sky130_fd_sc_hd__and3_1
XFILLER_0_41_337 VGND VGND VPWR VPWR sky130_fd_sc_hd__fill_2
Xaccumulator._2085_ accumulator._1164_ accumulator._1165_ VGND VGND VPWR VPWR accumulator._1183_
+ sky130_fd_sc_hd__and2_1
Xaccumulator._2223_ accumulator._1018_ accumulator._0051_ accumulator._0123_ VGND
+ VGND VPWR VPWR accumulator._0158_ sky130_fd_sc_hd__o21ba_1
Xaccumulator._2154_ accumulator._0042_ VGND VGND VPWR VPWR accumulator._0089_ sky130_fd_sc_hd__buf_2
XFILLER_0_36_109 VGND VGND VPWR VPWR sky130_fd_sc_hd__fill_1
XTAP_TAPCELL_ROW_17_281 VGND VPWR sky130_fd_sc_hd__tapvpwrvgnd_1
XFILLER_0_44_197 VPWR VGND VPWR VGND sky130_ef_sc_hd__decap_12
XFILLER_0_44_153 VPWR VGND VPWR VGND sky130_ef_sc_hd__decap_12
XFILLER_0_44_120 VGND VGND VPWR VPWR sky130_fd_sc_hd__decap_3
XFILLER_0_17_334 VGND VGND VPWR VPWR sky130_fd_sc_hd__fill_2
Xaccumulator._1869_ accumulator._0736_ accumulator._0906_ VGND VGND VPWR VPWR accumulator._0966_
+ sky130_fd_sc_hd__nor2_1
Xaccumulator._1938_ accumulator._1033_ accumulator._1034_ accumulator._0922_ VGND
+ VGND VPWR VPWR accumulator._1035_ sky130_fd_sc_hd__mux2_1
XTAP_TAPCELL_ROW_68_660 VGND VPWR sky130_fd_sc_hd__tapvpwrvgnd_1
XFILLER_0_35_142 VGND VGND VPWR VPWR sky130_fd_sc_hd__fill_1
XFILLER_0_35_131 VGND VGND VPWR VPWR sky130_fd_sc_hd__fill_1
XFILLER_0_50_156 VGND VGND VPWR VPWR sky130_fd_sc_hd__decap_6
XFILLER_0_50_112 VGND VGND VPWR VPWR sky130_fd_sc_hd__fill_2
XscaleAdd._590_ scaleAdd._099_ scaleAdd._106_ scaleAdd._135_ scaleAdd._138_ VGND VGND
+ VPWR VPWR scaleAdd._167_ sky130_fd_sc_hd__a211oi_2
XFILLER_0_58_278 VGND VGND VPWR VPWR sky130_fd_sc_hd__decap_4
XFILLER_0_25_99 VGND VGND VPWR VPWR sky130_fd_sc_hd__decap_6
XFILLER_0_41_87 VPWR VGND VPWR VGND sky130_ef_sc_hd__decap_12
XFILLER_0_26_197 VGND VGND VPWR VPWR sky130_fd_sc_hd__fill_2
Xaccumulator._1654_ accumulator.io_accOut\[6\] accumulator._0549_ accumulator._0403_
+ VGND VGND VPWR VPWR accumulator._0751_ sky130_fd_sc_hd__mux2_1
Xaccumulator._1723_ accumulator._0395_ accumulator._0517_ VGND VGND VPWR VPWR accumulator._0820_
+ sky130_fd_sc_hd__or2_1
XFILLER_0_22_370 VPWR VGND VPWR VGND sky130_ef_sc_hd__decap_12
XTAP_TAPCELL_ROW_65_641 VGND VPWR sky130_fd_sc_hd__tapvpwrvgnd_1
Xaccumulator._1585_ accumulator._0624_ accumulator._0625_ accumulator._0476_ VGND
+ VGND VPWR VPWR accumulator._0682_ sky130_fd_sc_hd__a21o_1
Xaccumulator._2206_ accumulator.io_accOut\[9\] accumulator._0091_ VGND VGND VPWR VPWR
+ accumulator._0141_ sky130_fd_sc_hd__and2_1
Xaccumulator._2068_ accumulator._1162_ accumulator._0920_ accumulator._0968_ VGND
+ VGND VPWR VPWR accumulator._1165_ sky130_fd_sc_hd__nand3b_1
Xaccumulator._2137_ accumulator._0047_ accumulator._0070_ accumulator._1196_ VGND
+ VGND VPWR VPWR accumulator._0071_ sky130_fd_sc_hd__mux2_1
XFILLER_0_17_153 VPWR VGND VPWR VGND sky130_ef_sc_hd__decap_12
XFILLER_0_17_186 VGND VGND VPWR VPWR sky130_fd_sc_hd__decap_4
XFILLER_0_20_307 VGND VGND VPWR VPWR sky130_fd_sc_hd__fill_1
XTAP_TAPCELL_ROW_28_365 VGND VPWR sky130_fd_sc_hd__tapvpwrvgnd_1
XFILLER_0_55_237 VGND VGND VPWR VPWR sky130_fd_sc_hd__decap_6
XscaleAdd._642_ scaleAdd._313_ scaleAdd._216_ VGND VGND VPWR VPWR scaleAdd._217_ sky130_fd_sc_hd__nand2_1
XscaleAdd._573_ scaleAdd._120_ net65 scaleAdd._149_ scaleAdd._150_ VGND VGND VPWR
+ VPWR scaleAdd._151_ sky130_fd_sc_hd__o22ai_1
XFILLER_0_11_57 VGND VGND VPWR VPWR sky130_fd_sc_hd__decap_4
XTAP_TAPCELL_ROW_11_232 VGND VPWR sky130_fd_sc_hd__tapvpwrvgnd_1
XscaleAdd._711_ scaleAdd._250_ scaleAdd._279_ scaleAdd._276_ scaleAdd._275_ VGND VGND
+ VPWR VPWR accumulator.io_inMant\[17\] sky130_fd_sc_hd__a211o_1
XFILLER_0_23_178 VPWR VGND VPWR VGND sky130_ef_sc_hd__decap_12
XFILLER_0_11_329 VGND VGND VPWR VPWR sky130_fd_sc_hd__decap_6
Xaccumulator._1370_ accumulator.io_accOut\[16\] accumulator._0466_ accumulator._0394_
+ VGND VGND VPWR VPWR accumulator._0467_ sky130_fd_sc_hd__mux2_1
XFILLER_0_36_65 VGND VGND VPWR VPWR sky130_fd_sc_hd__fill_2
Xinput6 io_inB[1] VGND VGND VPWR VPWR net6 sky130_fd_sc_hd__dlymetal6s2s_1
XFILLER_0_52_53 VGND VGND VPWR VPWR sky130_fd_sc_hd__decap_8
XFILLER_0_65_3 VPWR VGND VPWR VGND sky130_ef_sc_hd__decap_12
XFILLER_0_6_345 VPWR VGND VPWR VGND sky130_ef_sc_hd__decap_12
XFILLER_0_6_389 VPWR VGND VPWR VGND sky130_ef_sc_hd__decap_12
Xaccumulator._1637_ accumulator._0606_ VGND VGND VPWR VPWR accumulator._0734_ sky130_fd_sc_hd__buf_2
Xaccumulator._1568_ accumulator._0475_ accumulator._0505_ accumulator._0510_ VGND
+ VGND VPWR VPWR accumulator._0665_ sky130_fd_sc_hd__and3_1
Xaccumulator._1706_ accumulator.io_accOut\[7\] accumulator._0546_ accumulator._0403_
+ VGND VGND VPWR VPWR accumulator._0803_ sky130_fd_sc_hd__mux2_1
XFILLER_0_69_307 VPWR VGND VPWR VGND sky130_ef_sc_hd__decap_12
Xaccumulator._1499_ accumulator.io_accOut\[22\] accumulator._0595_ accumulator._0393_
+ VGND VGND VPWR VPWR accumulator._0596_ sky130_fd_sc_hd__mux2_1
Xoperator._26_ operator.io_outMant\[0\] operator._07_ operator._08_ VGND VGND VPWR
+ VPWR operator._09_ sky130_fd_sc_hd__and3b_1
XFILLER_0_37_248 VGND VGND VPWR VPWR sky130_fd_sc_hd__fill_1
XPHY_EDGE_ROW_14_Right_14 VGND VGND VPWR VPWR sky130_fd_sc_hd__decap_3
XPHY_EDGE_ROW_23_Right_23 VGND VGND VPWR VPWR sky130_fd_sc_hd__decap_3
XPHY_EDGE_ROW_32_Right_32 VGND VGND VPWR VPWR sky130_fd_sc_hd__decap_3
XscaleAdd._556_ scaleAdd._132_ scaleAdd._133_ VGND VGND VPWR VPWR scaleAdd._134_ sky130_fd_sc_hd__and2_1
XFILLER_0_3_337 VPWR VGND VPWR VGND sky130_ef_sc_hd__decap_12
XscaleAdd._625_ scaleAdd._062_ scaleAdd._200_ scaleAdd._171_ scaleAdd._154_ VGND VGND
+ VPWR VPWR scaleAdd._201_ sky130_fd_sc_hd__o22a_1
XFILLER_0_47_64 VPWR VGND VPWR VGND sky130_ef_sc_hd__decap_12
XPHY_EDGE_ROW_41_Right_41 VGND VGND VPWR VPWR sky130_fd_sc_hd__decap_3
Xaccumulator._1422_ accumulator._0478_ accumulator._0518_ accumulator._0469_ VGND
+ VGND VPWR VPWR accumulator._0519_ sky130_fd_sc_hd__a21o_1
XscaleAdd._487_ scaleAdd._065_ scaleAdd._066_ VGND VGND VPWR VPWR scaleAdd._067_ sky130_fd_sc_hd__xor2_1
XPHY_EDGE_ROW_50_Right_50 VGND VGND VPWR VPWR sky130_fd_sc_hd__decap_3
Xaccumulator._1353_ accumulator.io_accOut\[17\] accumulator._0449_ accumulator._0394_
+ VGND VGND VPWR VPWR accumulator._0450_ sky130_fd_sc_hd__mux2_1
Xaccumulator._1284_ accumulator._0382_ accumulator._0377_ accumulator._0380_ VGND
+ VGND VPWR VPWR accumulator._0383_ sky130_fd_sc_hd__a21o_1
XFILLER_0_19_215 VGND VGND VPWR VPWR sky130_fd_sc_hd__fill_1
XFILLER_0_34_218 VGND VGND VPWR VPWR sky130_fd_sc_hd__decap_8
XFILLER_0_27_292 VGND VGND VPWR VPWR sky130_fd_sc_hd__decap_4
XFILLER_0_27_281 VGND VGND VPWR VPWR sky130_fd_sc_hd__decap_4
XFILLER_0_27_270 VGND VGND VPWR VPWR sky130_fd_sc_hd__decap_3
XTAP_TAPCELL_ROW_22_316 VGND VPWR sky130_fd_sc_hd__tapvpwrvgnd_1
XFILLER_0_6_197 VPWR VGND VPWR VGND sky130_ef_sc_hd__decap_12
XFILLER_0_69_104 VGND VGND VPWR VPWR sky130_fd_sc_hd__decap_8
XFILLER_0_65_321 VGND VGND VPWR VPWR sky130_fd_sc_hd__decap_4
XFILLER_0_33_273 VGND VGND VPWR VPWR sky130_fd_sc_hd__decap_6
XscaleAdd._410_ scaleAdd._331_ scaleAdd._351_ VGND VGND VPWR VPWR scaleAdd._352_ sky130_fd_sc_hd__xor2_1
XFILLER_0_18_270 VPWR VGND VPWR VGND sky130_ef_sc_hd__decap_12
XFILLER_0_17_23 VGND VGND VPWR VPWR sky130_fd_sc_hd__fill_1
XTAP_TAPCELL_ROW_36_419 VGND VPWR sky130_fd_sc_hd__tapvpwrvgnd_1
XFILLER_0_56_321 VPWR VGND VPWR VGND sky130_ef_sc_hd__decap_12
XTAP_TAPCELL_ROW_44_485 VGND VPWR sky130_fd_sc_hd__tapvpwrvgnd_1
XFILLER_0_33_55 VGND VGND VPWR VPWR sky130_fd_sc_hd__fill_1
Xinput20 io_start VGND VGND VPWR VPWR net20 sky130_fd_sc_hd__clkbuf_1
Xaccumulator._1971_ accumulator._1058_ accumulator._1067_ accumulator._0922_ VGND
+ VGND VPWR VPWR accumulator._1068_ sky130_fd_sc_hd__mux2_1
XFILLER_0_58_41 VGND VGND VPWR VPWR sky130_fd_sc_hd__decap_8
XFILLER_0_24_251 VGND VGND VPWR VPWR sky130_fd_sc_hd__fill_1
XscaleAdd._608_ scaleAdd._172_ scaleAdd._173_ VGND VGND VPWR VPWR scaleAdd._184_ sky130_fd_sc_hd__or2b_1
XscaleAdd._539_ scaleAdd._072_ scaleAdd._075_ scaleAdd._117_ VGND VGND VPWR VPWR scaleAdd._118_
+ sky130_fd_sc_hd__a21oi_4
XFILLER_0_12_413 VGND VGND VPWR VPWR sky130_fd_sc_hd__decap_4
XFILLER_0_28_3 VPWR VGND VPWR VGND sky130_ef_sc_hd__decap_12
Xaccumulator._1405_ accumulator._0446_ accumulator._0440_ accumulator._0447_ VGND
+ VGND VPWR VPWR accumulator._0502_ sky130_fd_sc_hd__mux2_1
Xaccumulator._2385_ accumulator._0314_ accumulator._0317_ VGND VGND VPWR VPWR accumulator._0318_
+ sky130_fd_sc_hd__xor2_1
Xaccumulator._1336_ accumulator._0432_ VGND VGND VPWR VPWR accumulator._0433_ sky130_fd_sc_hd__buf_2
Xaccumulator._1267_ accumulator._0363_ accumulator._0365_ VGND VGND VPWR VPWR accumulator._0366_
+ sky130_fd_sc_hd__xnor2_1
XFILLER_0_62_346 VPWR VGND VPWR VGND sky130_ef_sc_hd__decap_12
XFILLER_0_47_387 VGND VGND VPWR VPWR sky130_fd_sc_hd__decap_4
XTAP_TAPCELL_ROW_58_588 VGND VPWR sky130_fd_sc_hd__tapvpwrvgnd_1
XFILLER_0_65_151 VPWR VGND VPWR VGND sky130_ef_sc_hd__decap_12
XFILLER_0_21_265 VGND VGND VPWR VPWR sky130_fd_sc_hd__fill_1
XFILLER_0_0_137 VGND VGND VPWR VPWR sky130_fd_sc_hd__decap_3
XFILLER_0_0_159 VGND VGND VPWR VPWR sky130_fd_sc_hd__decap_8
XTAP_TAPCELL_ROW_49_522 VGND VPWR sky130_fd_sc_hd__tapvpwrvgnd_1
Xaccumulator._2170_ accumulator._1180_ VGND VGND VPWR VPWR accumulator._0104_ sky130_fd_sc_hd__buf_2
XFILLER_0_29_343 VGND VGND VPWR VPWR sky130_fd_sc_hd__fill_1
XFILLER_0_8_226 VGND VGND VPWR VPWR sky130_fd_sc_hd__decap_8
Xaccumulator._1954_ accumulator._0837_ accumulator._1050_ VGND VGND VPWR VPWR accumulator._1051_
+ sky130_fd_sc_hd__xnor2_2
XFILLER_0_60_97 VGND VGND VPWR VPWR sky130_fd_sc_hd__fill_2
XFILLER_0_60_53 VGND VGND VPWR VPWR sky130_fd_sc_hd__decap_8
XFILLER_0_8_21 VGND VGND VPWR VPWR sky130_fd_sc_hd__decap_4
XFILLER_0_8_248 VGND VGND VPWR VPWR sky130_fd_sc_hd__decap_4
XFILLER_0_69_51 VGND VGND VPWR VPWR sky130_fd_sc_hd__decap_4
Xaccumulator._1885_ accumulator._0932_ accumulator._0934_ VGND VGND VPWR VPWR accumulator._0982_
+ sky130_fd_sc_hd__and2_1
XPHY_EDGE_ROW_4_Right_4 VGND VGND VPWR VPWR sky130_fd_sc_hd__decap_3
XFILLER_0_8_98 VPWR VGND VPWR VGND sky130_ef_sc_hd__decap_12
XFILLER_0_12_243 VGND VGND VPWR VPWR sky130_fd_sc_hd__decap_8
XFILLER_0_67_405 VPWR VGND VPWR VGND sky130_ef_sc_hd__decap_12
Xaccumulator._2368_ accumulator._0284_ accumulator._0288_ accumulator._0299_ VGND
+ VGND VPWR VPWR accumulator._0301_ sky130_fd_sc_hd__nor3_1
Xclone12 accumulator._1181_ VGND VGND VPWR VPWR net69 sky130_fd_sc_hd__clkbuf_16
XFILLER_0_39_129 VPWR VGND VPWR VGND sky130_ef_sc_hd__decap_12
Xaccumulator._2299_ accumulator.io_accOut\[19\] accumulator._0406_ VGND VGND VPWR
+ VPWR accumulator._0233_ sky130_fd_sc_hd__or2_1
Xaccumulator._1319_ accumulator._0368_ net58 VGND VGND VPWR VPWR accumulator._0416_
+ sky130_fd_sc_hd__xor2_4
XFILLER_0_7_281 VGND VGND VPWR VPWR sky130_fd_sc_hd__decap_4
XFILLER_0_14_57 VGND VGND VPWR VPWR sky130_fd_sc_hd__fill_1
XFILLER_0_14_68 VGND VGND VPWR VPWR sky130_fd_sc_hd__decap_4
XFILLER_0_41_305 VGND VGND VPWR VPWR sky130_fd_sc_hd__fill_2
XFILLER_0_38_162 VGND VGND VPWR VPWR sky130_fd_sc_hd__fill_1
XFILLER_0_38_151 VGND VGND VPWR VPWR sky130_fd_sc_hd__fill_2
XFILLER_0_26_335 VGND VGND VPWR VPWR sky130_fd_sc_hd__fill_1
XFILLER_0_5_218 VGND VGND VPWR VPWR sky130_fd_sc_hd__decap_6
Xaccumulator._1670_ accumulator._0599_ accumulator._0682_ accumulator._0683_ VGND
+ VGND VPWR VPWR accumulator._0767_ sky130_fd_sc_hd__and3_1
Xaccumulator._2222_ accumulator.io_accOut\[11\] accumulator._0397_ VGND VGND VPWR
+ VPWR accumulator._0157_ sky130_fd_sc_hd__and2_1
XTAP_TAPCELL_ROW_52_539 VGND VPWR sky130_fd_sc_hd__tapvpwrvgnd_1
Xaccumulator._2084_ accumulator._1153_ accumulator._0980_ net70 VGND VGND VPWR VPWR
+ accumulator._1182_ sky130_fd_sc_hd__mux2_1
Xaccumulator._2153_ accumulator._1141_ accumulator._0087_ VGND VGND VPWR VPWR accumulator._0088_
+ sky130_fd_sc_hd__or2_1
XFILLER_0_29_195 VGND VGND VPWR VPWR sky130_fd_sc_hd__fill_1
XFILLER_0_17_324 VGND VGND VPWR VPWR sky130_fd_sc_hd__decap_3
XTAP_TAPCELL_ROW_17_282 VGND VPWR sky130_fd_sc_hd__tapvpwrvgnd_1
Xaccumulator._1937_ accumulator._0815_ accumulator._0809_ accumulator._0839_ VGND
+ VGND VPWR VPWR accumulator._1034_ sky130_fd_sc_hd__o21bai_1
XFILLER_0_44_187 VGND VGND VPWR VPWR sky130_fd_sc_hd__fill_1
XFILLER_0_44_165 VGND VGND VPWR VPWR sky130_fd_sc_hd__decap_3
XTAP_TAPCELL_ROW_9_217 VGND VPWR sky130_fd_sc_hd__tapvpwrvgnd_1
Xaccumulator._1799_ accumulator._0880_ accumulator._0881_ VGND VGND VPWR VPWR accumulator._0896_
+ sky130_fd_sc_hd__and2b_1
Xaccumulator._1868_ accumulator._0924_ accumulator._0925_ accumulator._0911_ accumulator._0964_
+ VGND VGND VPWR VPWR accumulator._0965_ sky130_fd_sc_hd__o211a_1
XTAP_TAPCELL_ROW_68_661 VGND VPWR sky130_fd_sc_hd__tapvpwrvgnd_1
XTAP_TAPCELL_ROW_0_150 VGND VPWR sky130_fd_sc_hd__tapvpwrvgnd_1
XFILLER_0_50_135 VGND VGND VPWR VPWR sky130_fd_sc_hd__fill_1
XFILLER_0_58_257 VGND VGND VPWR VPWR sky130_fd_sc_hd__fill_1
XFILLER_0_41_55 VGND VGND VPWR VPWR sky130_fd_sc_hd__fill_1
XFILLER_0_26_121 VGND VGND VPWR VPWR sky130_fd_sc_hd__fill_1
XFILLER_0_41_146 VGND VGND VPWR VPWR sky130_fd_sc_hd__decap_8
XFILLER_0_41_99 VPWR VGND VPWR VGND sky130_ef_sc_hd__decap_12
XFILLER_0_41_113 VPWR VGND VPWR VGND sky130_ef_sc_hd__decap_12
XFILLER_0_26_187 VGND VGND VPWR VPWR sky130_fd_sc_hd__decap_8
XFILLER_0_66_85 VGND VGND VPWR VPWR sky130_fd_sc_hd__fill_1
XFILLER_0_66_41 VPWR VGND VPWR VGND sky130_ef_sc_hd__decap_12
Xaccumulator._1653_ accumulator._0733_ accumulator._0746_ accumulator._0747_ accumulator._0749_
+ VGND VGND VPWR VPWR accumulator._0750_ sky130_fd_sc_hd__a31o_1
Xaccumulator._1722_ accumulator._0651_ accumulator._0817_ accumulator._0818_ VGND
+ VGND VPWR VPWR accumulator._0819_ sky130_fd_sc_hd__nor3_1
Xaccumulator._1584_ accumulator._0661_ accumulator._0674_ accumulator._0675_ VGND
+ VGND VPWR VPWR accumulator._0681_ sky130_fd_sc_hd__nand3_1
XFILLER_0_5_55 VGND VGND VPWR VPWR sky130_fd_sc_hd__fill_1
XFILLER_0_5_11 VGND VGND VPWR VPWR sky130_fd_sc_hd__fill_2
XTAP_TAPCELL_ROW_65_642 VGND VPWR sky130_fd_sc_hd__tapvpwrvgnd_1
Xaccumulator._2205_ accumulator._0133_ accumulator._0140_ accumulator._0093_ VGND
+ VGND VPWR VPWR accumulator._0010_ sky130_fd_sc_hd__o21a_1
XFILLER_0_10_3 VGND VGND VPWR VPWR sky130_fd_sc_hd__decap_8
XFILLER_0_64_249 VGND VGND VPWR VPWR sky130_fd_sc_hd__decap_3
XFILLER_0_64_238 VGND VGND VPWR VPWR sky130_fd_sc_hd__decap_6
Xaccumulator._2067_ accumulator._0920_ accumulator._0968_ accumulator._1163_ VGND
+ VGND VPWR VPWR accumulator._1164_ sky130_fd_sc_hd__a21o_1
Xaccumulator._2136_ accumulator._0994_ accumulator._0051_ accumulator._0069_ VGND
+ VGND VPWR VPWR accumulator._0070_ sky130_fd_sc_hd__a21o_1
XFILLER_0_17_110 VGND VGND VPWR VPWR sky130_fd_sc_hd__fill_2
XFILLER_0_17_165 VGND VGND VPWR VPWR sky130_fd_sc_hd__decap_3
XFILLER_0_32_135 VGND VGND VPWR VPWR sky130_fd_sc_hd__decap_4
XFILLER_0_13_393 VPWR VGND VPWR VGND sky130_ef_sc_hd__decap_12
XTAP_TAPCELL_ROW_20_299 VGND VPWR sky130_fd_sc_hd__tapvpwrvgnd_1
XFILLER_0_20_319 VPWR VGND VPWR VGND sky130_ef_sc_hd__decap_12
XTAP_TAPCELL_ROW_28_366 VGND VPWR sky130_fd_sc_hd__tapvpwrvgnd_1
XFILLER_0_28_419 VGND VGND VPWR VPWR sky130_fd_sc_hd__fill_1
XscaleAdd._710_ scaleAdd._303_ scaleAdd._330_ scaleAdd._317_ scaleAdd._313_ VGND VGND
+ VPWR VPWR accumulator.io_inMant\[2\] sky130_fd_sc_hd__a22o_1
XFILLER_0_63_260 VGND VGND VPWR VPWR sky130_fd_sc_hd__decap_6
XscaleAdd._641_ scaleAdd._214_ scaleAdd._215_ VGND VGND VPWR VPWR scaleAdd._216_ sky130_fd_sc_hd__xor2_4
XscaleAdd._572_ scaleAdd._121_ scaleAdd._122_ scaleAdd._148_ VGND VGND VPWR VPWR scaleAdd._150_
+ sky130_fd_sc_hd__a21oi_2
XFILLER_0_11_25 VPWR VGND VPWR VGND sky130_ef_sc_hd__decap_12
XTAP_TAPCELL_ROW_11_233 VGND VPWR sky130_fd_sc_hd__tapvpwrvgnd_1
Xinput7 io_inB[2] VGND VGND VPWR VPWR net7 sky130_fd_sc_hd__dlymetal6s2s_1
XFILLER_0_6_357 VGND VGND VPWR VPWR sky130_fd_sc_hd__decap_6
XFILLER_0_14_113 VPWR VGND VPWR VGND sky130_ef_sc_hd__decap_12
XFILLER_0_58_3 VPWR VGND VPWR VGND sky130_ef_sc_hd__decap_12
Xaccumulator._1705_ accumulator._0733_ accumulator._0800_ accumulator._0801_ accumulator._0735_
+ accumulator._0557_ VGND VGND VPWR VPWR accumulator._0802_ sky130_fd_sc_hd__a32o_1
XFILLER_0_10_363 VGND VGND VPWR VPWR sky130_fd_sc_hd__fill_1
Xaccumulator._1636_ accumulator._0425_ VGND VGND VPWR VPWR accumulator._0733_ sky130_fd_sc_hd__buf_2
Xaccumulator._1567_ accumulator._0599_ accumulator._0662_ accumulator._0663_ VGND
+ VGND VPWR VPWR accumulator._0664_ sky130_fd_sc_hd__nand3_1
XFILLER_0_69_319 VPWR VGND VPWR VGND sky130_ef_sc_hd__decap_12
Xaccumulator._2119_ accumulator._1183_ accumulator._0051_ accumulator._0052_ VGND
+ VGND VPWR VPWR accumulator._0053_ sky130_fd_sc_hd__a21o_1
XFILLER_0_37_205 VPWR VGND VPWR VGND sky130_ef_sc_hd__decap_12
Xaccumulator._1498_ accumulator._0126_ accumulator._0490_ accumulator._0493_ accumulator._0095_
+ accumulator._0594_ VGND VGND VPWR VPWR accumulator._0595_ sky130_fd_sc_hd__o221a_1
Xoperator._25_ net2 net3 VGND VGND VPWR VPWR operator._08_ sky130_fd_sc_hd__or2_1
XFILLER_0_20_149 VGND VGND VPWR VPWR sky130_fd_sc_hd__decap_8
XFILLER_0_68_363 VGND VGND VPWR VPWR sky130_fd_sc_hd__fill_1
XscaleAdd._555_ scaleAdd._127_ scaleAdd._094_ scaleAdd._131_ VGND VGND VPWR VPWR scaleAdd._133_
+ sky130_fd_sc_hd__or3_1
XFILLER_0_3_349 VPWR VGND VPWR VGND sky130_ef_sc_hd__decap_12
XscaleAdd._624_ scaleAdd._312_ scaleAdd._188_ VGND VGND VPWR VPWR scaleAdd._200_ sky130_fd_sc_hd__nand2_1
XFILLER_0_11_138 VGND VGND VPWR VPWR sky130_fd_sc_hd__fill_1
XscaleAdd._486_ scaleAdd._026_ scaleAdd._028_ VGND VGND VPWR VPWR scaleAdd._066_ sky130_fd_sc_hd__and2_1
XFILLER_0_47_76 VGND VGND VPWR VPWR sky130_fd_sc_hd__fill_1
Xaccumulator._1421_ accumulator.io_accOut\[10\] accumulator._0517_ accumulator._0485_
+ VGND VGND VPWR VPWR accumulator._0518_ sky130_fd_sc_hd__mux2_1
XFILLER_0_59_330 VGND VGND VPWR VPWR sky130_fd_sc_hd__fill_2
Xaccumulator._1352_ accumulator._0434_ accumulator._0435_ accumulator._0440_ accumulator._0448_
+ VGND VGND VPWR VPWR accumulator._0449_ sky130_fd_sc_hd__a31o_1
Xaccumulator._1283_ accumulator._0380_ accumulator._0381_ VGND VGND VPWR VPWR accumulator._0382_
+ sky130_fd_sc_hd__nor2_2
XTAP_TAPCELL_ROW_22_317 VGND VPWR sky130_fd_sc_hd__tapvpwrvgnd_1
Xaccumulator._1619_ accumulator._0511_ accumulator._0520_ VGND VGND VPWR VPWR accumulator._0716_
+ sky130_fd_sc_hd__and2_1
XFILLER_0_18_282 VGND VGND VPWR VPWR sky130_fd_sc_hd__decap_8
XFILLER_0_18_293 VPWR VGND VPWR VGND sky130_ef_sc_hd__decap_12
XFILLER_0_68_182 VGND VGND VPWR VPWR sky130_fd_sc_hd__fill_1
XFILLER_0_8_419 VGND VGND VPWR VPWR sky130_fd_sc_hd__fill_1
Xaccumulator._1970_ accumulator._0845_ accumulator._0857_ accumulator._0859_ VGND
+ VGND VPWR VPWR accumulator._1067_ sky130_fd_sc_hd__a21bo_1
XTAP_TAPCELL_ROW_44_486 VGND VPWR sky130_fd_sc_hd__tapvpwrvgnd_1
Xinput21 reset VGND VGND VPWR VPWR net21 sky130_fd_sc_hd__buf_1
Xinput10 io_inScaleA[1] VGND VGND VPWR VPWR net10 sky130_fd_sc_hd__clkbuf_1
XFILLER_0_16_219 VPWR VGND VPWR VGND sky130_ef_sc_hd__decap_12
XscaleAdd._538_ scaleAdd._114_ scaleAdd._116_ VGND VGND VPWR VPWR scaleAdd._117_ sky130_fd_sc_hd__xnor2_1
XscaleAdd._607_ scaleAdd._183_ VGND VGND VPWR VPWR accumulator.io_inMant\[10\] sky130_fd_sc_hd__buf_1
XscaleAdd._469_ scaleAdd._307_ scaleAdd._337_ scaleAdd._006_ scaleAdd._005_ VGND VGND
+ VPWR VPWR scaleAdd._049_ sky130_fd_sc_hd__a31o_1
Xaccumulator._1335_ accumulator._0430_ accumulator._0431_ accumulator._0402_ VGND
+ VGND VPWR VPWR accumulator._0432_ sky130_fd_sc_hd__mux2_4
Xaccumulator._1404_ accumulator._0416_ accumulator._0426_ VGND VGND VPWR VPWR accumulator._0501_
+ sky130_fd_sc_hd__xor2_4
Xaccumulator._2384_ accumulator._0315_ accumulator._0316_ VGND VGND VPWR VPWR accumulator._0317_
+ sky130_fd_sc_hd__xnor2_1
XFILLER_0_66_108 VPWR VGND VPWR VGND sky130_ef_sc_hd__decap_12
Xaccumulator._1266_ accumulator._0293_ accumulator._0364_ VGND VGND VPWR VPWR accumulator._0365_
+ sky130_fd_sc_hd__xnor2_1
XFILLER_0_62_358 VGND VGND VPWR VPWR sky130_fd_sc_hd__fill_2
XTAP_TAPCELL_ROW_58_589 VGND VPWR sky130_fd_sc_hd__tapvpwrvgnd_1
XFILLER_0_38_322 VGND VGND VPWR VPWR sky130_fd_sc_hd__decap_3
XFILLER_0_65_163 VGND VGND VPWR VPWR sky130_fd_sc_hd__decap_4
XFILLER_0_61_391 VGND VGND VPWR VPWR sky130_fd_sc_hd__fill_1
XTAP_TAPCELL_ROW_49_523 VGND VPWR sky130_fd_sc_hd__tapvpwrvgnd_1
XFILLER_0_56_163 VPWR VGND VPWR VGND sky130_ef_sc_hd__decap_12
XFILLER_0_56_141 VGND VGND VPWR VPWR sky130_fd_sc_hd__decap_4
XFILLER_0_48_108 VPWR VGND VPWR VGND sky130_ef_sc_hd__decap_12
Xaccumulator._1953_ accumulator._1048_ accumulator._1049_ accumulator._0922_ VGND
+ VGND VPWR VPWR accumulator._1050_ sky130_fd_sc_hd__mux2_1
Xaccumulator._1884_ accumulator._0978_ accumulator._0980_ VGND VGND VPWR VPWR accumulator._0981_
+ sky130_fd_sc_hd__nor2_1
XFILLER_0_8_11 VGND VGND VPWR VPWR sky130_fd_sc_hd__fill_2
XFILLER_0_8_44 VGND VGND VPWR VPWR sky130_fd_sc_hd__fill_1
XFILLER_0_8_66 VPWR VGND VPWR VGND sky130_ef_sc_hd__decap_12
XFILLER_0_40_3 VPWR VGND VPWR VGND sky130_ef_sc_hd__decap_12
XFILLER_0_67_417 VGND VGND VPWR VPWR sky130_fd_sc_hd__decap_4
Xaccumulator._2298_ accumulator._0163_ accumulator._0231_ accumulator._1142_ VGND
+ VGND VPWR VPWR accumulator._0232_ sky130_fd_sc_hd__mux2_2
Xaccumulator._1318_ accumulator._0371_ accumulator._0414_ VGND VGND VPWR VPWR accumulator._0415_
+ sky130_fd_sc_hd__nand2_1
Xaccumulator._2367_ accumulator._0288_ accumulator._0284_ accumulator._0299_ VGND
+ VGND VPWR VPWR accumulator._0300_ sky130_fd_sc_hd__o21a_1
XFILLER_0_62_155 VPWR VGND VPWR VGND sky130_ef_sc_hd__decap_12
Xclone13 accumulator._1180_ accumulator._1132_ VGND VGND VPWR VPWR net70 sky130_fd_sc_hd__nand2_2
Xaccumulator._1249_ accumulator._0344_ accumulator._0273_ accumulator._0283_ accumulator._0347_
+ VGND VGND VPWR VPWR accumulator._0348_ sky130_fd_sc_hd__or4b_4
XFILLER_0_38_141 VGND VGND VPWR VPWR sky130_fd_sc_hd__decap_4
XFILLER_0_53_166 VGND VGND VPWR VPWR sky130_fd_sc_hd__fill_2
XFILLER_0_53_122 VPWR VGND VPWR VGND sky130_ef_sc_hd__decap_12
XFILLER_0_53_111 VGND VGND VPWR VPWR sky130_fd_sc_hd__fill_1
XFILLER_0_38_185 VGND VGND VPWR VPWR sky130_fd_sc_hd__decap_8
XFILLER_0_30_79 VGND VGND VPWR VPWR sky130_fd_sc_hd__decap_4
XFILLER_0_30_13 VPWR VGND VPWR VGND sky130_ef_sc_hd__decap_12
XFILLER_0_39_55 VGND VGND VPWR VPWR sky130_fd_sc_hd__fill_1
XFILLER_0_55_65 VPWR VGND VPWR VGND sky130_ef_sc_hd__decap_12
Xaccumulator._2152_ accumulator._0086_ accumulator._0037_ VGND VGND VPWR VPWR accumulator._0087_
+ sky130_fd_sc_hd__nor2_1
Xaccumulator._2221_ accumulator._0150_ accumulator._0155_ accumulator._0093_ VGND
+ VGND VPWR VPWR accumulator._0012_ sky130_fd_sc_hd__o21a_1
Xaccumulator._2083_ accumulator._1180_ accumulator._1132_ VGND VGND VPWR VPWR accumulator._1181_
+ sky130_fd_sc_hd__nand2_4
XFILLER_0_17_303 VGND VGND VPWR VPWR sky130_fd_sc_hd__decap_6
XTAP_TAPCELL_ROW_17_283 VGND VPWR sky130_fd_sc_hd__tapvpwrvgnd_1
Xaccumulator._1867_ accumulator._0913_ accumulator._0963_ accumulator._0893_ VGND
+ VGND VPWR VPWR accumulator._0964_ sky130_fd_sc_hd__nand3b_1
Xaccumulator._1936_ accumulator._0927_ accumulator._0941_ accumulator._0814_ VGND
+ VGND VPWR VPWR accumulator._1033_ sky130_fd_sc_hd__a21o_1
XFILLER_0_32_328 VGND VGND VPWR VPWR sky130_fd_sc_hd__decap_4
XFILLER_0_4_241 VGND VGND VPWR VPWR sky130_fd_sc_hd__decap_8
XTAP_TAPCELL_ROW_9_218 VGND VPWR sky130_fd_sc_hd__tapvpwrvgnd_1
XTAP_TAPCELL_ROW_68_662 VGND VPWR sky130_fd_sc_hd__tapvpwrvgnd_1
Xaccumulator._1798_ accumulator._0891_ VGND VGND VPWR VPWR accumulator._0895_ sky130_fd_sc_hd__inv_2
XFILLER_0_67_269 VGND VGND VPWR VPWR sky130_fd_sc_hd__decap_8
XFILLER_0_67_225 VGND VGND VPWR VPWR sky130_fd_sc_hd__decap_6
Xaccumulator._2419_ clknet_2_2__leaf_clock accumulator._0020_ VGND VGND VPWR VPWR
+ accumulator.io_accOut\[18\] sky130_fd_sc_hd__dfxtp_1
XTAP_TAPCELL_ROW_0_151 VGND VPWR sky130_fd_sc_hd__tapvpwrvgnd_1
XFILLER_0_31_361 VGND VGND VPWR VPWR sky130_fd_sc_hd__fill_2
XFILLER_0_25_57 VPWR VGND VPWR VGND sky130_ef_sc_hd__decap_12
XFILLER_0_25_46 VGND VGND VPWR VPWR sky130_fd_sc_hd__fill_1
XFILLER_0_46_409 VGND VGND VPWR VPWR sky130_fd_sc_hd__decap_6
Xclkbuf_2_1__f_clock clknet_0_clock VGND VGND VPWR VPWR clknet_2_1__leaf_clock sky130_fd_sc_hd__clkbuf_16
Xaccumulator._1721_ accumulator._0559_ accumulator._0500_ accumulator._0521_ accumulator._0740_
+ VGND VGND VPWR VPWR accumulator._0818_ sky130_fd_sc_hd__a211oi_1
XFILLER_0_41_169 VPWR VGND VPWR VGND sky130_ef_sc_hd__decap_12
XFILLER_0_41_125 VPWR VGND VPWR VGND sky130_ef_sc_hd__decap_12
XFILLER_0_26_166 VPWR VGND VPWR VGND sky130_ef_sc_hd__decap_12
XFILLER_0_66_53 VPWR VGND VPWR VGND sky130_ef_sc_hd__decap_12
Xaccumulator._1652_ accumulator._0734_ accumulator._0620_ accumulator._0748_ VGND
+ VGND VPWR VPWR accumulator._0749_ sky130_fd_sc_hd__nor3_1
Xaccumulator._1583_ accumulator._0675_ accumulator._0674_ accumulator._0661_ VGND
+ VGND VPWR VPWR accumulator._0680_ sky130_fd_sc_hd__nand3b_1
XTAP_TAPCELL_ROW_65_643 VGND VPWR sky130_fd_sc_hd__tapvpwrvgnd_1
Xaccumulator._2135_ accumulator._0996_ accumulator._1132_ accumulator._1180_ VGND
+ VGND VPWR VPWR accumulator._0069_ sky130_fd_sc_hd__and3_1
XFILLER_0_49_225 VPWR VGND VPWR VGND sky130_ef_sc_hd__decap_12
Xaccumulator._2204_ accumulator._0080_ accumulator._0138_ accumulator._0139_ accumulator._0089_
+ VGND VGND VPWR VPWR accumulator._0140_ sky130_fd_sc_hd__o211a_1
Xaccumulator._2066_ accumulator._0715_ accumulator._1162_ accumulator._1155_ VGND
+ VGND VPWR VPWR accumulator._1163_ sky130_fd_sc_hd__a21oi_1
XFILLER_0_32_125 VGND VGND VPWR VPWR sky130_fd_sc_hd__fill_1
Xaccumulator._1919_ accumulator._1003_ accumulator._1006_ accumulator._1002_ VGND
+ VGND VPWR VPWR accumulator._1016_ sky130_fd_sc_hd__and3_1
XFILLER_0_70_209 VPWR VGND VPWR VGND sky130_ef_sc_hd__decap_12
XFILLER_0_11_15 VGND VGND VPWR VPWR sky130_fd_sc_hd__fill_1
XFILLER_0_63_294 VGND VGND VPWR VPWR sky130_fd_sc_hd__decap_8
XFILLER_0_63_272 VGND VGND VPWR VPWR sky130_fd_sc_hd__decap_3
XscaleAdd._571_ scaleAdd._121_ scaleAdd._122_ scaleAdd._148_ VGND VGND VPWR VPWR scaleAdd._149_
+ sky130_fd_sc_hd__and3_1
XscaleAdd._640_ net15 net16 scaleAdd._156_ VGND VGND VPWR VPWR scaleAdd._215_ sky130_fd_sc_hd__o21ba_1
XFILLER_0_11_37 VPWR VGND VPWR VGND sky130_ef_sc_hd__decap_12
XTAP_TAPCELL_ROW_11_234 VGND VPWR sky130_fd_sc_hd__tapvpwrvgnd_1
Xinput8 io_inB[3] VGND VGND VPWR VPWR net8 sky130_fd_sc_hd__buf_1
XFILLER_0_52_77 VGND VGND VPWR VPWR sky130_fd_sc_hd__fill_1
XFILLER_0_14_125 VPWR VGND VPWR VGND sky130_ef_sc_hd__decap_12
Xaccumulator._1704_ accumulator._0559_ accumulator._0684_ accumulator._0687_ accumulator._0734_
+ VGND VGND VPWR VPWR accumulator._0801_ sky130_fd_sc_hd__a211o_1
Xaccumulator._1635_ accumulator._0604_ accumulator._0731_ VGND VGND VPWR VPWR accumulator._0732_
+ sky130_fd_sc_hd__xnor2_2
Xaccumulator._1566_ accumulator._0540_ accumulator._0544_ accumulator._0498_ VGND
+ VGND VPWR VPWR accumulator._0663_ sky130_fd_sc_hd__a21o_1
Xoperator._24_ net6 net7 VGND VGND VPWR VPWR operator._07_ sky130_fd_sc_hd__or2_1
Xaccumulator._1497_ accumulator._0447_ accumulator._0567_ accumulator._0593_ VGND
+ VGND VPWR VPWR accumulator._0594_ sky130_fd_sc_hd__a21o_1
Xaccumulator._2049_ accumulator._1081_ accumulator._1086_ accumulator._1145_ accumulator._1115_
+ VGND VGND VPWR VPWR accumulator._1146_ sky130_fd_sc_hd__a31oi_1
Xaccumulator._2118_ accumulator._0715_ accumulator._1132_ accumulator._1180_ VGND
+ VGND VPWR VPWR accumulator._0052_ sky130_fd_sc_hd__and3_1
XFILLER_0_37_217 VGND VGND VPWR VPWR sky130_fd_sc_hd__decap_6
XTAP_TAPCELL_ROW_25_337 VGND VPWR sky130_fd_sc_hd__tapvpwrvgnd_1
XFILLER_0_9_174 VGND VGND VPWR VPWR sky130_fd_sc_hd__decap_8
XFILLER_0_60_297 VGND VGND VPWR VPWR sky130_fd_sc_hd__decap_8
XFILLER_0_60_253 VGND VGND VPWR VPWR sky130_fd_sc_hd__decap_6
XFILLER_0_5_391 VGND VGND VPWR VPWR sky130_fd_sc_hd__fill_1
XFILLER_0_20_117 VGND VGND VPWR VPWR sky130_fd_sc_hd__fill_2
XFILLER_0_24_412 VGND VGND VPWR VPWR sky130_fd_sc_hd__fill_2
XscaleAdd._623_ scaleAdd._189_ scaleAdd._198_ VGND VGND VPWR VPWR scaleAdd._199_ sky130_fd_sc_hd__xor2_1
XscaleAdd._554_ scaleAdd._127_ scaleAdd._094_ scaleAdd._131_ VGND VGND VPWR VPWR scaleAdd._132_
+ sky130_fd_sc_hd__o21ai_1
XscaleAdd._485_ scaleAdd._063_ scaleAdd._064_ VGND VGND VPWR VPWR scaleAdd._065_ sky130_fd_sc_hd__xor2_1
XFILLER_0_47_55 VGND VGND VPWR VPWR sky130_fd_sc_hd__fill_1
Xaccumulator._1420_ accumulator._0453_ accumulator._0516_ VGND VGND VPWR VPWR accumulator._0517_
+ sky130_fd_sc_hd__and2_1
Xaccumulator._1351_ accumulator._0443_ accumulator._0446_ accumulator._0447_ VGND
+ VGND VPWR VPWR accumulator._0448_ sky130_fd_sc_hd__mux2_1
XTAP_TAPCELL_ROW_22_318 VGND VPWR sky130_fd_sc_hd__tapvpwrvgnd_1
Xaccumulator._1282_ accumulator.io_accOut\[26\] accumulator._0379_ VGND VGND VPWR
+ VPWR accumulator._0381_ sky130_fd_sc_hd__nor2_1
XFILLER_0_19_206 VGND VGND VPWR VPWR sky130_fd_sc_hd__decap_6
XFILLER_0_70_3 VPWR VGND VPWR VGND sky130_ef_sc_hd__decap_12
XFILLER_0_42_253 VPWR VGND VPWR VGND sky130_ef_sc_hd__decap_12
XFILLER_0_6_111 VGND VGND VPWR VPWR sky130_fd_sc_hd__decap_8
XFILLER_0_6_166 VGND VGND VPWR VPWR sky130_fd_sc_hd__decap_3
Xaccumulator._1618_ accumulator._0620_ accumulator._0709_ accumulator._0714_ VGND
+ VGND VPWR VPWR accumulator._0715_ sky130_fd_sc_hd__o21ai_4
XTAP_TAPCELL_ROW_38_440 VGND VPWR sky130_fd_sc_hd__tapvpwrvgnd_1
Xaccumulator._1549_ accumulator.io_accOut\[2\] accumulator._0403_ accumulator._0431_
+ accumulator._0414_ VGND VGND VPWR VPWR accumulator._0646_ sky130_fd_sc_hd__a31o_1
XFILLER_0_18_250 VGND VGND VPWR VPWR sky130_fd_sc_hd__fill_2
XFILLER_0_0_309 VPWR VGND VPWR VGND sky130_ef_sc_hd__decap_12
XFILLER_0_33_57 VPWR VGND VPWR VGND sky130_ef_sc_hd__decap_12
XPHY_EDGE_ROW_26_Left_97 VGND VGND VPWR VPWR sky130_fd_sc_hd__decap_3
XFILLER_0_24_286 VGND VGND VPWR VPWR sky130_fd_sc_hd__fill_2
XFILLER_0_24_253 VGND VGND VPWR VPWR sky130_fd_sc_hd__decap_8
XFILLER_0_3_169 VGND VGND VPWR VPWR sky130_fd_sc_hd__decap_8
XFILLER_0_3_125 VPWR VGND VPWR VGND sky130_ef_sc_hd__decap_12
XscaleAdd._606_ scaleAdd._180_ scaleAdd._182_ VGND VGND VPWR VPWR scaleAdd._183_ sky130_fd_sc_hd__and2_1
Xinput11 io_inScaleA[2] VGND VGND VPWR VPWR net11 sky130_fd_sc_hd__clkbuf_1
XscaleAdd._537_ operator.io_outMant\[2\] scaleAdd._350_ scaleAdd._067_ scaleAdd._115_
+ VGND VGND VPWR VPWR scaleAdd._116_ sky130_fd_sc_hd__a31o_1
XscaleAdd._468_ scaleAdd._013_ scaleAdd._015_ scaleAdd._047_ VGND VGND VPWR VPWR scaleAdd._048_
+ sky130_fd_sc_hd__o21ba_1
XscaleAdd._399_ scaleAdd._319_ scaleAdd._307_ VGND VGND VPWR VPWR scaleAdd._341_ sky130_fd_sc_hd__nand2_1
Xaccumulator._1403_ accumulator._0477_ accumulator._0499_ VGND VGND VPWR VPWR accumulator._0500_
+ sky130_fd_sc_hd__and2_1
Xaccumulator._1334_ accumulator._0421_ accumulator._0422_ accumulator._0430_ VGND
+ VGND VPWR VPWR accumulator._0431_ sky130_fd_sc_hd__a21oi_2
Xaccumulator._2383_ accumulator.io_accOut\[29\] accumulator._0587_ accumulator._0405_
+ VGND VGND VPWR VPWR accumulator._0316_ sky130_fd_sc_hd__mux2_1
Xaccumulator._1265_ accumulator._0337_ accumulator._0347_ VGND VGND VPWR VPWR accumulator._0364_
+ sky130_fd_sc_hd__nor2_1
XFILLER_0_62_315 VGND VGND VPWR VPWR sky130_fd_sc_hd__decap_8
XFILLER_0_59_172 VPWR VGND VPWR VGND sky130_ef_sc_hd__decap_12
XFILLER_0_38_356 VGND VGND VPWR VPWR sky130_fd_sc_hd__fill_2
XFILLER_0_53_337 VGND VGND VPWR VPWR sky130_fd_sc_hd__fill_1
XTAP_TAPCELL_ROW_41_457 VGND VPWR sky130_fd_sc_hd__tapvpwrvgnd_1
XFILLER_0_56_186 VGND VGND VPWR VPWR sky130_fd_sc_hd__decap_4
XFILLER_0_56_175 VGND VGND VPWR VPWR sky130_fd_sc_hd__decap_4
XFILLER_0_44_78 VGND VGND VPWR VPWR sky130_fd_sc_hd__fill_2
XFILLER_0_69_97 VGND VGND VPWR VPWR sky130_fd_sc_hd__fill_1
Xaccumulator._1952_ accumulator._0829_ accumulator._1043_ accumulator._0842_ VGND
+ VGND VPWR VPWR accumulator._1049_ sky130_fd_sc_hd__o21bai_1
Xaccumulator._1883_ accumulator._0975_ accumulator._0979_ VGND VGND VPWR VPWR accumulator._0980_
+ sky130_fd_sc_hd__xnor2_1
XFILLER_0_4_401 VPWR VGND VPWR VGND sky130_ef_sc_hd__decap_12
XFILLER_0_8_78 VGND VGND VPWR VPWR sky130_fd_sc_hd__decap_6
XFILLER_0_33_3 VPWR VGND VPWR VGND sky130_ef_sc_hd__decap_12
XFILLER_0_47_120 VGND VGND VPWR VPWR sky130_fd_sc_hd__decap_4
Xaccumulator._2297_ accumulator._0194_ accumulator._0230_ accumulator._0110_ VGND
+ VGND VPWR VPWR accumulator._0231_ sky130_fd_sc_hd__mux2_1
Xaccumulator._1317_ accumulator._0413_ VGND VGND VPWR VPWR accumulator._0414_ sky130_fd_sc_hd__buf_2
Xaccumulator._1248_ accumulator.io_inExp\[0\] accumulator._0345_ accumulator._0346_
+ VGND VGND VPWR VPWR accumulator._0347_ sky130_fd_sc_hd__o21a_1
Xaccumulator._2366_ accumulator._0297_ accumulator._0298_ VGND VGND VPWR VPWR accumulator._0299_
+ sky130_fd_sc_hd__nor2_1
XFILLER_0_62_167 VPWR VGND VPWR VGND sky130_ef_sc_hd__decap_12
XFILLER_0_50_318 VGND VGND VPWR VPWR sky130_fd_sc_hd__decap_4
XTAP_TAPCELL_ROW_54_560 VGND VPWR sky130_fd_sc_hd__tapvpwrvgnd_1
XFILLER_0_38_197 VGND VGND VPWR VPWR sky130_fd_sc_hd__fill_1
XFILLER_0_26_304 VGND VGND VPWR VPWR sky130_fd_sc_hd__decap_4
XFILLER_0_53_134 VGND VGND VPWR VPWR sky130_fd_sc_hd__decap_4
XFILLER_0_41_329 VGND VGND VPWR VPWR sky130_fd_sc_hd__decap_6
XFILLER_0_30_25 VGND VGND VPWR VPWR sky130_fd_sc_hd__decap_3
Xaccumulator._2082_ accumulator._1176_ accumulator._1154_ accumulator._1179_ VGND
+ VGND VPWR VPWR accumulator._1180_ sky130_fd_sc_hd__a21o_2
XFILLER_0_55_77 VPWR VGND VPWR VGND sky130_ef_sc_hd__decap_12
XFILLER_0_55_55 VGND VGND VPWR VPWR sky130_fd_sc_hd__fill_1
Xaccumulator._2151_ accumulator._0050_ VGND VGND VPWR VPWR accumulator._0086_ sky130_fd_sc_hd__buf_2
Xaccumulator._2220_ accumulator._0080_ accumulator._0153_ accumulator._0154_ accumulator._0089_
+ VGND VGND VPWR VPWR accumulator._0155_ sky130_fd_sc_hd__o211a_1
XFILLER_0_32_307 VGND VGND VPWR VPWR sky130_fd_sc_hd__fill_1
XFILLER_0_17_337 VGND VGND VPWR VPWR sky130_fd_sc_hd__decap_6
Xaccumulator._1866_ accumulator._0882_ accumulator._0954_ accumulator._0952_ accumulator._0962_
+ VGND VGND VPWR VPWR accumulator._0963_ sky130_fd_sc_hd__o31ai_4
Xaccumulator._1797_ accumulator._0887_ accumulator._0893_ VGND VGND VPWR VPWR accumulator._0894_
+ sky130_fd_sc_hd__nor2_1
Xaccumulator._1935_ accumulator._1031_ VGND VGND VPWR VPWR accumulator._1032_ sky130_fd_sc_hd__inv_2
XFILLER_0_4_264 VGND VGND VPWR VPWR sky130_fd_sc_hd__fill_2
XTAP_TAPCELL_ROW_9_219 VGND VPWR sky130_fd_sc_hd__tapvpwrvgnd_1
XTAP_TAPCELL_ROW_68_663 VGND VPWR sky130_fd_sc_hd__tapvpwrvgnd_1
Xaccumulator._2418_ clknet_2_2__leaf_clock accumulator._0019_ VGND VGND VPWR VPWR
+ accumulator.io_accOut\[17\] sky130_fd_sc_hd__dfxtp_1
XPHY_EDGE_ROW_13_Left_84 VGND VGND VPWR VPWR sky130_fd_sc_hd__decap_3
XFILLER_0_67_248 VGND VGND VPWR VPWR sky130_fd_sc_hd__decap_8
Xaccumulator._2349_ accumulator.io_accOut\[26\] accumulator._0280_ accumulator._0405_
+ VGND VGND VPWR VPWR accumulator._0281_ sky130_fd_sc_hd__mux2_1
XTAP_TAPCELL_ROW_0_152 VGND VPWR sky130_fd_sc_hd__tapvpwrvgnd_1
XFILLER_0_31_384 VGND VGND VPWR VPWR sky130_fd_sc_hd__fill_2
XFILLER_0_66_281 VGND VGND VPWR VPWR sky130_fd_sc_hd__fill_1
XFILLER_0_41_57 VGND VGND VPWR VPWR sky130_fd_sc_hd__decap_4
XFILLER_0_26_178 VGND VGND VPWR VPWR sky130_fd_sc_hd__decap_6
XTAP_TAPCELL_ROW_14_254 VGND VPWR sky130_fd_sc_hd__tapvpwrvgnd_1
XFILLER_0_14_307 VGND VGND VPWR VPWR sky130_fd_sc_hd__fill_1
XFILLER_0_14_318 VGND VGND VPWR VPWR sky130_fd_sc_hd__decap_4
XFILLER_0_14_329 VGND VGND VPWR VPWR sky130_fd_sc_hd__decap_6
Xaccumulator._1720_ accumulator._0734_ accumulator._0816_ VGND VGND VPWR VPWR accumulator._0817_
+ sky130_fd_sc_hd__and2_1
Xaccumulator._1651_ accumulator._0559_ accumulator._0611_ accumulator._0598_ VGND
+ VGND VPWR VPWR accumulator._0748_ sky130_fd_sc_hd__or3b_1
XFILLER_0_41_137 VGND VGND VPWR VPWR sky130_fd_sc_hd__decap_4
XFILLER_0_22_362 VGND VGND VPWR VPWR sky130_fd_sc_hd__fill_2
XFILLER_0_5_35 VPWR VGND VPWR VGND sky130_ef_sc_hd__decap_12
XFILLER_0_5_24 VGND VGND VPWR VPWR sky130_fd_sc_hd__fill_2
XFILLER_0_1_223 VGND VGND VPWR VPWR sky130_fd_sc_hd__fill_1
XFILLER_0_1_245 VGND VGND VPWR VPWR sky130_fd_sc_hd__decap_6
XFILLER_0_66_65 VPWR VGND VPWR VGND sky130_ef_sc_hd__decap_12
Xaccumulator._1582_ accumulator.io_accOut\[1\] accumulator._0395_ accumulator._0653_
+ VGND VGND VPWR VPWR accumulator._0679_ sky130_fd_sc_hd__and3_1
XFILLER_0_5_57 VGND VGND VPWR VPWR sky130_fd_sc_hd__fill_2
XFILLER_0_64_207 VGND VGND VPWR VPWR sky130_fd_sc_hd__decap_4
Xaccumulator._2065_ accumulator._0726_ accumulator._1161_ VGND VGND VPWR VPWR accumulator._1162_
+ sky130_fd_sc_hd__xnor2_1
XFILLER_0_49_237 VGND VGND VPWR VPWR sky130_fd_sc_hd__decap_6
XFILLER_0_49_204 VPWR VGND VPWR VGND sky130_ef_sc_hd__decap_12
Xaccumulator._2203_ accumulator._0128_ accumulator._1198_ accumulator._0038_ accumulator._1141_
+ VGND VGND VPWR VPWR accumulator._0139_ sky130_fd_sc_hd__a211o_1
Xaccumulator._2134_ accumulator._0068_ VGND VGND VPWR VPWR accumulator._0004_ sky130_fd_sc_hd__clkbuf_1
XFILLER_0_15_80 VGND VGND VPWR VPWR sky130_fd_sc_hd__decap_8
XscaleAdd._737__57 VGND VGND VPWR VPWR scaleAdd._737__57/HI net57 sky130_fd_sc_hd__conb_1
Xaccumulator._1849_ accumulator._0846_ accumulator._0848_ VGND VGND VPWR VPWR accumulator._0946_
+ sky130_fd_sc_hd__nand2_1
Xaccumulator._1918_ accumulator._1012_ accumulator._1014_ VGND VGND VPWR VPWR accumulator._1015_
+ sky130_fd_sc_hd__xnor2_2
XFILLER_0_11_49 VGND VGND VPWR VPWR sky130_fd_sc_hd__decap_6
XTAP_TAPCELL_ROW_11_235 VGND VPWR sky130_fd_sc_hd__tapvpwrvgnd_1
XscaleAdd._570_ scaleAdd._123_ scaleAdd._147_ VGND VGND VPWR VPWR scaleAdd._148_ sky130_fd_sc_hd__xnor2_1
XFILLER_0_36_79 VGND VGND VPWR VPWR sky130_fd_sc_hd__decap_4
Xinput9 io_inScaleA[0] VGND VGND VPWR VPWR net9 sky130_fd_sc_hd__buf_1
XTAP_TAPCELL_ROW_62_614 VGND VPWR sky130_fd_sc_hd__tapvpwrvgnd_1
XFILLER_0_46_218 VGND VGND VPWR VPWR sky130_fd_sc_hd__fill_1
XTAP_TAPCELL_ROW_70_680 VGND VPWR sky130_fd_sc_hd__tapvpwrvgnd_1
XFILLER_0_54_240 VPWR VGND VPWR VGND sky130_ef_sc_hd__decap_12
XFILLER_0_39_281 VGND VGND VPWR VPWR sky130_fd_sc_hd__decap_4
XFILLER_0_14_137 VGND VGND VPWR VPWR sky130_fd_sc_hd__decap_3
Xaccumulator._1703_ accumulator._0697_ accumulator._0700_ accumulator._0734_ VGND
+ VGND VPWR VPWR accumulator._0800_ sky130_fd_sc_hd__o21ai_1
Xaccumulator._1634_ accumulator._0605_ accumulator._0678_ accumulator._0730_ VGND
+ VGND VPWR VPWR accumulator._0731_ sky130_fd_sc_hd__a21bo_1
XFILLER_0_22_170 VPWR VGND VPWR VGND sky130_ef_sc_hd__decap_12
XscaleAdd._699_ scaleAdd._265_ scaleAdd._256_ scaleAdd._269_ VGND VGND VPWR VPWR scaleAdd._271_
+ sky130_fd_sc_hd__o21ba_1
XFILLER_0_10_321 VPWR VGND VPWR VGND sky130_ef_sc_hd__decap_12
XFILLER_0_10_365 VPWR VGND VPWR VGND sky130_ef_sc_hd__decap_12
Xaccumulator._1565_ accumulator._0515_ accumulator._0519_ accumulator._0476_ VGND
+ VGND VPWR VPWR accumulator._0662_ sky130_fd_sc_hd__a21o_1
XFILLER_0_26_90 VGND VGND VPWR VPWR sky130_fd_sc_hd__fill_2
Xoperator._23_ operator._05_ operator._06_ VGND VGND VPWR VPWR operator.io_outMant\[1\]
+ sky130_fd_sc_hd__xnor2_4
Xaccumulator._1496_ accumulator.io_inMant\[16\] accumulator._0335_ accumulator._0455_
+ accumulator._0579_ accumulator._0116_ VGND VGND VPWR VPWR accumulator._0593_ sky130_fd_sc_hd__a221o_1
Xaccumulator._2048_ accumulator._0998_ accumulator._1008_ accumulator._1010_ accumulator._1143_
+ accumulator._1144_ VGND VGND VPWR VPWR accumulator._1145_ sky130_fd_sc_hd__a41o_1
Xaccumulator._2117_ net70 VGND VGND VPWR VPWR accumulator._0051_ sky130_fd_sc_hd__buf_2
XTAP_TAPCELL_ROW_25_338 VGND VPWR sky130_fd_sc_hd__tapvpwrvgnd_1
XFILLER_0_9_186 VPWR VGND VPWR VGND sky130_ef_sc_hd__decap_12
XFILLER_0_45_284 VGND VGND VPWR VPWR sky130_fd_sc_hd__decap_6
XFILLER_0_68_365 VPWR VGND VPWR VGND sky130_ef_sc_hd__decap_12
XFILLER_0_68_321 VPWR VGND VPWR VGND sky130_ef_sc_hd__decap_12
XPHY_EDGE_ROW_38_Left_109 VGND VGND VPWR VPWR sky130_fd_sc_hd__decap_3
XFILLER_0_22_26 VGND VGND VPWR VPWR sky130_fd_sc_hd__fill_2
XscaleAdd._622_ scaleAdd._108_ scaleAdd._196_ scaleAdd._197_ VGND VGND VPWR VPWR scaleAdd._198_
+ sky130_fd_sc_hd__o21a_1
XPHY_EDGE_ROW_47_Left_118 VGND VGND VPWR VPWR sky130_fd_sc_hd__decap_3
XscaleAdd._553_ scaleAdd._091_ scaleAdd._130_ VGND VGND VPWR VPWR scaleAdd._131_ sky130_fd_sc_hd__xnor2_1
XscaleAdd._484_ operator.io_outMant\[1\] scaleAdd._025_ VGND VGND VPWR VPWR scaleAdd._064_
+ sky130_fd_sc_hd__nand2_1
XFILLER_0_11_107 VGND VGND VPWR VPWR sky130_fd_sc_hd__decap_4
XFILLER_0_11_118 VPWR VGND VPWR VGND sky130_ef_sc_hd__decap_12
XFILLER_0_63_55 VGND VGND VPWR VPWR sky130_fd_sc_hd__fill_1
XFILLER_0_59_310 VPWR VGND VPWR VGND sky130_ef_sc_hd__decap_12
XPHY_EDGE_ROW_56_Left_127 VGND VGND VPWR VPWR sky130_fd_sc_hd__decap_3
Xaccumulator._1281_ accumulator.io_accOut\[26\] accumulator._0379_ VGND VGND VPWR
+ VPWR accumulator._0380_ sky130_fd_sc_hd__and2_1
Xaccumulator._1350_ net68 accumulator._0244_ VGND VGND VPWR VPWR accumulator._0447_
+ sky130_fd_sc_hd__nor2_2
XPHY_EDGE_ROW_10_Right_10 VGND VGND VPWR VPWR sky130_fd_sc_hd__decap_3
XFILLER_0_63_99 VGND VGND VPWR VPWR sky130_fd_sc_hd__decap_4
XTAP_TAPCELL_ROW_22_319 VGND VPWR sky130_fd_sc_hd__tapvpwrvgnd_1
XFILLER_0_6_123 VGND VGND VPWR VPWR sky130_fd_sc_hd__fill_1
XPHY_EDGE_ROW_65_Left_136 VGND VGND VPWR VPWR sky130_fd_sc_hd__decap_3
XFILLER_0_63_3 VPWR VGND VPWR VGND sky130_ef_sc_hd__decap_12
XFILLER_0_42_243 VGND VGND VPWR VPWR sky130_fd_sc_hd__decap_3
XTAP_TAPCELL_ROW_30_374 VGND VPWR sky130_fd_sc_hd__tapvpwrvgnd_1
XFILLER_0_6_178 VGND VGND VPWR VPWR sky130_fd_sc_hd__fill_1
Xaccumulator._1617_ accumulator._0606_ accumulator._0710_ accumulator._0711_ accumulator._0713_
+ accumulator._0650_ VGND VGND VPWR VPWR accumulator._0714_ sky130_fd_sc_hd__a311o_1
XFILLER_0_10_195 VGND VGND VPWR VPWR sky130_fd_sc_hd__fill_1
Xaccumulator._1548_ accumulator.io_accOut\[1\] net60 accumulator._0431_ VGND VGND
+ VPWR VPWR accumulator._0645_ sky130_fd_sc_hd__and3_1
XTAP_TAPCELL_ROW_38_441 VGND VPWR sky130_fd_sc_hd__tapvpwrvgnd_1
Xaccumulator._1479_ accumulator._0435_ accumulator._0502_ accumulator._0575_ VGND
+ VGND VPWR VPWR accumulator._0576_ sky130_fd_sc_hd__a21o_1
XFILLER_0_65_335 VGND VGND VPWR VPWR sky130_fd_sc_hd__fill_1
XFILLER_0_21_405 VGND VGND VPWR VPWR sky130_fd_sc_hd__decap_6
XFILLER_0_33_69 VPWR VGND VPWR VGND sky130_ef_sc_hd__decap_12
XPHY_EDGE_ROW_1_Left_72 VGND VGND VPWR VPWR sky130_fd_sc_hd__decap_3
XFILLER_0_64_390 VPWR VGND VPWR VGND sky130_ef_sc_hd__decap_12
XFILLER_0_3_137 VPWR VGND VPWR VGND sky130_ef_sc_hd__decap_12
XscaleAdd._605_ scaleAdd._178_ scaleAdd._181_ VGND VGND VPWR VPWR scaleAdd._182_ sky130_fd_sc_hd__or2_1
XscaleAdd._536_ scaleAdd._065_ scaleAdd._066_ VGND VGND VPWR VPWR scaleAdd._115_ sky130_fd_sc_hd__nor2_1
Xinput12 io_inScaleA[3] VGND VGND VPWR VPWR net12 sky130_fd_sc_hd__clkbuf_1
Xaccumulator._1402_ accumulator._0487_ accumulator._0496_ accumulator._0498_ VGND
+ VGND VPWR VPWR accumulator._0499_ sky130_fd_sc_hd__a21o_1
XscaleAdd._398_ scaleAdd._336_ scaleAdd._339_ VGND VGND VPWR VPWR scaleAdd._340_ sky130_fd_sc_hd__nor2_1
XscaleAdd._467_ scaleAdd._319_ scaleAdd._308_ scaleAdd._016_ VGND VGND VPWR VPWR scaleAdd._047_
+ sky130_fd_sc_hd__and3_1
XFILLER_0_59_151 VGND VGND VPWR VPWR sky130_fd_sc_hd__decap_3
Xaccumulator._2382_ accumulator._0041_ accumulator._0306_ VGND VGND VPWR VPWR accumulator._0315_
+ sky130_fd_sc_hd__or2_1
Xaccumulator._1333_ accumulator._0389_ accumulator._0429_ VGND VGND VPWR VPWR accumulator._0430_
+ sky130_fd_sc_hd__xor2_2
Xaccumulator._1264_ accumulator._0344_ accumulator._0347_ VGND VGND VPWR VPWR accumulator._0363_
+ sky130_fd_sc_hd__and2b_1
XFILLER_0_59_195 VPWR VGND VPWR VGND sky130_ef_sc_hd__decap_12
XFILLER_0_59_184 VGND VGND VPWR VPWR sky130_fd_sc_hd__decap_8
XFILLER_0_47_368 VGND VGND VPWR VPWR sky130_fd_sc_hd__fill_2
XFILLER_0_47_346 VPWR VGND VPWR VGND sky130_ef_sc_hd__decap_12
XFILLER_0_47_335 VGND VGND VPWR VPWR sky130_fd_sc_hd__fill_1
XFILLER_0_15_243 VGND VGND VPWR VPWR sky130_fd_sc_hd__decap_4
XFILLER_0_15_254 VPWR VGND VPWR VGND sky130_ef_sc_hd__decap_12
XFILLER_0_70_393 VPWR VGND VPWR VGND sky130_ef_sc_hd__decap_12
XFILLER_0_65_121 VGND VGND VPWR VPWR sky130_fd_sc_hd__decap_3
XFILLER_0_65_110 VGND VGND VPWR VPWR sky130_fd_sc_hd__fill_2
XFILLER_0_53_305 VGND VGND VPWR VPWR sky130_fd_sc_hd__decap_8
XFILLER_0_38_379 VGND VGND VPWR VPWR sky130_fd_sc_hd__fill_2
XFILLER_0_61_393 VPWR VGND VPWR VGND sky130_ef_sc_hd__decap_12
XTAP_TAPCELL_ROW_41_458 VGND VPWR sky130_fd_sc_hd__tapvpwrvgnd_1
XFILLER_0_21_246 VGND VGND VPWR VPWR sky130_fd_sc_hd__decap_4
XFILLER_0_21_202 VGND VGND VPWR VPWR sky130_fd_sc_hd__decap_4
XFILLER_0_28_69 VGND VGND VPWR VPWR sky130_fd_sc_hd__fill_1
XTAP_TAPCELL_ROW_57_580 VGND VPWR sky130_fd_sc_hd__tapvpwrvgnd_1
XFILLER_0_29_368 VPWR VGND VPWR VGND sky130_ef_sc_hd__decap_12
XFILLER_0_4_413 VGND VGND VPWR VPWR sky130_fd_sc_hd__decap_6
Xaccumulator._1951_ accumulator._0827_ accumulator._0926_ accumulator._0943_ accumulator._0826_
+ VGND VGND VPWR VPWR accumulator._1048_ sky130_fd_sc_hd__a31o_1
Xaccumulator._1882_ accumulator._0920_ accumulator._0968_ accumulator._0972_ VGND
+ VGND VPWR VPWR accumulator._0979_ sky130_fd_sc_hd__a21oi_2
XscaleAdd._519_ scaleAdd._082_ scaleAdd._097_ VGND VGND VPWR VPWR scaleAdd._098_ sky130_fd_sc_hd__xor2_2
Xaccumulator._2365_ accumulator._1141_ accumulator._0281_ accumulator._0296_ VGND
+ VGND VPWR VPWR accumulator._0298_ sky130_fd_sc_hd__a21oi_1
Xaccumulator._2296_ accumulator._0211_ accumulator._0229_ accumulator._0061_ VGND
+ VGND VPWR VPWR accumulator._0230_ sky130_fd_sc_hd__mux2_2
Xaccumulator._1316_ accumulator._0373_ accumulator._0412_ VGND VGND VPWR VPWR accumulator._0413_
+ sky130_fd_sc_hd__and2_1
Xaccumulator._1247_ accumulator._0337_ accumulator._0225_ VGND VGND VPWR VPWR accumulator._0346_
+ sky130_fd_sc_hd__and2b_1
XFILLER_0_62_179 VPWR VGND VPWR VGND sky130_ef_sc_hd__decap_12
XFILLER_0_62_135 VGND VGND VPWR VPWR sky130_fd_sc_hd__decap_4
XFILLER_0_62_113 VPWR VGND VPWR VGND sky130_ef_sc_hd__decap_12
XFILLER_0_43_393 VPWR VGND VPWR VGND sky130_ef_sc_hd__decap_12
Xclone15 accumulator._0430_ accumulator._0431_ accumulator._0402_ VGND VGND VPWR VPWR
+ net72 sky130_fd_sc_hd__mux2_2
XFILLER_0_58_408 VPWR VGND VPWR VGND sky130_ef_sc_hd__decap_12
XTAP_TAPCELL_ROW_3_172 VGND VPWR sky130_fd_sc_hd__tapvpwrvgnd_1
XTAP_TAPCELL_ROW_54_561 VGND VPWR sky130_fd_sc_hd__tapvpwrvgnd_1
XFILLER_0_53_146 VPWR VGND VPWR VGND sky130_ef_sc_hd__decap_12
XFILLER_0_53_113 VGND VGND VPWR VPWR sky130_fd_sc_hd__fill_1
XFILLER_0_38_121 VGND VGND VPWR VPWR sky130_fd_sc_hd__decap_3
XFILLER_0_39_57 VGND VGND VPWR VPWR sky130_fd_sc_hd__decap_8
XFILLER_0_1_405 VPWR VGND VPWR VGND sky130_ef_sc_hd__decap_12
Xaccumulator._2081_ accumulator._1177_ accumulator._1137_ accumulator._1130_ VGND
+ VGND VPWR VPWR accumulator._1179_ sky130_fd_sc_hd__a21bo_1
XFILLER_0_55_89 VPWR VGND VPWR VGND sky130_ef_sc_hd__decap_12
Xaccumulator._2150_ accumulator._1198_ accumulator._0083_ accumulator._1149_ VGND
+ VGND VPWR VPWR accumulator._0084_ sky130_fd_sc_hd__mux2_1
XFILLER_0_29_110 VGND VGND VPWR VPWR sky130_fd_sc_hd__fill_2
XPHY_EDGE_ROW_8_Right_8 VGND VGND VPWR VPWR sky130_fd_sc_hd__decap_3
Xaccumulator._1934_ accumulator._1028_ accumulator._1030_ VGND VGND VPWR VPWR accumulator._1031_
+ sky130_fd_sc_hd__xnor2_2
XFILLER_0_4_221 VPWR VGND VPWR VGND sky130_ef_sc_hd__decap_12
Xaccumulator._1865_ accumulator._0885_ accumulator._0955_ accumulator._0959_ accumulator._0961_
+ VGND VGND VPWR VPWR accumulator._0962_ sky130_fd_sc_hd__o211a_1
Xaccumulator._1796_ accumulator._0892_ VGND VGND VPWR VPWR accumulator._0893_ sky130_fd_sc_hd__clkbuf_2
XPHY_EDGE_ROW_39_Right_39 VGND VGND VPWR VPWR sky130_fd_sc_hd__decap_3
XTAP_TAPCELL_ROW_68_664 VGND VPWR sky130_fd_sc_hd__tapvpwrvgnd_1
XFILLER_0_67_205 VGND VGND VPWR VPWR sky130_fd_sc_hd__fill_2
Xaccumulator._2417_ clknet_2_2__leaf_clock accumulator._0018_ VGND VGND VPWR VPWR
+ accumulator.io_accOut\[16\] sky130_fd_sc_hd__dfxtp_1
Xaccumulator._2348_ accumulator._0379_ VGND VGND VPWR VPWR accumulator._0280_ sky130_fd_sc_hd__inv_2
XTAP_TAPCELL_ROW_0_153 VGND VPWR sky130_fd_sc_hd__tapvpwrvgnd_1
XTAP_TAPCELL_ROW_0_142 VGND VPWR sky130_fd_sc_hd__tapvpwrvgnd_1
XFILLER_0_63_411 VGND VGND VPWR VPWR sky130_fd_sc_hd__decap_8
XPHY_EDGE_ROW_48_Right_48 VGND VGND VPWR VPWR sky130_fd_sc_hd__decap_3
Xaccumulator._2279_ accumulator._0181_ accumulator._0212_ accumulator._0110_ VGND
+ VGND VPWR VPWR accumulator._0213_ sky130_fd_sc_hd__mux2_1
XFILLER_0_35_113 VGND VGND VPWR VPWR sky130_fd_sc_hd__fill_2
XPHY_EDGE_ROW_57_Right_57 VGND VGND VPWR VPWR sky130_fd_sc_hd__decap_3
XFILLER_0_50_105 VGND VGND VPWR VPWR sky130_fd_sc_hd__fill_2
XPHY_EDGE_ROW_66_Right_66 VGND VGND VPWR VPWR sky130_fd_sc_hd__decap_3
XFILLER_0_25_26 VGND VGND VPWR VPWR sky130_fd_sc_hd__fill_2
XTAP_TAPCELL_ROW_14_255 VGND VPWR sky130_fd_sc_hd__tapvpwrvgnd_1
Xaccumulator._1650_ accumulator._0559_ accumulator._0716_ accumulator._0717_ accumulator._0734_
+ VGND VGND VPWR VPWR accumulator._0747_ sky130_fd_sc_hd__a211o_1
Xaccumulator._1581_ accumulator._0655_ accumulator._0677_ VGND VGND VPWR VPWR accumulator._0678_
+ sky130_fd_sc_hd__and2_1
XFILLER_0_5_47 VGND VGND VPWR VPWR sky130_fd_sc_hd__decap_8
XFILLER_0_66_77 VGND VGND VPWR VPWR sky130_fd_sc_hd__decap_6
Xaccumulator._2202_ accumulator._0128_ accumulator._0083_ accumulator._0137_ VGND
+ VGND VPWR VPWR accumulator._0138_ sky130_fd_sc_hd__o21a_1
Xaccumulator._2064_ accumulator._0923_ accumulator._0715_ VGND VGND VPWR VPWR accumulator._1161_
+ sky130_fd_sc_hd__nand2_1
XFILLER_0_49_216 VGND VGND VPWR VPWR sky130_fd_sc_hd__decap_8
XFILLER_0_45_411 VGND VGND VPWR VPWR sky130_fd_sc_hd__decap_6
Xaccumulator._2133_ accumulator._0399_ accumulator._0067_ VGND VGND VPWR VPWR accumulator._0068_
+ sky130_fd_sc_hd__and2_1
XFILLER_0_17_113 VGND VGND VPWR VPWR sky130_fd_sc_hd__decap_4
Xaccumulator._1917_ accumulator._1013_ accumulator._0798_ accumulator._0922_ VGND
+ VGND VPWR VPWR accumulator._1014_ sky130_fd_sc_hd__mux2_1
Xaccumulator._1848_ accumulator._0871_ accumulator._0851_ VGND VGND VPWR VPWR accumulator._0945_
+ sky130_fd_sc_hd__or2b_1
Xaccumulator._1779_ accumulator._0872_ accumulator._0861_ accumulator._0875_ VGND
+ VGND VPWR VPWR accumulator._0876_ sky130_fd_sc_hd__o21ai_1
XFILLER_0_40_182 VPWR VGND VPWR VGND sky130_ef_sc_hd__decap_12
XFILLER_0_51_414 VGND VGND VPWR VPWR sky130_fd_sc_hd__decap_3
XFILLER_0_48_282 VGND VGND VPWR VPWR sky130_fd_sc_hd__fill_1
XFILLER_0_23_138 VGND VGND VPWR VPWR sky130_fd_sc_hd__decap_8
XTAP_TAPCELL_ROW_11_236 VGND VPWR sky130_fd_sc_hd__tapvpwrvgnd_1
XFILLER_0_31_182 VGND VGND VPWR VPWR sky130_fd_sc_hd__fill_1
XTAP_TAPCELL_ROW_70_681 VGND VPWR sky130_fd_sc_hd__tapvpwrvgnd_1
XTAP_TAPCELL_ROW_62_615 VGND VPWR sky130_fd_sc_hd__tapvpwrvgnd_1
XscaleAdd._698_ scaleAdd._265_ scaleAdd._256_ scaleAdd._269_ VGND VGND VPWR VPWR scaleAdd._270_
+ sky130_fd_sc_hd__nor3b_2
Xaccumulator._1702_ accumulator._0743_ accumulator._0744_ VGND VGND VPWR VPWR accumulator._0799_
+ sky130_fd_sc_hd__or2_1
Xaccumulator._1564_ accumulator._0525_ accumulator._0657_ accumulator._0660_ accumulator._0557_
+ accumulator._0523_ VGND VGND VPWR VPWR accumulator._0661_ sky130_fd_sc_hd__o2111ai_4
Xaccumulator._1633_ accumulator._0605_ accumulator._0679_ accumulator._0729_ VGND
+ VGND VPWR VPWR accumulator._0730_ sky130_fd_sc_hd__or3_1
XFILLER_0_22_193 VGND VGND VPWR VPWR sky130_fd_sc_hd__decap_3
XFILLER_0_22_182 VGND VGND VPWR VPWR sky130_fd_sc_hd__decap_6
XFILLER_0_10_333 VPWR VGND VPWR VGND sky130_ef_sc_hd__decap_12
XFILLER_0_10_377 VPWR VGND VPWR VGND sky130_ef_sc_hd__decap_12
Xaccumulator._1495_ accumulator._0587_ accumulator._0591_ accumulator._0402_ VGND
+ VGND VPWR VPWR accumulator._0592_ sky130_fd_sc_hd__mux2_1
Xoperator._22_ net2 net3 net5 VGND VGND VPWR VPWR operator._06_ sky130_fd_sc_hd__o21a_1
XTAP_TAPCELL_ROW_25_339 VGND VPWR sky130_fd_sc_hd__tapvpwrvgnd_1
Xaccumulator._2047_ accumulator._1040_ accumulator._1057_ VGND VGND VPWR VPWR accumulator._1144_
+ sky130_fd_sc_hd__nand2_1
XFILLER_0_60_211 VGND VGND VPWR VPWR sky130_fd_sc_hd__fill_2
Xaccumulator._2116_ accumulator._1148_ VGND VGND VPWR VPWR accumulator._0050_ sky130_fd_sc_hd__inv_2
XFILLER_0_9_198 VGND VGND VPWR VPWR sky130_fd_sc_hd__decap_4
XFILLER_0_60_266 VPWR VGND VPWR VGND sky130_ef_sc_hd__decap_12
XFILLER_0_5_393 VPWR VGND VPWR VGND sky130_ef_sc_hd__decap_12
XFILLER_0_13_160 VGND VGND VPWR VPWR sky130_fd_sc_hd__decap_8
XFILLER_0_68_377 VPWR VGND VPWR VGND sky130_ef_sc_hd__decap_12
XFILLER_0_68_333 VPWR VGND VPWR VGND sky130_ef_sc_hd__decap_12
XFILLER_0_22_49 VGND VGND VPWR VPWR sky130_fd_sc_hd__fill_1
XFILLER_0_51_255 VPWR VGND VPWR VGND sky130_ef_sc_hd__decap_12
XscaleAdd._621_ scaleAdd._312_ net64 scaleAdd._195_ scaleAdd._313_ VGND VGND VPWR
+ VPWR scaleAdd._197_ sky130_fd_sc_hd__a22o_1
XscaleAdd._552_ scaleAdd._003_ scaleAdd._128_ scaleAdd._129_ VGND VGND VPWR VPWR scaleAdd._130_
+ sky130_fd_sc_hd__o21a_1
XFILLER_0_47_57 VGND VGND VPWR VPWR sky130_fd_sc_hd__decap_3
XscaleAdd._483_ scaleAdd._043_ scaleAdd._062_ VGND VGND VPWR VPWR scaleAdd._063_ sky130_fd_sc_hd__xnor2_1
XFILLER_0_59_322 VGND VGND VPWR VPWR sky130_fd_sc_hd__decap_8
XFILLER_0_59_300 VGND VGND VPWR VPWR sky130_fd_sc_hd__decap_6
Xaccumulator._1280_ accumulator._0352_ accumulator._0378_ accumulator._0362_ VGND
+ VGND VPWR VPWR accumulator._0379_ sky130_fd_sc_hd__a21o_1
XFILLER_0_2_37 VPWR VGND VPWR VGND sky130_ef_sc_hd__decap_12
XFILLER_0_2_15 VPWR VGND VPWR VGND sky130_ef_sc_hd__decap_12
XFILLER_0_27_296 VGND VGND VPWR VPWR sky130_fd_sc_hd__fill_1
XFILLER_0_27_285 VGND VGND VPWR VPWR sky130_fd_sc_hd__fill_1
XFILLER_0_6_146 VPWR VGND VPWR VGND sky130_ef_sc_hd__decap_12
XFILLER_0_56_3 VPWR VGND VPWR VGND sky130_ef_sc_hd__decap_12
XFILLER_0_42_299 VGND VGND VPWR VPWR sky130_fd_sc_hd__decap_8
XTAP_TAPCELL_ROW_30_375 VGND VPWR sky130_fd_sc_hd__tapvpwrvgnd_1
XFILLER_0_2_363 VGND VGND VPWR VPWR sky130_fd_sc_hd__fill_1
XFILLER_0_10_130 VGND VGND VPWR VPWR sky130_fd_sc_hd__decap_8
XFILLER_0_10_141 VPWR VGND VPWR VGND sky130_ef_sc_hd__decap_12
Xaccumulator._1616_ accumulator._0501_ accumulator._0648_ accumulator._0712_ accumulator._0523_
+ VGND VGND VPWR VPWR accumulator._0713_ sky130_fd_sc_hd__o211a_1
Xaccumulator._1547_ accumulator.io_accOut\[4\] accumulator._0469_ accumulator._0531_
+ accumulator._0643_ VGND VGND VPWR VPWR accumulator._0644_ sky130_fd_sc_hd__a31oi_1
Xaccumulator._1478_ accumulator._0443_ accumulator._0574_ accumulator._0263_ VGND
+ VGND VPWR VPWR accumulator._0575_ sky130_fd_sc_hd__mux2_1
XFILLER_0_33_233 VGND VGND VPWR VPWR sky130_fd_sc_hd__decap_3
XFILLER_0_33_222 VGND VGND VPWR VPWR sky130_fd_sc_hd__fill_2
XFILLER_0_33_15 VPWR VGND VPWR VGND sky130_ef_sc_hd__decap_12
XFILLER_0_68_141 VGND VGND VPWR VPWR sky130_fd_sc_hd__fill_1
XFILLER_0_56_347 VGND VGND VPWR VPWR sky130_fd_sc_hd__fill_2
Xinput13 io_inScaleA[4] VGND VGND VPWR VPWR net13 sky130_fd_sc_hd__buf_2
XFILLER_0_24_266 VPWR VGND VPWR VGND sky130_ef_sc_hd__decap_12
XFILLER_0_3_149 VGND VGND VPWR VPWR sky130_fd_sc_hd__decap_3
XscaleAdd._604_ scaleAdd._120_ net73 scaleAdd._150_ scaleAdd._179_ VGND VGND VPWR
+ VPWR scaleAdd._181_ sky130_fd_sc_hd__o31a_1
XscaleAdd._535_ scaleAdd._076_ scaleAdd._113_ VGND VGND VPWR VPWR scaleAdd._114_ sky130_fd_sc_hd__xor2_1
XscaleAdd._466_ scaleAdd._020_ scaleAdd._044_ scaleAdd._001_ VGND VGND VPWR VPWR scaleAdd._046_
+ sky130_fd_sc_hd__o21bai_1
Xaccumulator._1401_ accumulator._0497_ VGND VGND VPWR VPWR accumulator._0498_ sky130_fd_sc_hd__clkbuf_4
Xaccumulator._2381_ accumulator._0307_ accumulator._0311_ accumulator._0312_ accumulator._0300_
+ VGND VGND VPWR VPWR accumulator._0314_ sky130_fd_sc_hd__o22a_1
XscaleAdd._397_ scaleAdd._337_ scaleAdd._338_ scaleAdd._303_ VGND VGND VPWR VPWR scaleAdd._339_
+ sky130_fd_sc_hd__o21ai_1
XTAP_TAPCELL_ROW_35_412 VGND VPWR sky130_fd_sc_hd__tapvpwrvgnd_1
Xaccumulator._1332_ accumulator._0391_ accumulator._0390_ VGND VGND VPWR VPWR accumulator._0429_
+ sky130_fd_sc_hd__nand2_1
Xaccumulator._1263_ accumulator._0343_ accumulator._0356_ VGND VGND VPWR VPWR accumulator._0362_
+ sky130_fd_sc_hd__and2_4
XFILLER_0_70_361 VGND VGND VPWR VPWR sky130_fd_sc_hd__decap_3
XFILLER_0_62_328 VGND VGND VPWR VPWR sky130_fd_sc_hd__decap_4
XFILLER_0_55_391 VGND VGND VPWR VPWR sky130_fd_sc_hd__fill_1
XFILLER_0_47_358 VGND VGND VPWR VPWR sky130_fd_sc_hd__decap_3
XFILLER_0_15_200 VPWR VGND VPWR VGND sky130_ef_sc_hd__decap_12
XFILLER_0_15_266 VGND VGND VPWR VPWR sky130_fd_sc_hd__decap_6
XFILLER_0_65_199 VGND VGND VPWR VPWR sky130_fd_sc_hd__decap_6
XFILLER_0_65_133 VPWR VGND VPWR VGND sky130_ef_sc_hd__decap_12
XTAP_TAPCELL_ROW_41_459 VGND VPWR sky130_fd_sc_hd__tapvpwrvgnd_1
XFILLER_0_38_347 VGND VGND VPWR VPWR sky130_fd_sc_hd__fill_1
XFILLER_0_38_314 VGND VGND VPWR VPWR sky130_fd_sc_hd__decap_8
XFILLER_0_21_225 VGND VGND VPWR VPWR sky130_fd_sc_hd__decap_3
XFILLER_0_28_15 VPWR VGND VPWR VGND sky130_ef_sc_hd__decap_12
XTAP_TAPCELL_ROW_57_581 VGND VPWR sky130_fd_sc_hd__tapvpwrvgnd_1
XFILLER_0_56_122 VGND VGND VPWR VPWR sky130_fd_sc_hd__fill_2
XFILLER_0_29_303 VGND VGND VPWR VPWR sky130_fd_sc_hd__fill_2
Xaccumulator._1950_ accumulator._1041_ accumulator._1046_ accumulator._0992_ VGND
+ VGND VPWR VPWR accumulator._1047_ sky130_fd_sc_hd__a21o_1
XFILLER_0_52_372 VGND VGND VPWR VPWR sky130_fd_sc_hd__decap_4
XFILLER_0_29_358 VGND VGND VPWR VPWR sky130_fd_sc_hd__fill_1
XFILLER_0_69_55 VGND VGND VPWR VPWR sky130_fd_sc_hd__fill_1
XFILLER_0_52_394 VGND VGND VPWR VPWR sky130_fd_sc_hd__decap_3
Xaccumulator._1881_ accumulator._0732_ accumulator._0977_ VGND VGND VPWR VPWR accumulator._0978_
+ sky130_fd_sc_hd__xnor2_2
XscaleAdd._518_ scaleAdd._094_ scaleAdd._096_ VGND VGND VPWR VPWR scaleAdd._097_ sky130_fd_sc_hd__nor2_1
XFILLER_0_8_58 VGND VGND VPWR VPWR sky130_fd_sc_hd__fill_2
XscaleAdd._449_ scaleAdd._352_ scaleAdd._353_ VGND VGND VPWR VPWR scaleAdd._030_ sky130_fd_sc_hd__and2b_1
Xaccumulator._1315_ accumulator.io_accOut\[23\] accumulator._0411_ VGND VGND VPWR
+ VPWR accumulator._0412_ sky130_fd_sc_hd__nand2_1
Xaccumulator._2364_ accumulator._1141_ accumulator._0281_ accumulator._0296_ VGND
+ VGND VPWR VPWR accumulator._0297_ sky130_fd_sc_hd__and3_1
Xaccumulator._2295_ accumulator._1113_ accumulator._1111_ accumulator._1184_ VGND
+ VGND VPWR VPWR accumulator._0229_ sky130_fd_sc_hd__mux2_2
XFILLER_0_47_177 VGND VGND VPWR VPWR sky130_fd_sc_hd__fill_2
XFILLER_0_35_328 VGND VGND VPWR VPWR sky130_fd_sc_hd__decap_3
XFILLER_0_35_306 VGND VGND VPWR VPWR sky130_fd_sc_hd__decap_6
Xaccumulator._1246_ accumulator._0336_ VGND VGND VPWR VPWR accumulator._0345_ sky130_fd_sc_hd__clkbuf_4
XFILLER_0_62_125 VGND VGND VPWR VPWR sky130_fd_sc_hd__fill_2
XFILLER_0_28_380 VPWR VGND VPWR VGND sky130_ef_sc_hd__decap_12
XTAP_TAPCELL_ROW_3_173 VGND VPWR sky130_fd_sc_hd__tapvpwrvgnd_1
XFILLER_0_53_169 VPWR VGND VPWR VGND sky130_ef_sc_hd__decap_12
XFILLER_0_53_158 VGND VGND VPWR VPWR sky130_fd_sc_hd__decap_8
XFILLER_0_53_103 VGND VGND VPWR VPWR sky130_fd_sc_hd__fill_1
XFILLER_0_1_417 VGND VGND VPWR VPWR sky130_fd_sc_hd__decap_4
XFILLER_0_55_57 VGND VGND VPWR VPWR sky130_fd_sc_hd__decap_3
Xaccumulator._2080_ accumulator._1135_ VGND VGND VPWR VPWR accumulator._1177_ sky130_fd_sc_hd__inv_2
XFILLER_0_57_420 VGND VGND VPWR VPWR sky130_fd_sc_hd__fill_1
XFILLER_0_49_409 VGND VGND VPWR VPWR sky130_fd_sc_hd__decap_8
Xaccumulator._1864_ accumulator._0885_ accumulator._0955_ accumulator._0960_ VGND
+ VGND VPWR VPWR accumulator._0961_ sky130_fd_sc_hd__a21bo_1
Xaccumulator._1933_ accumulator._0969_ accumulator._1029_ VGND VGND VPWR VPWR accumulator._1030_
+ sky130_fd_sc_hd__or2_1
XFILLER_0_52_191 VGND VGND VPWR VPWR sky130_fd_sc_hd__fill_1
XFILLER_0_4_277 VGND VGND VPWR VPWR sky130_fd_sc_hd__fill_1
XFILLER_0_4_233 VGND VGND VPWR VPWR sky130_fd_sc_hd__fill_2
XFILLER_0_20_82 VGND VGND VPWR VPWR sky130_fd_sc_hd__fill_2
Xaccumulator._1795_ accumulator._0890_ accumulator._0891_ VGND VGND VPWR VPWR accumulator._0892_
+ sky130_fd_sc_hd__or2_1
XFILLER_0_40_397 VGND VGND VPWR VPWR sky130_fd_sc_hd__decap_8
XTAP_TAPCELL_ROW_68_665 VGND VPWR sky130_fd_sc_hd__tapvpwrvgnd_1
Xaccumulator._2278_ accumulator._0193_ accumulator._0211_ accumulator._0061_ VGND
+ VGND VPWR VPWR accumulator._0212_ sky130_fd_sc_hd__mux2_1
Xaccumulator._2416_ clknet_2_3__leaf_clock accumulator._0017_ VGND VGND VPWR VPWR
+ accumulator.io_accOut\[15\] sky130_fd_sc_hd__dfxtp_1
Xaccumulator._2347_ accumulator._0270_ accumulator._0274_ VGND VGND VPWR VPWR accumulator._0279_
+ sky130_fd_sc_hd__nand2_1
XTAP_TAPCELL_ROW_0_154 VGND VPWR sky130_fd_sc_hd__tapvpwrvgnd_1
XTAP_TAPCELL_ROW_0_143 VGND VPWR sky130_fd_sc_hd__tapvpwrvgnd_1
XTAP_TAPCELL_ROW_51_532 VGND VPWR sky130_fd_sc_hd__tapvpwrvgnd_1
XFILLER_0_35_158 VGND VGND VPWR VPWR sky130_fd_sc_hd__fill_1
XFILLER_0_35_136 VGND VGND VPWR VPWR sky130_fd_sc_hd__fill_2
XFILLER_0_35_103 VGND VGND VPWR VPWR sky130_fd_sc_hd__decap_3
XFILLER_0_16_361 VGND VGND VPWR VPWR sky130_fd_sc_hd__decap_3
Xaccumulator._1229_ accumulator.io_inMant\[2\] accumulator.io_inMant\[1\] VGND VGND
+ VPWR VPWR accumulator._0313_ sky130_fd_sc_hd__and2b_1
XFILLER_0_8_3 VGND VGND VPWR VPWR sky130_fd_sc_hd__decap_8
XTAP_TAPCELL_ROW_8_210 VGND VPWR sky130_fd_sc_hd__tapvpwrvgnd_1
XFILLER_0_41_15 VPWR VGND VPWR VGND sky130_ef_sc_hd__decap_12
XFILLER_0_34_191 VGND VGND VPWR VPWR sky130_fd_sc_hd__decap_4
XFILLER_0_26_114 VGND VGND VPWR VPWR sky130_fd_sc_hd__fill_1
XFILLER_0_1_225 VPWR VGND VPWR VGND sky130_ef_sc_hd__decap_12
XTAP_TAPCELL_ROW_14_256 VGND VPWR sky130_fd_sc_hd__tapvpwrvgnd_1
Xaccumulator._1580_ accumulator._0653_ accumulator._0654_ accumulator._0676_ VGND
+ VGND VPWR VPWR accumulator._0677_ sky130_fd_sc_hd__o21ai_1
Xaccumulator._2201_ accumulator._0111_ accumulator._0134_ accumulator._0135_ accumulator._0086_
+ VGND VGND VPWR VPWR accumulator._0137_ sky130_fd_sc_hd__a211o_1
Xaccumulator._2132_ accumulator._1142_ accumulator._0042_ accumulator._0066_ accumulator._0397_
+ accumulator.io_accOut\[2\] VGND VGND VPWR VPWR accumulator._0067_ sky130_fd_sc_hd__a32o_1
Xaccumulator._2063_ accumulator._0920_ accumulator._0968_ accumulator._1157_ VGND
+ VGND VPWR VPWR accumulator._1160_ sky130_fd_sc_hd__and3_1
XFILLER_0_45_401 VGND VGND VPWR VPWR sky130_fd_sc_hd__fill_2
Xaccumulator._1847_ accumulator._0943_ accumulator._0926_ accumulator._0827_ accumulator._0837_
+ accumulator._0826_ VGND VGND VPWR VPWR accumulator._0944_ sky130_fd_sc_hd__a311o_1
Xaccumulator._1916_ accumulator._0930_ accumulator._0794_ accumulator._0936_ accumulator._0937_
+ VGND VGND VPWR VPWR accumulator._1013_ sky130_fd_sc_hd__a31o_1
XFILLER_0_40_194 VGND VGND VPWR VPWR sky130_fd_sc_hd__fill_2
XFILLER_0_40_172 VGND VGND VPWR VPWR sky130_fd_sc_hd__fill_1
XFILLER_0_32_139 VGND VGND VPWR VPWR sky130_fd_sc_hd__fill_1
XFILLER_0_32_117 VGND VGND VPWR VPWR sky130_fd_sc_hd__decap_8
XFILLER_0_31_81 VPWR VGND VPWR VGND sky130_ef_sc_hd__decap_12
XFILLER_0_13_342 VPWR VGND VPWR VGND sky130_ef_sc_hd__decap_12
Xaccumulator._1778_ accumulator._0863_ accumulator._0862_ accumulator._0873_ accumulator._0874_
+ VGND VGND VPWR VPWR accumulator._0875_ sky130_fd_sc_hd__o2bb2a_1
XFILLER_0_36_401 VGND VGND VPWR VPWR sky130_fd_sc_hd__decap_3
XTAP_TAPCELL_ROW_28_359 VGND VPWR sky130_fd_sc_hd__tapvpwrvgnd_1
XFILLER_0_48_294 VPWR VGND VPWR VGND sky130_ef_sc_hd__decap_12
XTAP_TAPCELL_ROW_11_237 VGND VPWR sky130_fd_sc_hd__tapvpwrvgnd_1
XFILLER_0_16_180 VGND VGND VPWR VPWR sky130_fd_sc_hd__decap_6
XFILLER_0_36_15 VPWR VGND VPWR VGND sky130_ef_sc_hd__decap_12
XTAP_TAPCELL_ROW_70_682 VGND VPWR sky130_fd_sc_hd__tapvpwrvgnd_1
XTAP_TAPCELL_ROW_62_616 VGND VPWR sky130_fd_sc_hd__tapvpwrvgnd_1
XFILLER_0_54_253 VGND VGND VPWR VPWR sky130_fd_sc_hd__decap_6
Xaccumulator._1701_ accumulator._0754_ accumulator._0786_ accumulator._0795_ accumulator._0797_
+ VGND VGND VPWR VPWR accumulator._0798_ sky130_fd_sc_hd__a31oi_2
XFILLER_0_42_415 VGND VGND VPWR VPWR sky130_fd_sc_hd__fill_1
XscaleAdd._697_ scaleAdd._266_ scaleAdd._268_ VGND VGND VPWR VPWR scaleAdd._269_ sky130_fd_sc_hd__xnor2_1
Xaccumulator._1632_ accumulator._0680_ accumulator._0727_ accumulator._0728_ VGND
+ VGND VPWR VPWR accumulator._0729_ sky130_fd_sc_hd__a21oi_1
Xaccumulator._1563_ accumulator._0526_ accumulator._0658_ accumulator._0659_ accumulator._0558_
+ VGND VGND VPWR VPWR accumulator._0660_ sky130_fd_sc_hd__a211o_1
Xaccumulator._1494_ accumulator._0590_ VGND VGND VPWR VPWR accumulator._0591_ sky130_fd_sc_hd__inv_2
Xoperator._21_ net6 net7 net1 VGND VGND VPWR VPWR operator._05_ sky130_fd_sc_hd__o21ai_2
XFILLER_0_10_345 VPWR VGND VPWR VGND sky130_ef_sc_hd__decap_12
XFILLER_0_10_389 VPWR VGND VPWR VGND sky130_ef_sc_hd__decap_12
Xaccumulator._2115_ accumulator._0047_ accumulator._0048_ accumulator._1197_ VGND
+ VGND VPWR VPWR accumulator._0049_ sky130_fd_sc_hd__mux2_1
XFILLER_0_9_133 VPWR VGND VPWR VGND sky130_ef_sc_hd__decap_12
Xaccumulator._2046_ accumulator._1018_ accumulator._1024_ VGND VGND VPWR VPWR accumulator._1143_
+ sky130_fd_sc_hd__nor2_1
XFILLER_0_45_253 VGND VGND VPWR VPWR sky130_fd_sc_hd__fill_1
XFILLER_0_33_415 VGND VGND VPWR VPWR sky130_fd_sc_hd__fill_2
XFILLER_0_5_361 VPWR VGND VPWR VGND sky130_ef_sc_hd__decap_12
XFILLER_0_60_278 VGND VGND VPWR VPWR sky130_fd_sc_hd__fill_2
XFILLER_0_13_172 VGND VGND VPWR VPWR sky130_fd_sc_hd__decap_4
XFILLER_0_13_194 VGND VGND VPWR VPWR sky130_fd_sc_hd__fill_2
XFILLER_0_20_109 VGND VGND VPWR VPWR sky130_fd_sc_hd__decap_8
XFILLER_0_68_389 VPWR VGND VPWR VGND sky130_ef_sc_hd__decap_12
XFILLER_0_68_345 VPWR VGND VPWR VGND sky130_ef_sc_hd__decap_12
XFILLER_0_36_253 VGND VGND VPWR VPWR sky130_fd_sc_hd__fill_2
XFILLER_0_28_209 VPWR VGND VPWR VGND sky130_ef_sc_hd__decap_12
XFILLER_0_51_267 VPWR VGND VPWR VGND sky130_ef_sc_hd__decap_12
XFILLER_0_51_201 VGND VGND VPWR VPWR sky130_fd_sc_hd__decap_6
XFILLER_0_24_404 VGND VGND VPWR VPWR sky130_fd_sc_hd__decap_4
XFILLER_0_3_309 VPWR VGND VPWR VGND sky130_ef_sc_hd__decap_12
XscaleAdd._620_ scaleAdd._312_ scaleAdd._195_ VGND VGND VPWR VPWR scaleAdd._196_ sky130_fd_sc_hd__nand2_1
XscaleAdd._482_ scaleAdd._060_ scaleAdd._061_ operator.io_outMant\[0\] VGND VGND VPWR
+ VPWR scaleAdd._062_ sky130_fd_sc_hd__o21ai_1
XscaleAdd._551_ scaleAdd._319_ scaleAdd._337_ scaleAdd._085_ scaleAdd._308_ VGND VGND
+ VPWR VPWR scaleAdd._129_ sky130_fd_sc_hd__a22o_1
XFILLER_0_63_57 VGND VGND VPWR VPWR sky130_fd_sc_hd__decap_4
XFILLER_0_59_389 VGND VGND VPWR VPWR sky130_fd_sc_hd__decap_3
XFILLER_0_59_378 VGND VGND VPWR VPWR sky130_fd_sc_hd__fill_2
XFILLER_0_59_367 VGND VGND VPWR VPWR sky130_fd_sc_hd__decap_6
XFILLER_0_59_345 VPWR VGND VPWR VGND sky130_ef_sc_hd__decap_12
XFILLER_0_2_49 VGND VGND VPWR VPWR sky130_fd_sc_hd__decap_4
XFILLER_0_2_27 VGND VGND VPWR VPWR sky130_fd_sc_hd__fill_1
XFILLER_0_42_223 VPWR VGND VPWR VGND sky130_ef_sc_hd__decap_12
XTAP_TAPCELL_ROW_30_376 VGND VPWR sky130_fd_sc_hd__tapvpwrvgnd_1
XFILLER_0_6_103 VGND VGND VPWR VPWR sky130_fd_sc_hd__decap_4
XFILLER_0_6_158 VGND VGND VPWR VPWR sky130_fd_sc_hd__decap_8
XFILLER_0_12_94 VGND VGND VPWR VPWR sky130_fd_sc_hd__decap_8
XFILLER_0_30_407 VGND VGND VPWR VPWR sky130_fd_sc_hd__fill_2
XFILLER_0_10_153 VPWR VGND VPWR VGND sky130_ef_sc_hd__decap_12
XFILLER_0_49_3 VPWR VGND VPWR VGND sky130_ef_sc_hd__decap_12
Xaccumulator._1615_ accumulator._0539_ accumulator._0427_ accumulator._0475_ accumulator._0691_
+ VGND VGND VPWR VPWR accumulator._0712_ sky130_fd_sc_hd__or4_1
Xaccumulator._1546_ accumulator.io_accOut\[3\] net60 accumulator._0414_ accumulator._0431_
+ VGND VGND VPWR VPWR accumulator._0643_ sky130_fd_sc_hd__and4_1
XFILLER_0_10_197 VPWR VGND VPWR VGND sky130_ef_sc_hd__decap_12
Xaccumulator._1477_ accumulator._0561_ accumulator._0573_ accumulator._0439_ VGND
+ VGND VPWR VPWR accumulator._0574_ sky130_fd_sc_hd__mux2_1
Xaccumulator._2029_ accumulator._0919_ accumulator._0965_ accumulator._1120_ accumulator._0913_
+ accumulator._1125_ VGND VGND VPWR VPWR accumulator._1126_ sky130_fd_sc_hd__a221o_1
XTAP_TAPCELL_ROW_21_310 VGND VPWR sky130_fd_sc_hd__tapvpwrvgnd_1
XFILLER_0_68_164 VGND VGND VPWR VPWR sky130_fd_sc_hd__fill_1
XFILLER_0_33_27 VPWR VGND VPWR VGND sky130_ef_sc_hd__decap_12
XFILLER_0_68_197 VGND VGND VPWR VPWR sky130_fd_sc_hd__decap_3
XTAP_TAPCELL_ROW_44_479 VGND VPWR sky130_fd_sc_hd__tapvpwrvgnd_1
XFILLER_0_24_212 VGND VGND VPWR VPWR sky130_fd_sc_hd__fill_1
XscaleAdd._603_ scaleAdd._120_ scaleAdd._150_ scaleAdd._118_ scaleAdd._178_ scaleAdd._179_
+ VGND VGND VPWR VPWR scaleAdd._180_ sky130_fd_sc_hd__o311ai_2
Xinput14 io_inScaleA[5] VGND VGND VPWR VPWR net14 sky130_fd_sc_hd__buf_1
XFILLER_0_24_278 VGND VGND VPWR VPWR sky130_fd_sc_hd__decap_8
XscaleAdd._534_ scaleAdd._110_ scaleAdd._112_ VGND VGND VPWR VPWR scaleAdd._113_ sky130_fd_sc_hd__xor2_1
XscaleAdd._465_ scaleAdd._020_ scaleAdd._044_ VGND VGND VPWR VPWR scaleAdd._045_ sky130_fd_sc_hd__nand2_1
Xaccumulator._1331_ accumulator._0427_ VGND VGND VPWR VPWR accumulator._0428_ sky130_fd_sc_hd__buf_2
Xaccumulator._1400_ accumulator._0472_ accumulator._0473_ VGND VGND VPWR VPWR accumulator._0497_
+ sky130_fd_sc_hd__nor2_2
Xaccumulator._2380_ accumulator._0297_ accumulator._0311_ VGND VGND VPWR VPWR accumulator._0312_
+ sky130_fd_sc_hd__or2_1
XscaleAdd._396_ net11 net13 VGND VGND VPWR VPWR scaleAdd._338_ sky130_fd_sc_hd__and2_1
XTAP_TAPCELL_ROW_35_413 VGND VPWR sky130_fd_sc_hd__tapvpwrvgnd_1
Xaccumulator._1262_ accumulator._0360_ VGND VGND VPWR VPWR accumulator._0361_ sky130_fd_sc_hd__inv_2
XFILLER_0_30_226 VGND VGND VPWR VPWR sky130_fd_sc_hd__decap_4
XFILLER_0_15_212 VPWR VGND VPWR VGND sky130_ef_sc_hd__decap_12
XFILLER_0_38_304 VGND VGND VPWR VPWR sky130_fd_sc_hd__decap_4
Xaccumulator._1529_ accumulator._0624_ accumulator._0625_ accumulator._0498_ VGND
+ VGND VPWR VPWR accumulator._0626_ sky130_fd_sc_hd__a21o_1
XFILLER_0_65_167 VGND VGND VPWR VPWR sky130_fd_sc_hd__fill_1
XFILLER_0_65_145 VGND VGND VPWR VPWR sky130_fd_sc_hd__fill_1
XFILLER_0_61_340 VPWR VGND VPWR VGND sky130_ef_sc_hd__decap_12
XFILLER_0_0_109 VGND VGND VPWR VPWR sky130_fd_sc_hd__decap_3
XFILLER_0_44_15 VPWR VGND VPWR VGND sky130_ef_sc_hd__decap_12
XFILLER_0_28_27 VGND VGND VPWR VPWR sky130_fd_sc_hd__fill_1
XTAP_TAPCELL_ROW_57_582 VGND VPWR sky130_fd_sc_hd__tapvpwrvgnd_1
XFILLER_0_29_337 VGND VGND VPWR VPWR sky130_fd_sc_hd__decap_6
XFILLER_0_60_69 VPWR VGND VPWR VGND sky130_ef_sc_hd__decap_12
Xaccumulator._1880_ accumulator._0969_ accumulator._0976_ VGND VGND VPWR VPWR accumulator._0977_
+ sky130_fd_sc_hd__nor2_1
XFILLER_0_12_215 VGND VGND VPWR VPWR sky130_fd_sc_hd__fill_1
XscaleAdd._379_ scaleAdd._303_ operator.io_outMant\[1\] VGND VGND VPWR VPWR scaleAdd._323_
+ sky130_fd_sc_hd__and2_1
XscaleAdd._517_ scaleAdd._095_ scaleAdd._093_ scaleAdd._089_ VGND VGND VPWR VPWR scaleAdd._096_
+ sky130_fd_sc_hd__a21oi_1
XscaleAdd._448_ operator.io_outMant\[1\] scaleAdd._350_ scaleAdd._026_ scaleAdd._027_
+ VGND VGND VPWR VPWR scaleAdd._029_ sky130_fd_sc_hd__a22o_1
Xaccumulator._2294_ accumulator._0041_ accumulator._0076_ VGND VGND VPWR VPWR accumulator._0228_
+ sky130_fd_sc_hd__and2_1
X_19_ accumulator.io_accOut\[19\] VGND VGND VPWR VPWR net32 sky130_fd_sc_hd__clkbuf_1
Xaccumulator._1314_ accumulator._0372_ accumulator._0344_ accumulator._0362_ VGND
+ VGND VPWR VPWR accumulator._0411_ sky130_fd_sc_hd__or3_1
Xaccumulator._2432_ clknet_2_1__leaf_clock accumulator._0033_ VGND VGND VPWR VPWR
+ accumulator.state\[0\] sky130_fd_sc_hd__dfxtp_1
XFILLER_0_18_93 VGND VGND VPWR VPWR sky130_fd_sc_hd__fill_1
Xaccumulator._1245_ accumulator.io_inExp\[0\] accumulator._0336_ VGND VGND VPWR VPWR
+ accumulator._0344_ sky130_fd_sc_hd__and2_1
Xaccumulator._2363_ accumulator._0294_ accumulator._0295_ VGND VGND VPWR VPWR accumulator._0296_
+ sky130_fd_sc_hd__nand2_1
XFILLER_0_47_167 VGND VGND VPWR VPWR sky130_fd_sc_hd__fill_1
XFILLER_0_28_392 VGND VGND VPWR VPWR sky130_fd_sc_hd__decap_4
XFILLER_0_70_181 VPWR VGND VPWR VGND sky130_ef_sc_hd__decap_12
XFILLER_0_38_101 VGND VGND VPWR VPWR sky130_fd_sc_hd__decap_6
XTAP_TAPCELL_ROW_3_174 VGND VPWR sky130_fd_sc_hd__tapvpwrvgnd_1
XFILLER_0_14_29 VPWR VGND VPWR VGND sky130_ef_sc_hd__decap_12
XFILLER_0_38_156 VGND VGND VPWR VPWR sky130_fd_sc_hd__decap_6
XFILLER_0_34_362 VGND VGND VPWR VPWR sky130_fd_sc_hd__fill_2
XFILLER_0_26_329 VGND VGND VPWR VPWR sky130_fd_sc_hd__decap_6
XFILLER_0_39_15 VPWR VGND VPWR VGND sky130_ef_sc_hd__decap_12
XFILLER_0_69_281 VGND VGND VPWR VPWR sky130_fd_sc_hd__fill_1
XFILLER_0_69_270 VGND VGND VPWR VPWR sky130_fd_sc_hd__decap_3
XTAP_TAPCELL_ROW_60_599 VGND VPWR sky130_fd_sc_hd__tapvpwrvgnd_1
XFILLER_0_44_137 VGND VGND VPWR VPWR sky130_fd_sc_hd__decap_3
XFILLER_0_29_189 VGND VGND VPWR VPWR sky130_fd_sc_hd__decap_6
Xaccumulator._1932_ accumulator._1016_ accumulator._1015_ accumulator._1022_ VGND
+ VGND VPWR VPWR accumulator._1029_ sky130_fd_sc_hd__and3_1
Xaccumulator._1863_ accumulator._0733_ accumulator._0601_ accumulator._0878_ VGND
+ VGND VPWR VPWR accumulator._0960_ sky130_fd_sc_hd__and3_1
XFILLER_0_40_365 VGND VGND VPWR VPWR sky130_fd_sc_hd__decap_4
XFILLER_0_40_321 VGND VGND VPWR VPWR sky130_fd_sc_hd__decap_8
XFILLER_0_4_256 VGND VGND VPWR VPWR sky130_fd_sc_hd__fill_1
XFILLER_0_20_50 VPWR VGND VPWR VGND sky130_ef_sc_hd__decap_12
Xaccumulator._1794_ accumulator._0888_ accumulator._0889_ VGND VGND VPWR VPWR accumulator._0891_
+ sky130_fd_sc_hd__and2_1
Xaccumulator._2415_ clknet_2_1__leaf_clock accumulator._0016_ VGND VGND VPWR VPWR
+ accumulator.io_accOut\[14\] sky130_fd_sc_hd__dfxtp_1
XTAP_TAPCELL_ROW_68_666 VGND VPWR sky130_fd_sc_hd__tapvpwrvgnd_1
Xaccumulator._2277_ accumulator._1101_ accumulator._1099_ accumulator._1184_ VGND
+ VGND VPWR VPWR accumulator._0211_ sky130_fd_sc_hd__mux2_2
Xaccumulator._2346_ accumulator.io_accOut\[25\] accumulator._0167_ accumulator._0400_
+ accumulator._0278_ VGND VGND VPWR VPWR accumulator._0027_ sky130_fd_sc_hd__o211a_1
XTAP_TAPCELL_ROW_0_155 VGND VPWR sky130_fd_sc_hd__tapvpwrvgnd_1
XTAP_TAPCELL_ROW_0_144 VGND VPWR sky130_fd_sc_hd__tapvpwrvgnd_1
Xaccumulator._1228_ accumulator.io_inMant\[16\] VGND VGND VPWR VPWR accumulator._0304_
+ sky130_fd_sc_hd__inv_2
XTAP_TAPCELL_ROW_51_533 VGND VPWR sky130_fd_sc_hd__tapvpwrvgnd_1
XTAP_TAPCELL_ROW_8_211 VGND VPWR sky130_fd_sc_hd__tapvpwrvgnd_1
XFILLER_0_41_27 VPWR VGND VPWR VGND sky130_ef_sc_hd__decap_12
XTAP_TAPCELL_ROW_14_257 VGND VPWR sky130_fd_sc_hd__tapvpwrvgnd_1
XFILLER_0_1_215 VGND VGND VPWR VPWR sky130_fd_sc_hd__decap_8
XFILLER_0_5_16 VGND VGND VPWR VPWR sky130_fd_sc_hd__decap_8
Xaccumulator._2062_ accumulator._0920_ accumulator._0968_ accumulator._1158_ VGND
+ VGND VPWR VPWR accumulator._1159_ sky130_fd_sc_hd__a21oi_1
Xaccumulator._2200_ accumulator._0094_ accumulator._0051_ accumulator._0106_ accumulator._1197_
+ VGND VGND VPWR VPWR accumulator._0135_ sky130_fd_sc_hd__o211a_1
Xaccumulator._2131_ accumulator._1149_ accumulator._0060_ accumulator._0064_ VGND
+ VGND VPWR VPWR accumulator._0066_ sky130_fd_sc_hd__a21o_1
XFILLER_0_9_304 VPWR VGND VPWR VGND sky130_ef_sc_hd__decap_12
XFILLER_0_60_416 VGND VGND VPWR VPWR sky130_fd_sc_hd__decap_4
XFILLER_0_57_251 VPWR VGND VPWR VGND sky130_ef_sc_hd__decap_12
XFILLER_0_31_93 VGND VGND VPWR VPWR sky130_fd_sc_hd__decap_8
XFILLER_0_9_337 VPWR VGND VPWR VGND sky130_ef_sc_hd__decap_12
XPHY_EDGE_ROW_17_Left_88 VGND VGND VPWR VPWR sky130_fd_sc_hd__decap_3
Xaccumulator._1777_ accumulator._0852_ accumulator._0704_ accumulator._0868_ VGND
+ VGND VPWR VPWR accumulator._0874_ sky130_fd_sc_hd__o21ai_1
Xaccumulator._1915_ accumulator._0804_ accumulator._0806_ VGND VGND VPWR VPWR accumulator._1012_
+ sky130_fd_sc_hd__or2_1
Xaccumulator._1846_ accumulator._0941_ accumulator._0927_ accumulator._0942_ accumulator._0814_
+ VGND VGND VPWR VPWR accumulator._0943_ sky130_fd_sc_hd__a211o_1
XFILLER_0_0_281 VPWR VGND VPWR VGND sky130_ef_sc_hd__decap_12
XFILLER_0_13_354 VPWR VGND VPWR VGND sky130_ef_sc_hd__decap_12
XFILLER_0_48_262 VPWR VGND VPWR VGND sky130_ef_sc_hd__decap_12
Xaccumulator._2329_ accumulator._0260_ accumulator._0261_ accumulator._0398_ VGND
+ VGND VPWR VPWR accumulator._0262_ sky130_fd_sc_hd__a21o_1
XTAP_TAPCELL_ROW_11_238 VGND VPWR sky130_fd_sc_hd__tapvpwrvgnd_1
XFILLER_0_16_170 VGND VGND VPWR VPWR sky130_fd_sc_hd__fill_1
XFILLER_0_36_27 VGND VGND VPWR VPWR sky130_fd_sc_hd__fill_1
XTAP_TAPCELL_ROW_62_617 VGND VPWR sky130_fd_sc_hd__tapvpwrvgnd_1
XFILLER_0_52_15 VPWR VGND VPWR VGND sky130_ef_sc_hd__decap_12
XTAP_TAPCELL_ROW_70_683 VGND VPWR sky130_fd_sc_hd__tapvpwrvgnd_1
XFILLER_0_39_251 VGND VGND VPWR VPWR sky130_fd_sc_hd__decap_6
XFILLER_0_6_307 VGND VGND VPWR VPWR sky130_fd_sc_hd__fill_1
Xaccumulator._1700_ accumulator._0753_ accumulator._0796_ accumulator._0752_ VGND
+ VGND VPWR VPWR accumulator._0797_ sky130_fd_sc_hd__a21o_1
Xaccumulator._1631_ accumulator._0653_ accumulator._0654_ VGND VGND VPWR VPWR accumulator._0728_
+ sky130_fd_sc_hd__xor2_1
XscaleAdd._696_ scaleAdd._267_ scaleAdd._216_ scaleAdd._251_ VGND VGND VPWR VPWR scaleAdd._268_
+ sky130_fd_sc_hd__mux2_1
XFILLER_0_10_357 VGND VGND VPWR VPWR sky130_fd_sc_hd__decap_6
Xaccumulator._1562_ accumulator._0497_ accumulator._0565_ accumulator._0571_ VGND
+ VGND VPWR VPWR accumulator._0659_ sky130_fd_sc_hd__and3_1
Xoperator._20_ operator.io_outExp\[2\] operator._04_ operator._01_ operator._02_ VGND
+ VGND VPWR VPWR operator.io_outExp\[1\] sky130_fd_sc_hd__a2bb2o_1
Xaccumulator._1493_ accumulator._0588_ accumulator._0589_ VGND VGND VPWR VPWR accumulator._0590_
+ sky130_fd_sc_hd__nor2_1
Xaccumulator._2114_ accumulator._1185_ accumulator._1153_ accumulator._1181_ VGND
+ VGND VPWR VPWR accumulator._0048_ sky130_fd_sc_hd__mux2_1
XFILLER_0_42_70 VPWR VGND VPWR VGND sky130_ef_sc_hd__decap_12
Xaccumulator._2045_ accumulator._1141_ VGND VGND VPWR VPWR accumulator._1142_ sky130_fd_sc_hd__buf_2
XFILLER_0_9_145 VPWR VGND VPWR VGND sky130_ef_sc_hd__decap_12
XFILLER_0_9_167 VGND VGND VPWR VPWR sky130_fd_sc_hd__fill_1
XFILLER_0_5_373 VPWR VGND VPWR VGND sky130_ef_sc_hd__decap_12
Xaccumulator._1829_ accumulator._0852_ accumulator._0817_ accumulator._0818_ accumulator._0821_
+ VGND VGND VPWR VPWR accumulator._0926_ sky130_fd_sc_hd__or4_1
XFILLER_0_68_357 VGND VGND VPWR VPWR sky130_fd_sc_hd__decap_6
XFILLER_0_36_276 VGND VGND VPWR VPWR sky130_fd_sc_hd__decap_4
XTAP_TAPCELL_ROW_24_330 VGND VPWR sky130_fd_sc_hd__tapvpwrvgnd_1
XFILLER_0_22_29 VPWR VGND VPWR VGND sky130_ef_sc_hd__decap_12
XFILLER_0_22_18 VGND VGND VPWR VPWR sky130_fd_sc_hd__decap_8
XFILLER_0_51_279 VGND VGND VPWR VPWR sky130_fd_sc_hd__fill_1
XscaleAdd._550_ scaleAdd._337_ scaleAdd._085_ VGND VGND VPWR VPWR scaleAdd._128_ sky130_fd_sc_hd__nand2_1
XscaleAdd._481_ scaleAdd._045_ scaleAdd._046_ scaleAdd._059_ VGND VGND VPWR VPWR scaleAdd._061_
+ sky130_fd_sc_hd__and3_1
XFILLER_0_47_15 VPWR VGND VPWR VGND sky130_ef_sc_hd__decap_12
XFILLER_0_59_357 VGND VGND VPWR VPWR sky130_fd_sc_hd__fill_1
XFILLER_0_59_335 VGND VGND VPWR VPWR sky130_fd_sc_hd__fill_1
XFILLER_0_42_235 VGND VGND VPWR VPWR sky130_fd_sc_hd__decap_8
XTAP_TAPCELL_ROW_30_377 VGND VPWR sky130_fd_sc_hd__tapvpwrvgnd_1
XFILLER_0_27_276 VGND VGND VPWR VPWR sky130_fd_sc_hd__decap_4
XFILLER_0_2_321 VPWR VGND VPWR VGND sky130_ef_sc_hd__decap_12
XFILLER_0_6_137 VGND VGND VPWR VPWR sky130_fd_sc_hd__decap_3
Xaccumulator._1614_ accumulator._0428_ accumulator._0630_ accumulator._0633_ VGND
+ VGND VPWR VPWR accumulator._0711_ sky130_fd_sc_hd__nand3_1
XPHY_EDGE_ROW_34_Left_105 VGND VGND VPWR VPWR sky130_fd_sc_hd__decap_3
XFILLER_0_2_365 VPWR VGND VPWR VGND sky130_ef_sc_hd__decap_12
XscaleAdd._679_ scaleAdd._318_ scaleAdd._234_ scaleAdd._196_ VGND VGND VPWR VPWR scaleAdd._252_
+ sky130_fd_sc_hd__a21boi_1
XFILLER_0_10_165 VPWR VGND VPWR VGND sky130_ef_sc_hd__decap_12
Xaccumulator._1545_ accumulator._0611_ accumulator._0639_ accumulator._0641_ accumulator._0599_
+ VGND VGND VPWR VPWR accumulator._0642_ sky130_fd_sc_hd__a211o_1
Xaccumulator._1476_ accumulator.io_inMant\[14\] accumulator.io_inMant\[15\] accumulator._0436_
+ VGND VGND VPWR VPWR accumulator._0573_ sky130_fd_sc_hd__mux2_1
Xaccumulator._2028_ accumulator._0923_ accumulator._0914_ VGND VGND VPWR VPWR accumulator._1125_
+ sky130_fd_sc_hd__and2_1
XPHY_EDGE_ROW_43_Left_114 VGND VGND VPWR VPWR sky130_fd_sc_hd__decap_3
XTAP_TAPCELL_ROW_21_311 VGND VPWR sky130_fd_sc_hd__tapvpwrvgnd_1
XPHY_EDGE_ROW_52_Left_123 VGND VGND VPWR VPWR sky130_fd_sc_hd__decap_3
XFILLER_0_33_279 VGND VGND VPWR VPWR sky130_fd_sc_hd__fill_1
XFILLER_0_5_181 VGND VGND VPWR VPWR sky130_fd_sc_hd__fill_2
XPHY_EDGE_ROW_61_Left_132 VGND VGND VPWR VPWR sky130_fd_sc_hd__decap_3
XFILLER_0_56_338 VGND VGND VPWR VPWR sky130_fd_sc_hd__decap_4
XFILLER_0_33_39 VPWR VGND VPWR VGND sky130_ef_sc_hd__decap_12
XPHY_EDGE_ROW_70_Left_141 VGND VGND VPWR VPWR sky130_fd_sc_hd__decap_3
XscaleAdd._602_ scaleAdd._121_ scaleAdd._122_ scaleAdd._148_ VGND VGND VPWR VPWR scaleAdd._179_
+ sky130_fd_sc_hd__nand3_1
Xinput15 io_inScaleA[6] VGND VGND VPWR VPWR net15 sky130_fd_sc_hd__clkbuf_2
XscaleAdd._395_ net14 VGND VGND VPWR VPWR scaleAdd._337_ sky130_fd_sc_hd__buf_2
XscaleAdd._533_ operator.io_outMant\[1\] scaleAdd._025_ scaleAdd._063_ scaleAdd._111_
+ VGND VGND VPWR VPWR scaleAdd._112_ sky130_fd_sc_hd__a31o_1
XscaleAdd._464_ scaleAdd._023_ VGND VGND VPWR VPWR scaleAdd._044_ sky130_fd_sc_hd__inv_2
Xaccumulator._1330_ accumulator._0416_ accumulator._0426_ VGND VGND VPWR VPWR accumulator._0427_
+ sky130_fd_sc_hd__xnor2_2
Xaccumulator._1261_ accumulator._0358_ accumulator._0359_ VGND VGND VPWR VPWR accumulator._0360_
+ sky130_fd_sc_hd__or2_2
XFILLER_0_47_305 VPWR VGND VPWR VGND sky130_ef_sc_hd__decap_12
XTAP_TAPCELL_ROW_35_414 VGND VPWR sky130_fd_sc_hd__tapvpwrvgnd_1
XFILLER_0_23_61 VPWR VGND VPWR VGND sky130_ef_sc_hd__decap_12
XFILLER_0_61_3 VPWR VGND VPWR VGND sky130_ef_sc_hd__decap_12
XFILLER_0_55_393 VGND VGND VPWR VPWR sky130_fd_sc_hd__decap_8
XFILLER_0_2_173 VGND VGND VPWR VPWR sky130_fd_sc_hd__fill_1
XFILLER_0_2_195 VGND VGND VPWR VPWR sky130_fd_sc_hd__fill_1
XFILLER_0_2_184 VGND VGND VPWR VPWR sky130_fd_sc_hd__fill_1
XFILLER_0_65_113 VGND VGND VPWR VPWR sky130_fd_sc_hd__decap_8
Xaccumulator._1459_ accumulator._0424_ VGND VGND VPWR VPWR accumulator._0556_ sky130_fd_sc_hd__inv_2
Xaccumulator._1528_ accumulator._0536_ accumulator._0504_ accumulator._0543_ VGND
+ VGND VPWR VPWR accumulator._0625_ sky130_fd_sc_hd__a21o_1
XPHY_EDGE_ROW_5_Left_76 VGND VGND VPWR VPWR sky130_fd_sc_hd__decap_3
XTAP_TAPCELL_ROW_49_517 VGND VPWR sky130_fd_sc_hd__tapvpwrvgnd_1
XFILLER_0_44_27 VGND VGND VPWR VPWR sky130_fd_sc_hd__fill_1
XTAP_TAPCELL_ROW_6_194 VGND VPWR sky130_fd_sc_hd__tapvpwrvgnd_1
XFILLER_0_60_15 VPWR VGND VPWR VGND sky130_ef_sc_hd__decap_12
XTAP_TAPCELL_ROW_57_583 VGND VPWR sky130_fd_sc_hd__tapvpwrvgnd_1
XFILLER_0_56_179 VGND VGND VPWR VPWR sky130_fd_sc_hd__fill_1
XFILLER_0_56_102 VPWR VGND VPWR VGND sky130_ef_sc_hd__decap_12
XFILLER_0_37_360 VGND VGND VPWR VPWR sky130_fd_sc_hd__fill_2
XFILLER_0_69_57 VPWR VGND VPWR VGND sky130_ef_sc_hd__decap_12
XFILLER_0_52_363 VGND VGND VPWR VPWR sky130_fd_sc_hd__fill_1
XTAP_TAPCELL_ROW_40_450 VGND VPWR sky130_fd_sc_hd__tapvpwrvgnd_1
XFILLER_0_37_393 VGND VGND VPWR VPWR sky130_fd_sc_hd__decap_4
XscaleAdd._516_ scaleAdd._014_ scaleAdd._083_ scaleAdd._088_ scaleAdd._090_ VGND VGND
+ VPWR VPWR scaleAdd._095_ sky130_fd_sc_hd__or4_1
XscaleAdd._447_ operator.io_outMant\[1\] scaleAdd._350_ scaleAdd._026_ scaleAdd._027_
+ VGND VGND VPWR VPWR scaleAdd._028_ sky130_fd_sc_hd__nand4_1
XscaleAdd._378_ scaleAdd._317_ scaleAdd._320_ scaleAdd._321_ VGND VGND VPWR VPWR scaleAdd._322_
+ sky130_fd_sc_hd__nor3_1
XFILLER_0_18_50 VPWR VGND VPWR VGND sky130_ef_sc_hd__decap_12
Xaccumulator._2431_ clknet_2_0__leaf_clock accumulator._0032_ VGND VGND VPWR VPWR
+ accumulator.io_accOut\[30\] sky130_fd_sc_hd__dfxtp_2
Xaccumulator._2293_ accumulator._0226_ accumulator._0227_ accumulator._0093_ VGND
+ VGND VPWR VPWR accumulator._0020_ sky130_fd_sc_hd__o21a_1
X_18_ accumulator.io_accOut\[18\] VGND VGND VPWR VPWR net31 sky130_fd_sc_hd__buf_1
XFILLER_0_26_6 VGND VGND VPWR VPWR sky130_fd_sc_hd__fill_1
Xaccumulator._1244_ accumulator._0341_ accumulator._0342_ VGND VGND VPWR VPWR accumulator._0343_
+ sky130_fd_sc_hd__xnor2_2
Xaccumulator._1313_ accumulator._0377_ accumulator._0382_ VGND VGND VPWR VPWR accumulator._0410_
+ sky130_fd_sc_hd__xor2_4
XFILLER_0_18_83 VGND VGND VPWR VPWR sky130_fd_sc_hd__fill_1
Xaccumulator._2362_ accumulator._0041_ accumulator._0292_ VGND VGND VPWR VPWR accumulator._0295_
+ sky130_fd_sc_hd__nand2_1
XFILLER_0_55_190 VGND VGND VPWR VPWR sky130_fd_sc_hd__fill_2
XFILLER_0_34_93 VPWR VGND VPWR VGND sky130_ef_sc_hd__decap_12
XFILLER_0_70_193 VGND VGND VPWR VPWR sky130_fd_sc_hd__decap_3
XFILLER_0_11_293 VPWR VGND VPWR VGND sky130_ef_sc_hd__decap_12
XTAP_TAPCELL_ROW_3_175 VGND VPWR sky130_fd_sc_hd__tapvpwrvgnd_1
XFILLER_0_38_113 VGND VGND VPWR VPWR sky130_fd_sc_hd__decap_8
XFILLER_0_61_182 VPWR VGND VPWR VGND sky130_ef_sc_hd__decap_12
XFILLER_0_30_29 VPWR VGND VPWR VGND sky130_ef_sc_hd__decap_12
XFILLER_0_19_371 VGND VGND VPWR VPWR sky130_fd_sc_hd__decap_4
XFILLER_0_55_15 VPWR VGND VPWR VGND sky130_ef_sc_hd__decap_12
XFILLER_0_39_27 VPWR VGND VPWR VGND sky130_ef_sc_hd__decap_12
XFILLER_0_69_260 VGND VGND VPWR VPWR sky130_fd_sc_hd__fill_1
XFILLER_0_29_113 VPWR VGND VPWR VGND sky130_ef_sc_hd__decap_12
XTAP_TAPCELL_ROW_17_277 VGND VPWR sky130_fd_sc_hd__tapvpwrvgnd_1
Xaccumulator._1862_ accumulator._0953_ accumulator._0958_ VGND VGND VPWR VPWR accumulator._0959_
+ sky130_fd_sc_hd__or2_1
Xaccumulator._1793_ accumulator._0888_ accumulator._0889_ VGND VGND VPWR VPWR accumulator._0890_
+ sky130_fd_sc_hd__nor2_1
Xaccumulator._1931_ accumulator._0815_ accumulator._1027_ VGND VGND VPWR VPWR accumulator._1028_
+ sky130_fd_sc_hd__xnor2_2
XFILLER_0_40_344 VPWR VGND VPWR VGND sky130_ef_sc_hd__decap_12
XFILLER_0_20_62 VPWR VGND VPWR VGND sky130_ef_sc_hd__decap_12
Xaccumulator._2414_ clknet_2_3__leaf_clock accumulator._0015_ VGND VGND VPWR VPWR
+ accumulator.io_accOut\[13\] sky130_fd_sc_hd__dfxtp_1
Xaccumulator._2345_ accumulator._0276_ accumulator._0277_ accumulator._0091_ VGND
+ VGND VPWR VPWR accumulator._0278_ sky130_fd_sc_hd__a21o_1
XTAP_TAPCELL_ROW_51_534 VGND VPWR sky130_fd_sc_hd__tapvpwrvgnd_1
Xaccumulator._2276_ accumulator._0208_ accumulator._0210_ accumulator._0093_ VGND
+ VGND VPWR VPWR accumulator._0018_ sky130_fd_sc_hd__o21a_1
Xaccumulator._1227_ accumulator._0273_ accumulator._0283_ VGND VGND VPWR VPWR accumulator._0293_
+ sky130_fd_sc_hd__nor2_4
XTAP_TAPCELL_ROW_0_156 VGND VPWR sky130_fd_sc_hd__tapvpwrvgnd_1
XFILLER_0_0_72 VPWR VGND VPWR VGND sky130_ef_sc_hd__decap_12
XTAP_TAPCELL_ROW_0_145 VGND VPWR sky130_fd_sc_hd__tapvpwrvgnd_1
XFILLER_0_35_127 VGND VGND VPWR VPWR sky130_fd_sc_hd__decap_4
XFILLER_0_31_333 VGND VGND VPWR VPWR sky130_fd_sc_hd__decap_3
XFILLER_0_31_311 VGND VGND VPWR VPWR sky130_fd_sc_hd__fill_1
XFILLER_0_28_190 VGND VGND VPWR VPWR sky130_fd_sc_hd__decap_6
XFILLER_0_16_341 VPWR VGND VPWR VGND sky130_ef_sc_hd__decap_12
XPHY_EDGE_ROW_17_Right_17 VGND VGND VPWR VPWR sky130_fd_sc_hd__decap_3
XPHY_EDGE_ROW_26_Right_26 VGND VGND VPWR VPWR sky130_fd_sc_hd__decap_3
XTAP_TAPCELL_ROW_8_212 VGND VPWR sky130_fd_sc_hd__tapvpwrvgnd_1
XFILLER_0_39_411 VGND VGND VPWR VPWR sky130_fd_sc_hd__fill_2
XFILLER_0_25_18 VGND VGND VPWR VPWR sky130_fd_sc_hd__decap_8
XFILLER_0_41_39 VPWR VGND VPWR VGND sky130_ef_sc_hd__decap_12
XPHY_EDGE_ROW_35_Right_35 VGND VGND VPWR VPWR sky130_fd_sc_hd__decap_3
XFILLER_0_26_149 VGND VGND VPWR VPWR sky130_fd_sc_hd__fill_2
XTAP_TAPCELL_ROW_14_258 VGND VPWR sky130_fd_sc_hd__tapvpwrvgnd_1
XPHY_EDGE_ROW_44_Right_44 VGND VGND VPWR VPWR sky130_fd_sc_hd__decap_3
XTAP_TAPCELL_ROW_65_637 VGND VPWR sky130_fd_sc_hd__tapvpwrvgnd_1
XFILLER_0_57_263 VPWR VGND VPWR VGND sky130_ef_sc_hd__decap_12
Xaccumulator._2061_ accumulator._1155_ accumulator._1157_ accumulator._0970_ VGND
+ VGND VPWR VPWR accumulator._1158_ sky130_fd_sc_hd__o21a_1
XPHY_EDGE_ROW_53_Right_53 VGND VGND VPWR VPWR sky130_fd_sc_hd__decap_3
Xaccumulator._2130_ accumulator._0061_ accumulator._0062_ accumulator._0063_ accumulator._1148_
+ VGND VGND VPWR VPWR accumulator._0064_ sky130_fd_sc_hd__a211oi_1
XFILLER_0_9_316 VPWR VGND VPWR VGND sky130_ef_sc_hd__decap_12
XFILLER_0_9_349 VPWR VGND VPWR VGND sky130_ef_sc_hd__decap_12
XFILLER_0_15_95 VGND VGND VPWR VPWR sky130_fd_sc_hd__decap_8
Xaccumulator._1914_ accumulator._1008_ accumulator._1010_ VGND VGND VPWR VPWR accumulator._1011_
+ sky130_fd_sc_hd__nand2_1
XFILLER_0_17_127 VPWR VGND VPWR VGND sky130_ef_sc_hd__decap_12
Xaccumulator._1776_ accumulator._0866_ VGND VGND VPWR VPWR accumulator._0873_ sky130_fd_sc_hd__inv_2
XPHY_EDGE_ROW_62_Right_62 VGND VGND VPWR VPWR sky130_fd_sc_hd__decap_3
Xaccumulator._1845_ accumulator._0822_ accumulator._0830_ VGND VGND VPWR VPWR accumulator._0942_
+ sky130_fd_sc_hd__nor2_1
XFILLER_0_40_141 VGND VGND VPWR VPWR sky130_fd_sc_hd__decap_6
XFILLER_0_0_293 VPWR VGND VPWR VGND sky130_ef_sc_hd__decap_12
XFILLER_0_13_366 VPWR VGND VPWR VGND sky130_ef_sc_hd__decap_12
Xaccumulator._2328_ accumulator._0036_ accumulator._0259_ VGND VGND VPWR VPWR accumulator._0261_
+ sky130_fd_sc_hd__or2_1
Xaccumulator._2259_ accumulator._1073_ accumulator._1080_ accumulator._1184_ VGND
+ VGND VPWR VPWR accumulator._0193_ sky130_fd_sc_hd__mux2_2
XFILLER_0_63_233 VPWR VGND VPWR VGND sky130_ef_sc_hd__decap_12
XFILLER_0_48_274 VGND VGND VPWR VPWR sky130_fd_sc_hd__decap_8
XFILLER_0_48_230 VGND VGND VPWR VPWR sky130_fd_sc_hd__fill_1
XTAP_TAPCELL_ROW_62_618 VGND VPWR sky130_fd_sc_hd__tapvpwrvgnd_1
XFILLER_0_52_27 VGND VGND VPWR VPWR sky130_fd_sc_hd__fill_1
XTAP_TAPCELL_ROW_70_684 VGND VPWR sky130_fd_sc_hd__tapvpwrvgnd_1
XFILLER_0_54_266 VPWR VGND VPWR VGND sky130_ef_sc_hd__decap_12
XscaleAdd._695_ scaleAdd._312_ scaleAdd._216_ VGND VGND VPWR VPWR scaleAdd._267_ sky130_fd_sc_hd__nand2_1
Xaccumulator._1630_ accumulator._0676_ accumulator._0681_ accumulator._0705_ accumulator._0715_
+ accumulator._0726_ VGND VGND VPWR VPWR accumulator._0727_ sky130_fd_sc_hd__a2111o_1
Xaccumulator._1561_ accumulator._0452_ accumulator._0470_ VGND VGND VPWR VPWR accumulator._0658_
+ sky130_fd_sc_hd__and2_1
XFILLER_0_22_141 VPWR VGND VPWR VGND sky130_ef_sc_hd__decap_12
XFILLER_0_26_50 VPWR VGND VPWR VGND sky130_ef_sc_hd__decap_12
Xaccumulator._1492_ accumulator.io_accOut\[30\] accumulator.io_accOut\[29\] accumulator.io_accOut\[28\]
+ accumulator.io_accOut\[27\] VGND VGND VPWR VPWR accumulator._0589_ sky130_fd_sc_hd__or4_1
Xaccumulator._2113_ accumulator._0978_ net69 accumulator._0046_ VGND VGND VPWR VPWR
+ accumulator._0047_ sky130_fd_sc_hd__a21o_1
Xaccumulator._2044_ accumulator._1140_ VGND VGND VPWR VPWR accumulator._1141_ sky130_fd_sc_hd__buf_2
XFILLER_0_45_222 VGND VGND VPWR VPWR sky130_fd_sc_hd__fill_2
XFILLER_0_45_200 VGND VGND VPWR VPWR sky130_fd_sc_hd__decap_8
XFILLER_0_42_82 VGND VGND VPWR VPWR sky130_fd_sc_hd__fill_2
XFILLER_0_9_157 VGND VGND VPWR VPWR sky130_fd_sc_hd__decap_3
XTAP_TAPCELL_ROW_33_397 VGND VPWR sky130_fd_sc_hd__tapvpwrvgnd_1
XFILLER_0_5_385 VGND VGND VPWR VPWR sky130_fd_sc_hd__decap_6
XFILLER_0_13_141 VGND VGND VPWR VPWR sky130_fd_sc_hd__fill_2
XFILLER_0_13_152 VGND VGND VPWR VPWR sky130_fd_sc_hd__decap_3
Xaccumulator._1828_ accumulator._0888_ accumulator._0889_ VGND VGND VPWR VPWR accumulator._0925_
+ sky130_fd_sc_hd__or2b_1
Xaccumulator._1759_ accumulator._0853_ accumulator._0855_ VGND VGND VPWR VPWR accumulator._0856_
+ sky130_fd_sc_hd__or2b_1
XFILLER_0_6_82 VGND VGND VPWR VPWR sky130_fd_sc_hd__fill_2
XFILLER_0_51_247 VGND VGND VPWR VPWR sky130_fd_sc_hd__decap_3
XTAP_TAPCELL_ROW_24_331 VGND VPWR sky130_fd_sc_hd__tapvpwrvgnd_1
XFILLER_0_47_27 VPWR VGND VPWR VGND sky130_ef_sc_hd__decap_12
XscaleAdd._480_ scaleAdd._045_ scaleAdd._046_ scaleAdd._059_ VGND VGND VPWR VPWR scaleAdd._060_
+ sky130_fd_sc_hd__a21oi_1
XFILLER_0_63_15 VPWR VGND VPWR VGND sky130_ef_sc_hd__decap_12
XFILLER_0_2_29 VGND VGND VPWR VPWR sky130_fd_sc_hd__fill_2
XFILLER_0_67_391 VGND VGND VPWR VPWR sky130_fd_sc_hd__fill_1
XFILLER_0_27_211 VPWR VGND VPWR VGND sky130_ef_sc_hd__decap_12
XTAP_TAPCELL_ROW_30_378 VGND VPWR sky130_fd_sc_hd__tapvpwrvgnd_1
XFILLER_0_2_333 VPWR VGND VPWR VGND sky130_ef_sc_hd__decap_12
XscaleAdd._678_ scaleAdd._318_ scaleAdd._195_ scaleAdd._250_ VGND VGND VPWR VPWR scaleAdd._251_
+ sky130_fd_sc_hd__and3_1
Xaccumulator._1613_ accumulator._0611_ accumulator._0639_ accumulator._0641_ accumulator._0558_
+ VGND VGND VPWR VPWR accumulator._0710_ sky130_fd_sc_hd__a211o_1
Xaccumulator._1544_ accumulator.io_accOut\[5\] accumulator._0539_ accumulator._0531_
+ accumulator._0640_ accumulator._0498_ VGND VGND VPWR VPWR accumulator._0641_ sky130_fd_sc_hd__a311oi_2
XFILLER_0_2_377 VPWR VGND VPWR VGND sky130_ef_sc_hd__decap_12
XFILLER_0_10_177 VPWR VGND VPWR VGND sky130_ef_sc_hd__decap_12
Xaccumulator._1475_ accumulator._0565_ accumulator._0571_ VGND VGND VPWR VPWR accumulator._0572_
+ sky130_fd_sc_hd__and2_1
XTAP_TAPCELL_ROW_38_434 VGND VPWR sky130_fd_sc_hd__tapvpwrvgnd_1
Xaccumulator._2027_ accumulator._1105_ accumulator._1109_ accumulator._1123_ VGND
+ VGND VPWR VPWR accumulator._1124_ sky130_fd_sc_hd__and3_1
XFILLER_0_33_225 VGND VGND VPWR VPWR sky130_fd_sc_hd__decap_8
XTAP_TAPCELL_ROW_21_312 VGND VPWR sky130_fd_sc_hd__tapvpwrvgnd_1
XFILLER_0_18_244 VGND VGND VPWR VPWR sky130_fd_sc_hd__decap_3
XFILLER_0_5_193 VPWR VGND VPWR VGND sky130_ef_sc_hd__decap_12
XscaleAdd._601_ scaleAdd._175_ scaleAdd._177_ VGND VGND VPWR VPWR scaleAdd._178_ sky130_fd_sc_hd__xor2_1
XscaleAdd._532_ scaleAdd._313_ scaleAdd._077_ scaleAdd._043_ VGND VGND VPWR VPWR scaleAdd._111_
+ sky130_fd_sc_hd__and3_1
Xinput16 io_inScaleA[7] VGND VGND VPWR VPWR net16 sky130_fd_sc_hd__buf_2
XFILLER_0_58_15 VPWR VGND VPWR VGND sky130_ef_sc_hd__decap_12
XFILLER_0_32_291 VPWR VGND VPWR VGND sky130_ef_sc_hd__decap_12
XscaleAdd._394_ scaleAdd._333_ scaleAdd._335_ VGND VGND VPWR VPWR scaleAdd._336_ sky130_fd_sc_hd__nor2_1
XscaleAdd._463_ operator.io_outMant\[3\] scaleAdd._322_ VGND VGND VPWR VPWR scaleAdd._043_
+ sky130_fd_sc_hd__and2_1
XFILLER_0_59_111 VGND VGND VPWR VPWR sky130_fd_sc_hd__fill_1
XFILLER_0_59_100 VGND VGND VPWR VPWR sky130_fd_sc_hd__fill_1
XTAP_TAPCELL_ROW_35_415 VGND VPWR sky130_fd_sc_hd__tapvpwrvgnd_1
Xaccumulator._1260_ accumulator.io_accOut\[27\] accumulator._0357_ VGND VGND VPWR
+ VPWR accumulator._0359_ sky130_fd_sc_hd__nor2_1
XFILLER_0_55_383 VGND VGND VPWR VPWR sky130_fd_sc_hd__decap_8
XFILLER_0_55_350 VPWR VGND VPWR VGND sky130_ef_sc_hd__decap_12
XFILLER_0_47_317 VPWR VGND VPWR VGND sky130_ef_sc_hd__decap_12
XFILLER_0_23_73 VPWR VGND VPWR VGND sky130_ef_sc_hd__decap_12
XFILLER_0_15_247 VGND VGND VPWR VPWR sky130_fd_sc_hd__fill_1
XPHY_EDGE_ROW_21_Left_92 VGND VGND VPWR VPWR sky130_fd_sc_hd__decap_3
XFILLER_0_54_3 VPWR VGND VPWR VGND sky130_ef_sc_hd__decap_12
Xaccumulator._1527_ accumulator._0536_ accumulator._0495_ accumulator._0539_ VGND
+ VGND VPWR VPWR accumulator._0624_ sky130_fd_sc_hd__a21o_1
XFILLER_0_3_50 VGND VGND VPWR VPWR sky130_fd_sc_hd__decap_6
XFILLER_0_65_103 VGND VGND VPWR VPWR sky130_fd_sc_hd__fill_1
Xaccumulator._1458_ accumulator._0525_ accumulator._0535_ accumulator._0554_ VGND
+ VGND VPWR VPWR accumulator._0555_ sky130_fd_sc_hd__a21o_1
XFILLER_0_38_339 VGND VGND VPWR VPWR sky130_fd_sc_hd__decap_8
Xaccumulator._1389_ accumulator.io_accOut\[15\] accumulator._0484_ accumulator._0485_
+ VGND VGND VPWR VPWR accumulator._0486_ sky130_fd_sc_hd__mux2_1
XFILLER_0_3_94 VGND VGND VPWR VPWR sky130_fd_sc_hd__decap_4
XFILLER_0_65_169 VPWR VGND VPWR VGND sky130_ef_sc_hd__decap_12
XFILLER_0_21_206 VGND VGND VPWR VPWR sky130_fd_sc_hd__fill_1
XFILLER_0_28_29 VPWR VGND VPWR VGND sky130_ef_sc_hd__decap_12
XFILLER_0_14_291 VGND VGND VPWR VPWR sky130_fd_sc_hd__fill_1
XTAP_TAPCELL_ROW_49_518 VGND VPWR sky130_fd_sc_hd__tapvpwrvgnd_1
XTAP_TAPCELL_ROW_6_195 VGND VPWR sky130_fd_sc_hd__tapvpwrvgnd_1
XFILLER_0_60_27 VGND VGND VPWR VPWR sky130_fd_sc_hd__fill_1
XFILLER_0_56_114 VGND VGND VPWR VPWR sky130_fd_sc_hd__decap_8
XFILLER_0_44_309 VPWR VGND VPWR VGND sky130_ef_sc_hd__decap_12
XTAP_TAPCELL_ROW_40_451 VGND VPWR sky130_fd_sc_hd__tapvpwrvgnd_1
XFILLER_0_29_328 VGND VGND VPWR VPWR sky130_fd_sc_hd__decap_8
XFILLER_0_69_69 VPWR VGND VPWR VGND sky130_ef_sc_hd__decap_12
XFILLER_0_52_386 VGND VGND VPWR VPWR sky130_fd_sc_hd__decap_8
XFILLER_0_52_331 VGND VGND VPWR VPWR sky130_fd_sc_hd__decap_8
XscaleAdd._515_ scaleAdd._089_ scaleAdd._093_ VGND VGND VPWR VPWR scaleAdd._094_ sky130_fd_sc_hd__and2_1
XscaleAdd._446_ operator.io_outMant\[0\] scaleAdd._025_ scaleAdd._310_ VGND VGND VPWR
+ VPWR scaleAdd._027_ sky130_fd_sc_hd__a21o_1
XscaleAdd._377_ scaleAdd._303_ scaleAdd._319_ scaleAdd._308_ VGND VGND VPWR VPWR scaleAdd._321_
+ sky130_fd_sc_hd__a21oi_1
Xaccumulator._2361_ accumulator._0041_ accumulator._0292_ VGND VGND VPWR VPWR accumulator._0294_
+ sky130_fd_sc_hd__or2_1
XFILLER_0_18_62 VGND VGND VPWR VPWR sky130_fd_sc_hd__fill_1
Xaccumulator._2430_ clknet_2_0__leaf_clock accumulator._0031_ VGND VGND VPWR VPWR
+ accumulator.io_accOut\[29\] sky130_fd_sc_hd__dfxtp_1
XFILLER_0_47_147 VPWR VGND VPWR VGND sky130_ef_sc_hd__decap_12
XFILLER_0_47_136 VGND VGND VPWR VPWR sky130_fd_sc_hd__fill_2
XFILLER_0_47_103 VGND VGND VPWR VPWR sky130_fd_sc_hd__fill_2
Xaccumulator._2292_ accumulator._0118_ accumulator._0066_ accumulator._0209_ accumulator._0091_
+ accumulator.io_accOut\[18\] VGND VGND VPWR VPWR accumulator._0227_ sky130_fd_sc_hd__a32o_1
X_17_ accumulator.io_accOut\[17\] VGND VGND VPWR VPWR net30 sky130_fd_sc_hd__buf_1
XFILLER_0_34_83 VGND VGND VPWR VPWR sky130_fd_sc_hd__fill_1
Xaccumulator._1243_ accumulator.io_inExp\[5\] accumulator._0126_ VGND VGND VPWR VPWR
+ accumulator._0342_ sky130_fd_sc_hd__xor2_1
XFILLER_0_19_6 VGND VGND VPWR VPWR sky130_fd_sc_hd__decap_8
Xaccumulator._1312_ accumulator._0360_ net59 VGND VGND VPWR VPWR accumulator._0409_
+ sky130_fd_sc_hd__xnor2_4
XFILLER_0_62_139 VGND VGND VPWR VPWR sky130_fd_sc_hd__fill_1
XFILLER_0_62_106 VGND VGND VPWR VPWR sky130_fd_sc_hd__decap_4
XFILLER_0_7_222 VGND VGND VPWR VPWR sky130_fd_sc_hd__fill_2
XTAP_TAPCELL_ROW_3_176 VGND VPWR sky130_fd_sc_hd__tapvpwrvgnd_1
XFILLER_0_66_401 VPWR VGND VPWR VGND sky130_ef_sc_hd__decap_12
XTAP_TAPCELL_ROW_54_554 VGND VPWR sky130_fd_sc_hd__tapvpwrvgnd_1
XFILLER_0_53_117 VGND VGND VPWR VPWR sky130_fd_sc_hd__fill_2
XFILLER_0_38_169 VGND VGND VPWR VPWR sky130_fd_sc_hd__fill_1
XFILLER_0_38_136 VGND VGND VPWR VPWR sky130_fd_sc_hd__decap_4
XFILLER_0_26_309 VGND VGND VPWR VPWR sky130_fd_sc_hd__decap_8
XFILLER_0_19_350 VPWR VGND VPWR VGND sky130_ef_sc_hd__decap_12
XFILLER_0_61_194 VGND VGND VPWR VPWR sky130_fd_sc_hd__decap_8
XFILLER_0_39_39 VPWR VGND VPWR VGND sky130_ef_sc_hd__decap_12
XFILLER_0_34_397 VGND VGND VPWR VPWR sky130_fd_sc_hd__fill_1
XFILLER_0_34_342 VPWR VGND VPWR VGND sky130_ef_sc_hd__decap_12
XFILLER_0_55_27 VPWR VGND VPWR VGND sky130_ef_sc_hd__decap_12
XFILLER_0_29_125 VPWR VGND VPWR VGND sky130_ef_sc_hd__decap_12
XTAP_TAPCELL_ROW_17_278 VGND VPWR sky130_fd_sc_hd__tapvpwrvgnd_1
Xaccumulator._1930_ accumulator._0918_ accumulator._0809_ accumulator._1026_ VGND
+ VGND VPWR VPWR accumulator._1027_ sky130_fd_sc_hd__o21a_1
XFILLER_0_52_161 VGND VGND VPWR VPWR sky130_fd_sc_hd__fill_1
XFILLER_0_29_169 VPWR VGND VPWR VGND sky130_ef_sc_hd__decap_12
XFILLER_0_25_364 VPWR VGND VPWR VGND sky130_ef_sc_hd__decap_12
Xaccumulator._1861_ accumulator._0865_ accumulator._0956_ accumulator._0957_ VGND
+ VGND VPWR VPWR accumulator._0958_ sky130_fd_sc_hd__a21oi_1
XFILLER_0_40_356 VGND VGND VPWR VPWR sky130_fd_sc_hd__decap_8
Xaccumulator._1792_ accumulator.io_accOut\[20\] accumulator._0582_ accumulator._0404_
+ VGND VGND VPWR VPWR accumulator._0889_ sky130_fd_sc_hd__mux2_1
XscaleAdd._429_ scaleAdd._009_ scaleAdd._338_ VGND VGND VPWR VPWR scaleAdd._010_ sky130_fd_sc_hd__xnor2_1
XFILLER_0_4_269 VGND VGND VPWR VPWR sky130_fd_sc_hd__decap_8
XFILLER_0_20_74 VGND VGND VPWR VPWR sky130_fd_sc_hd__decap_8
XFILLER_0_20_85 VPWR VGND VPWR VGND sky130_ef_sc_hd__decap_12
Xaccumulator._2413_ clknet_2_3__leaf_clock accumulator._0014_ VGND VGND VPWR VPWR
+ accumulator.io_accOut\[12\] sky130_fd_sc_hd__dfxtp_1
Xaccumulator._2344_ accumulator._0260_ accumulator._0269_ accumulator._0275_ VGND
+ VGND VPWR VPWR accumulator._0277_ sky130_fd_sc_hd__o21ai_1
XFILLER_0_17_3 VGND VGND VPWR VPWR sky130_fd_sc_hd__fill_2
XTAP_TAPCELL_ROW_51_535 VGND VPWR sky130_fd_sc_hd__tapvpwrvgnd_1
Xaccumulator._2275_ accumulator._0118_ accumulator._0039_ accumulator._0209_ accumulator._0091_
+ accumulator.io_accOut\[16\] VGND VGND VPWR VPWR accumulator._0210_ sky130_fd_sc_hd__a32o_1
Xaccumulator._1226_ accumulator.io_inExp\[2\] accumulator._0263_ VGND VGND VPWR VPWR
+ accumulator._0283_ sky130_fd_sc_hd__nor2_4
XTAP_TAPCELL_ROW_0_146 VGND VPWR sky130_fd_sc_hd__tapvpwrvgnd_1
XFILLER_0_16_353 VGND VGND VPWR VPWR sky130_fd_sc_hd__decap_8
XTAP_TAPCELL_ROW_8_213 VGND VPWR sky130_fd_sc_hd__tapvpwrvgnd_1
XFILLER_0_58_209 VGND VGND VPWR VPWR sky130_fd_sc_hd__decap_6
XFILLER_0_66_253 VPWR VGND VPWR VGND sky130_ef_sc_hd__decap_12
XTAP_TAPCELL_ROW_14_259 VGND VPWR sky130_fd_sc_hd__tapvpwrvgnd_1
XFILLER_0_66_15 VPWR VGND VPWR VGND sky130_ef_sc_hd__decap_12
XFILLER_0_22_345 VGND VGND VPWR VPWR sky130_fd_sc_hd__fill_1
XTAP_TAPCELL_ROW_65_638 VGND VPWR sky130_fd_sc_hd__tapvpwrvgnd_1
XFILLER_0_57_297 VGND VGND VPWR VPWR sky130_fd_sc_hd__fill_2
XFILLER_0_57_275 VGND VGND VPWR VPWR sky130_fd_sc_hd__decap_4
XFILLER_0_57_231 VGND VGND VPWR VPWR sky130_fd_sc_hd__fill_1
Xaccumulator._2060_ accumulator._0705_ accumulator._1156_ VGND VGND VPWR VPWR accumulator._1157_
+ sky130_fd_sc_hd__xnor2_1
XFILLER_0_9_328 VGND VGND VPWR VPWR sky130_fd_sc_hd__decap_8
XFILLER_0_17_117 VGND VGND VPWR VPWR sky130_fd_sc_hd__fill_1
Xaccumulator._1913_ accumulator._1009_ accumulator._1006_ VGND VGND VPWR VPWR accumulator._1010_
+ sky130_fd_sc_hd__xor2_2
Xaccumulator._1775_ accumulator._0866_ accumulator._0871_ VGND VGND VPWR VPWR accumulator._0872_
+ sky130_fd_sc_hd__nand2_1
Xaccumulator._1844_ accumulator._0939_ accumulator._0929_ accumulator._0928_ accumulator._0940_
+ VGND VGND VPWR VPWR accumulator._0941_ sky130_fd_sc_hd__a31oi_2
XFILLER_0_40_197 VPWR VGND VPWR VGND sky130_ef_sc_hd__decap_12
XFILLER_0_0_261 VPWR VGND VPWR VGND sky130_ef_sc_hd__decap_12
XFILLER_0_13_378 VPWR VGND VPWR VGND sky130_ef_sc_hd__decap_12
Xaccumulator._2258_ accumulator._0128_ accumulator._0129_ accumulator._0169_ accumulator._0397_
+ VGND VGND VPWR VPWR accumulator._0192_ sky130_fd_sc_hd__a31o_1
Xaccumulator._2327_ accumulator._0036_ accumulator._0259_ VGND VGND VPWR VPWR accumulator._0260_
+ sky130_fd_sc_hd__nand2_1
XFILLER_0_63_278 VGND VGND VPWR VPWR sky130_fd_sc_hd__fill_2
XFILLER_0_63_245 VGND VGND VPWR VPWR sky130_fd_sc_hd__decap_8
Xaccumulator._2189_ accumulator._1018_ accumulator._0036_ accumulator._0123_ VGND
+ VGND VPWR VPWR accumulator._0124_ sky130_fd_sc_hd__o21bai_1
XFILLER_0_48_286 VGND VGND VPWR VPWR sky130_fd_sc_hd__fill_1
XFILLER_0_48_253 VGND VGND VPWR VPWR sky130_fd_sc_hd__decap_4
XFILLER_0_23_109 VGND VGND VPWR VPWR sky130_fd_sc_hd__decap_3
Xaccumulator._1209_ accumulator._0065_ accumulator._0075_ VGND VGND VPWR VPWR accumulator._0116_
+ sky130_fd_sc_hd__nor2_1
XFILLER_0_31_142 VPWR VGND VPWR VGND sky130_ef_sc_hd__decap_12
XFILLER_0_6_3 VPWR VGND VPWR VGND sky130_ef_sc_hd__decap_12
XFILLER_0_36_29 VPWR VGND VPWR VGND sky130_ef_sc_hd__decap_12
XTAP_TAPCELL_ROW_62_619 VGND VPWR sky130_fd_sc_hd__tapvpwrvgnd_1
XFILLER_0_27_415 VGND VGND VPWR VPWR sky130_fd_sc_hd__decap_3
XTAP_TAPCELL_ROW_70_685 VGND VPWR sky130_fd_sc_hd__tapvpwrvgnd_1
XTAP_TAPCELL_ROW_70_674 VGND VPWR sky130_fd_sc_hd__tapvpwrvgnd_1
XFILLER_0_54_278 VPWR VGND VPWR VGND sky130_ef_sc_hd__decap_12
XFILLER_0_42_407 VGND VGND VPWR VPWR sky130_fd_sc_hd__decap_8
XFILLER_0_6_309 VPWR VGND VPWR VGND sky130_ef_sc_hd__decap_12
XscaleAdd._694_ scaleAdd._330_ scaleAdd._234_ VGND VGND VPWR VPWR scaleAdd._266_ sky130_fd_sc_hd__nand2_1
Xaccumulator._1560_ accumulator._0611_ accumulator._0598_ accumulator._0656_ VGND
+ VGND VPWR VPWR accumulator._0657_ sky130_fd_sc_hd__a21o_1
XFILLER_0_22_197 VGND VGND VPWR VPWR sky130_fd_sc_hd__decap_4
XFILLER_0_10_304 VGND VGND VPWR VPWR sky130_fd_sc_hd__decap_4
Xaccumulator._2112_ accumulator._0980_ accumulator._1132_ accumulator._1180_ VGND
+ VGND VPWR VPWR accumulator._0046_ sky130_fd_sc_hd__and3_1
Xaccumulator._1491_ accumulator.io_accOut\[26\] accumulator.io_accOut\[25\] accumulator.io_accOut\[24\]
+ accumulator.io_accOut\[23\] VGND VGND VPWR VPWR accumulator._0588_ sky130_fd_sc_hd__or4_1
Xaccumulator._2043_ accumulator._1088_ accumulator._1139_ VGND VGND VPWR VPWR accumulator._1140_
+ sky130_fd_sc_hd__or2_1
XFILLER_0_45_267 VGND VGND VPWR VPWR sky130_fd_sc_hd__decap_4
XFILLER_0_33_407 VGND VGND VPWR VPWR sky130_fd_sc_hd__decap_8
XTAP_TAPCELL_ROW_33_398 VGND VPWR sky130_fd_sc_hd__tapvpwrvgnd_1
XFILLER_0_9_103 VGND VGND VPWR VPWR sky130_fd_sc_hd__fill_2
XFILLER_0_60_259 VGND VGND VPWR VPWR sky130_fd_sc_hd__fill_1
XFILLER_0_60_248 VGND VGND VPWR VPWR sky130_fd_sc_hd__decap_4
Xaccumulator._1827_ accumulator._0912_ VGND VGND VPWR VPWR accumulator._0924_ sky130_fd_sc_hd__inv_2
Xaccumulator._1758_ accumulator._0852_ accumulator._0709_ VGND VGND VPWR VPWR accumulator._0855_
+ sky130_fd_sc_hd__or2_1
Xaccumulator._1689_ accumulator._0766_ accumulator._0776_ accumulator._0784_ accumulator._0785_
+ VGND VGND VPWR VPWR accumulator._0786_ sky130_fd_sc_hd__o31a_1
XFILLER_0_6_61 VGND VGND VPWR VPWR sky130_fd_sc_hd__fill_1
XTAP_TAPCELL_ROW_24_332 VGND VPWR sky130_fd_sc_hd__tapvpwrvgnd_1
XFILLER_0_36_234 VPWR VGND VPWR VGND sky130_ef_sc_hd__decap_12
XFILLER_0_47_39 VPWR VGND VPWR VGND sky130_ef_sc_hd__decap_12
XFILLER_0_63_27 VPWR VGND VPWR VGND sky130_ef_sc_hd__decap_12
XFILLER_0_27_223 VGND VGND VPWR VPWR sky130_fd_sc_hd__fill_1
XFILLER_0_12_42 VGND VGND VPWR VPWR sky130_fd_sc_hd__fill_1
XTAP_TAPCELL_ROW_30_379 VGND VPWR sky130_fd_sc_hd__tapvpwrvgnd_1
XFILLER_0_2_389 VPWR VGND VPWR VGND sky130_ef_sc_hd__decap_12
XFILLER_0_2_345 VPWR VGND VPWR VGND sky130_ef_sc_hd__decap_12
XscaleAdd._677_ scaleAdd._312_ scaleAdd._234_ VGND VGND VPWR VPWR scaleAdd._250_ sky130_fd_sc_hd__and2_1
Xaccumulator._1612_ accumulator._0606_ accumulator._0706_ accumulator._0707_ accumulator._0708_
+ VGND VGND VPWR VPWR accumulator._0709_ sky130_fd_sc_hd__o31a_2
Xaccumulator._1474_ accumulator._0433_ accumulator._0570_ accumulator._0469_ VGND
+ VGND VPWR VPWR accumulator._0571_ sky130_fd_sc_hd__a21o_1
Xaccumulator._1543_ accumulator._0468_ net72 accumulator._0550_ VGND VGND VPWR VPWR
+ accumulator._0640_ sky130_fd_sc_hd__and3_1
XFILLER_0_10_189 VGND VGND VPWR VPWR sky130_fd_sc_hd__decap_6
XTAP_TAPCELL_ROW_38_435 VGND VPWR sky130_fd_sc_hd__tapvpwrvgnd_1
Xaccumulator._2026_ accumulator._1122_ VGND VGND VPWR VPWR accumulator._1123_ sky130_fd_sc_hd__inv_2
XTAP_TAPCELL_ROW_21_313 VGND VPWR sky130_fd_sc_hd__tapvpwrvgnd_1
XFILLER_0_41_281 VPWR VGND VPWR VGND sky130_ef_sc_hd__decap_12
XFILLER_0_56_307 VGND VGND VPWR VPWR sky130_fd_sc_hd__fill_1
XFILLER_0_64_373 VGND VGND VPWR VPWR sky130_fd_sc_hd__fill_2
XFILLER_0_58_27 VGND VGND VPWR VPWR sky130_fd_sc_hd__fill_1
XscaleAdd._531_ scaleAdd._078_ scaleAdd._109_ VGND VGND VPWR VPWR scaleAdd._110_ sky130_fd_sc_hd__xor2_1
XscaleAdd._600_ scaleAdd._123_ scaleAdd._147_ scaleAdd._176_ VGND VGND VPWR VPWR scaleAdd._177_
+ sky130_fd_sc_hd__a21bo_1
XscaleAdd._462_ scaleAdd._034_ scaleAdd._035_ scaleAdd._036_ VGND VGND VPWR VPWR scaleAdd._042_
+ sky130_fd_sc_hd__nand3_1
Xinput17 io_inScaleB[6] VGND VGND VPWR VPWR net17 sky130_fd_sc_hd__buf_1
XscaleAdd._393_ scaleAdd._308_ net13 VGND VGND VPWR VPWR scaleAdd._335_ sky130_fd_sc_hd__nand2_1
XFILLER_0_59_167 VGND VGND VPWR VPWR sky130_fd_sc_hd__fill_1
XFILLER_0_47_329 VGND VGND VPWR VPWR sky130_fd_sc_hd__decap_6
XTAP_TAPCELL_ROW_35_416 VGND VPWR sky130_fd_sc_hd__tapvpwrvgnd_1
XFILLER_0_70_321 VPWR VGND VPWR VGND sky130_ef_sc_hd__decap_12
XFILLER_0_55_362 VPWR VGND VPWR VGND sky130_ef_sc_hd__decap_12
XFILLER_0_23_85 VPWR VGND VPWR VGND sky130_ef_sc_hd__decap_12
XFILLER_0_70_365 VPWR VGND VPWR VGND sky130_ef_sc_hd__decap_12
XscaleAdd._729_ scaleAdd._286_ scaleAdd._287_ scaleAdd._281_ VGND VGND VPWR VPWR scaleAdd._295_
+ sky130_fd_sc_hd__mux2_1
XFILLER_0_23_281 VGND VGND VPWR VPWR sky130_fd_sc_hd__decap_6
XFILLER_0_2_197 VGND VGND VPWR VPWR sky130_fd_sc_hd__decap_6
XFILLER_0_48_82 VGND VGND VPWR VPWR sky130_fd_sc_hd__fill_2
XFILLER_0_47_3 VPWR VGND VPWR VGND sky130_ef_sc_hd__decap_12
Xaccumulator._1457_ accumulator._0428_ accumulator._0545_ accumulator._0552_ accumulator._0553_
+ VGND VGND VPWR VPWR accumulator._0554_ sky130_fd_sc_hd__a31o_1
Xaccumulator._1526_ accumulator._0621_ accumulator._0622_ accumulator._0476_ VGND
+ VGND VPWR VPWR accumulator._0623_ sky130_fd_sc_hd__a21o_1
XFILLER_0_3_62 VPWR VGND VPWR VGND sky130_ef_sc_hd__decap_12
XFILLER_0_64_92 VGND VGND VPWR VPWR sky130_fd_sc_hd__decap_3
XFILLER_0_38_329 VGND VGND VPWR VPWR sky130_fd_sc_hd__fill_2
Xaccumulator._1388_ accumulator._0393_ VGND VGND VPWR VPWR accumulator._0485_ sky130_fd_sc_hd__buf_6
Xaccumulator._2009_ accumulator._0879_ accumulator._1090_ VGND VGND VPWR VPWR accumulator._1106_
+ sky130_fd_sc_hd__and2_1
XFILLER_0_46_373 VGND VGND VPWR VPWR sky130_fd_sc_hd__decap_4
XTAP_TAPCELL_ROW_49_519 VGND VPWR sky130_fd_sc_hd__tapvpwrvgnd_1
XFILLER_0_44_29 VPWR VGND VPWR VGND sky130_ef_sc_hd__decap_12
XTAP_TAPCELL_ROW_6_196 VGND VPWR sky130_fd_sc_hd__tapvpwrvgnd_1
XFILLER_0_64_192 VGND VGND VPWR VPWR sky130_fd_sc_hd__decap_4
XTAP_TAPCELL_ROW_40_452 VGND VPWR sky130_fd_sc_hd__tapvpwrvgnd_1
XFILLER_0_8_29 VGND VGND VPWR VPWR sky130_fd_sc_hd__fill_1
XFILLER_0_69_15 VPWR VGND VPWR VGND sky130_ef_sc_hd__decap_12
XFILLER_0_52_376 VGND VGND VPWR VPWR sky130_fd_sc_hd__fill_1
XFILLER_0_52_365 VGND VGND VPWR VPWR sky130_fd_sc_hd__fill_1
XscaleAdd._514_ scaleAdd._088_ scaleAdd._090_ scaleAdd._091_ scaleAdd._092_ VGND VGND
+ VPWR VPWR scaleAdd._093_ sky130_fd_sc_hd__a2bb2o_1
XscaleAdd._445_ scaleAdd._311_ scaleAdd._025_ VGND VGND VPWR VPWR scaleAdd._026_ sky130_fd_sc_hd__or2b_4
XFILLER_0_20_251 VGND VGND VPWR VPWR sky130_fd_sc_hd__fill_1
Xaccumulator._2291_ accumulator._0118_ accumulator._0153_ accumulator._0224_ accumulator._0089_
+ VGND VGND VPWR VPWR accumulator._0226_ sky130_fd_sc_hd__o211a_1
X_16_ accumulator.io_accOut\[16\] VGND VGND VPWR VPWR net29 sky130_fd_sc_hd__buf_1
Xaccumulator._1311_ accumulator._0408_ VGND VGND VPWR VPWR accumulator._0001_ sky130_fd_sc_hd__clkbuf_1
XscaleAdd._376_ scaleAdd._303_ scaleAdd._319_ scaleAdd._308_ VGND VGND VPWR VPWR scaleAdd._320_
+ sky130_fd_sc_hd__and3_1
Xaccumulator._2360_ accumulator.io_accOut\[27\] accumulator._0291_ accumulator._0405_
+ VGND VGND VPWR VPWR accumulator._0292_ sky130_fd_sc_hd__mux2_1
XFILLER_0_18_85 VGND VGND VPWR VPWR sky130_fd_sc_hd__decap_8
XFILLER_0_47_159 VGND VGND VPWR VPWR sky130_fd_sc_hd__decap_8
Xaccumulator._1242_ accumulator._0105_ accumulator._0136_ accumulator._0340_ accumulator._0126_
+ accumulator.io_inExp\[4\] VGND VGND VPWR VPWR accumulator._0341_ sky130_fd_sc_hd__a32o_2
XFILLER_0_43_321 VGND VGND VPWR VPWR sky130_fd_sc_hd__fill_1
XFILLER_0_11_284 VGND VGND VPWR VPWR sky130_fd_sc_hd__fill_2
XFILLER_0_66_413 VGND VGND VPWR VPWR sky130_fd_sc_hd__decap_6
XTAP_TAPCELL_ROW_54_555 VGND VPWR sky130_fd_sc_hd__tapvpwrvgnd_1
Xaccumulator._1509_ accumulator._0553_ VGND VGND VPWR VPWR accumulator._0606_ sky130_fd_sc_hd__buf_2
XTAP_TAPCELL_ROW_3_177 VGND VPWR sky130_fd_sc_hd__tapvpwrvgnd_1
XFILLER_0_53_107 VGND VGND VPWR VPWR sky130_fd_sc_hd__decap_4
XPHY_EDGE_ROW_49_Left_120 VGND VGND VPWR VPWR sky130_fd_sc_hd__decap_3
XFILLER_0_19_362 VGND VGND VPWR VPWR sky130_fd_sc_hd__fill_1
XFILLER_0_34_354 VGND VGND VPWR VPWR sky130_fd_sc_hd__decap_8
XFILLER_0_55_39 VPWR VGND VPWR VGND sky130_ef_sc_hd__decap_12
XFILLER_0_69_295 VPWR VGND VPWR VGND sky130_ef_sc_hd__decap_12
XFILLER_0_29_148 VPWR VGND VPWR VGND sky130_ef_sc_hd__decap_12
XFILLER_0_29_137 VGND VGND VPWR VPWR sky130_fd_sc_hd__decap_6
XTAP_TAPCELL_ROW_17_279 VGND VPWR sky130_fd_sc_hd__tapvpwrvgnd_1
Xaccumulator._1860_ accumulator._0880_ accumulator._0881_ VGND VGND VPWR VPWR accumulator._0957_
+ sky130_fd_sc_hd__and2_1
XFILLER_0_52_195 VGND VGND VPWR VPWR sky130_fd_sc_hd__fill_1
XFILLER_0_52_173 VPWR VGND VPWR VGND sky130_ef_sc_hd__decap_12
XFILLER_0_37_181 VPWR VGND VPWR VGND sky130_ef_sc_hd__decap_12
XFILLER_0_25_343 VGND VGND VPWR VPWR sky130_fd_sc_hd__fill_1
Xaccumulator._1791_ accumulator._0733_ accumulator._0763_ VGND VGND VPWR VPWR accumulator._0888_
+ sky130_fd_sc_hd__nand2_1
XFILLER_0_40_379 VGND VGND VPWR VPWR sky130_fd_sc_hd__decap_3
XscaleAdd._428_ scaleAdd._002_ scaleAdd._004_ VGND VGND VPWR VPWR scaleAdd._009_ sky130_fd_sc_hd__xor2_1
XFILLER_0_20_97 VPWR VGND VPWR VGND sky130_ef_sc_hd__decap_12
Xaccumulator._2274_ accumulator._0406_ accumulator._0041_ VGND VGND VPWR VPWR accumulator._0209_
+ sky130_fd_sc_hd__and2_1
Xaccumulator._2412_ clknet_2_3__leaf_clock accumulator._0013_ VGND VGND VPWR VPWR
+ accumulator.io_accOut\[11\] sky130_fd_sc_hd__dfxtp_1
Xaccumulator._2343_ accumulator._0103_ accumulator._0104_ accumulator._0268_ accumulator._0269_
+ accumulator._0275_ VGND VGND VPWR VPWR accumulator._0276_ sky130_fd_sc_hd__a2111o_1
XTAP_TAPCELL_ROW_0_147 VGND VPWR sky130_fd_sc_hd__tapvpwrvgnd_1
XTAP_TAPCELL_ROW_51_536 VGND VPWR sky130_fd_sc_hd__tapvpwrvgnd_1
XPHY_EDGE_ROW_3_Right_3 VGND VGND VPWR VPWR sky130_fd_sc_hd__decap_3
XFILLER_0_0_41 VPWR VGND VPWR VGND sky130_ef_sc_hd__decap_12
XFILLER_0_0_85 VPWR VGND VPWR VGND sky130_ef_sc_hd__decap_12
XFILLER_0_16_321 VGND VGND VPWR VPWR sky130_fd_sc_hd__decap_3
Xaccumulator._1225_ accumulator.io_inExp\[2\] accumulator._0263_ VGND VGND VPWR VPWR
+ accumulator._0273_ sky130_fd_sc_hd__and2_4
Xaccumulator._1989_ accumulator._1083_ accumulator._1085_ VGND VGND VPWR VPWR accumulator._1086_
+ sky130_fd_sc_hd__nor2_1
XFILLER_0_3_281 VGND VGND VPWR VPWR sky130_fd_sc_hd__fill_1
XTAP_TAPCELL_ROW_8_214 VGND VPWR sky130_fd_sc_hd__tapvpwrvgnd_1
XFILLER_0_9_61 VPWR VGND VPWR VGND sky130_ef_sc_hd__decap_12
XFILLER_0_66_287 VPWR VGND VPWR VGND sky130_ef_sc_hd__decap_12
XFILLER_0_66_265 VPWR VGND VPWR VGND sky130_ef_sc_hd__decap_12
XFILLER_0_34_195 VGND VGND VPWR VPWR sky130_fd_sc_hd__fill_1
XFILLER_0_1_207 VGND VGND VPWR VPWR sky130_fd_sc_hd__decap_3
XFILLER_0_66_27 VGND VGND VPWR VPWR sky130_fd_sc_hd__fill_1
XTAP_TAPCELL_ROW_65_639 VGND VPWR sky130_fd_sc_hd__tapvpwrvgnd_1
XFILLER_0_15_31 VPWR VGND VPWR VGND sky130_ef_sc_hd__decap_12
XFILLER_0_57_221 VGND VGND VPWR VPWR sky130_fd_sc_hd__decap_3
Xaccumulator._1912_ accumulator._0992_ accumulator._1003_ VGND VGND VPWR VPWR accumulator._1009_
+ sky130_fd_sc_hd__nor2_4
Xaccumulator._1843_ accumulator._0743_ accumulator._0744_ VGND VGND VPWR VPWR accumulator._0940_
+ sky130_fd_sc_hd__and2b_1
XFILLER_0_13_335 VGND VGND VPWR VPWR sky130_fd_sc_hd__fill_1
Xaccumulator._1774_ accumulator._0869_ accumulator._0870_ VGND VGND VPWR VPWR accumulator._0871_
+ sky130_fd_sc_hd__or2_2
XFILLER_0_56_82 VGND VGND VPWR VPWR sky130_fd_sc_hd__fill_2
XFILLER_0_0_273 VGND VGND VPWR VPWR sky130_fd_sc_hd__decap_6
Xaccumulator._2257_ net106 accumulator._0167_ accumulator._0184_ accumulator._0191_
+ accumulator._0177_ VGND VGND VPWR VPWR accumulator._0016_ sky130_fd_sc_hd__o221a_1
Xaccumulator._2326_ accumulator.io_accOut\[23\] accumulator._0258_ accumulator._0405_
+ VGND VGND VPWR VPWR accumulator._0259_ sky130_fd_sc_hd__mux2_1
Xaccumulator._1208_ accumulator.io_inExp\[3\] accumulator._0095_ VGND VGND VPWR VPWR
+ accumulator._0105_ sky130_fd_sc_hd__or2_1
Xaccumulator._2188_ accumulator._0103_ accumulator._0104_ accumulator._1024_ VGND
+ VGND VPWR VPWR accumulator._0123_ sky130_fd_sc_hd__a21oi_1
XFILLER_0_31_198 VGND VGND VPWR VPWR sky130_fd_sc_hd__decap_8
XFILLER_0_31_154 VPWR VGND VPWR VGND sky130_ef_sc_hd__decap_12
XTAP_TAPCELL_ROW_70_686 VGND VPWR sky130_fd_sc_hd__tapvpwrvgnd_1
XTAP_TAPCELL_ROW_70_675 VGND VPWR sky130_fd_sc_hd__tapvpwrvgnd_1
XFILLER_0_54_224 VGND VGND VPWR VPWR sky130_fd_sc_hd__decap_3
XFILLER_0_54_202 VGND VGND VPWR VPWR sky130_fd_sc_hd__decap_8
XFILLER_0_52_29 VPWR VGND VPWR VGND sky130_ef_sc_hd__decap_12
XTAP_TAPCELL_ROW_27_352 VGND VPWR sky130_fd_sc_hd__tapvpwrvgnd_1
XFILLER_0_22_121 VGND VGND VPWR VPWR sky130_fd_sc_hd__fill_1
XscaleAdd._693_ scaleAdd._253_ scaleAdd._254_ VGND VGND VPWR VPWR scaleAdd._265_ sky130_fd_sc_hd__and2_1
XTAP_TAPCELL_ROW_10_230 VGND VPWR sky130_fd_sc_hd__tapvpwrvgnd_1
Xaccumulator._1490_ net79 VGND VGND VPWR VPWR accumulator._0587_ sky130_fd_sc_hd__inv_2
Xaccumulator._2042_ accumulator._1115_ accumulator._1138_ VGND VGND VPWR VPWR accumulator._1139_
+ sky130_fd_sc_hd__or2_4
Xaccumulator._2111_ accumulator._0044_ VGND VGND VPWR VPWR accumulator._0002_ sky130_fd_sc_hd__clkbuf_1
XFILLER_0_45_279 VGND VGND VPWR VPWR sky130_fd_sc_hd__fill_1
XTAP_TAPCELL_ROW_33_399 VGND VPWR sky130_fd_sc_hd__tapvpwrvgnd_1
XFILLER_0_5_321 VPWR VGND VPWR VGND sky130_ef_sc_hd__decap_12
Xaccumulator._1826_ accumulator._0922_ VGND VGND VPWR VPWR accumulator._0923_ sky130_fd_sc_hd__buf_2
Xaccumulator._1757_ accumulator._0852_ accumulator._0709_ accumulator._0853_ VGND
+ VGND VPWR VPWR accumulator._0854_ sky130_fd_sc_hd__or3b_2
XFILLER_0_13_176 VGND VGND VPWR VPWR sky130_fd_sc_hd__fill_1
XFILLER_0_67_81 VPWR VGND VPWR VGND sky130_ef_sc_hd__decap_12
Xaccumulator._1688_ accumulator._0764_ accumulator._0765_ VGND VGND VPWR VPWR accumulator._0785_
+ sky130_fd_sc_hd__nand2_1
Xaccumulator._2309_ accumulator._0235_ accumulator._0236_ accumulator._0241_ accumulator._0242_
+ VGND VGND VPWR VPWR accumulator._0022_ sky130_fd_sc_hd__o211a_1
XFILLER_0_36_213 VGND VGND VPWR VPWR sky130_fd_sc_hd__decap_4
XFILLER_0_36_202 VGND VGND VPWR VPWR sky130_fd_sc_hd__decap_6
XTAP_TAPCELL_ROW_24_333 VGND VPWR sky130_fd_sc_hd__tapvpwrvgnd_1
XFILLER_0_36_246 VGND VGND VPWR VPWR sky130_fd_sc_hd__decap_6
XFILLER_0_24_408 VGND VGND VPWR VPWR sky130_fd_sc_hd__fill_1
XFILLER_0_63_39 VPWR VGND VPWR VGND sky130_ef_sc_hd__decap_12
XFILLER_0_67_393 VPWR VGND VPWR VGND sky130_ef_sc_hd__decap_12
XFILLER_0_42_205 VGND VGND VPWR VPWR sky130_fd_sc_hd__decap_8
XFILLER_0_27_246 VPWR VGND VPWR VGND sky130_ef_sc_hd__decap_12
XFILLER_0_27_202 VGND VGND VPWR VPWR sky130_fd_sc_hd__fill_2
XFILLER_0_6_129 VGND VGND VPWR VPWR sky130_fd_sc_hd__decap_8
XFILLER_0_12_65 VGND VGND VPWR VPWR sky130_fd_sc_hd__decap_6
Xaccumulator._1611_ accumulator._0523_ accumulator._0558_ accumulator._0610_ VGND
+ VGND VPWR VPWR accumulator._0708_ sky130_fd_sc_hd__or3b_1
XFILLER_0_42_249 VGND VGND VPWR VPWR sky130_fd_sc_hd__decap_3
XFILLER_0_2_357 VGND VGND VPWR VPWR sky130_fd_sc_hd__decap_6
XFILLER_0_2_302 VGND VGND VPWR VPWR sky130_fd_sc_hd__decap_6
XscaleAdd._676_ scaleAdd._247_ scaleAdd._249_ VGND VGND VPWR VPWR accumulator.io_inMant\[13\]
+ sky130_fd_sc_hd__xor2_2
Xaccumulator._1473_ accumulator.io_accOut\[18\] accumulator._0569_ net78 VGND VGND
+ VPWR VPWR accumulator._0570_ sky130_fd_sc_hd__mux2_1
Xaccumulator._1542_ accumulator._0637_ accumulator._0638_ VGND VGND VPWR VPWR accumulator._0639_
+ sky130_fd_sc_hd__nand2_1
XTAP_TAPCELL_ROW_38_436 VGND VPWR sky130_fd_sc_hd__tapvpwrvgnd_1
XFILLER_0_37_73 VGND VGND VPWR VPWR sky130_fd_sc_hd__decap_6
XFILLER_0_37_51 VGND VGND VPWR VPWR sky130_fd_sc_hd__decap_4
Xaccumulator._2025_ accumulator._0913_ accumulator._1121_ VGND VGND VPWR VPWR accumulator._1122_
+ sky130_fd_sc_hd__xor2_2
XFILLER_0_33_249 VPWR VGND VPWR VGND sky130_ef_sc_hd__decap_12
Xaccumulator._1809_ accumulator._0904_ accumulator._0905_ VGND VGND VPWR VPWR accumulator._0906_
+ sky130_fd_sc_hd__and2b_1
XFILLER_0_41_293 VPWR VGND VPWR VGND sky130_ef_sc_hd__decap_12
XFILLER_0_64_363 VGND VGND VPWR VPWR sky130_fd_sc_hd__fill_1
XPHY_EDGE_ROW_30_Left_101 VGND VGND VPWR VPWR sky130_fd_sc_hd__decap_3
Xinput18 io_inScaleB[7] VGND VGND VPWR VPWR net18 sky130_fd_sc_hd__buf_1
XFILLER_0_32_282 VGND VGND VPWR VPWR sky130_fd_sc_hd__decap_3
XscaleAdd._392_ scaleAdd._307_ scaleAdd._308_ scaleAdd._332_ VGND VGND VPWR VPWR scaleAdd._334_
+ sky130_fd_sc_hd__and3_1
XscaleAdd._530_ scaleAdd._079_ scaleAdd._108_ VGND VGND VPWR VPWR scaleAdd._109_ sky130_fd_sc_hd__xor2_1
XscaleAdd._461_ scaleAdd._041_ VGND VGND VPWR VPWR accumulator.io_inMant\[6\] sky130_fd_sc_hd__buf_1
XFILLER_0_59_113 VPWR VGND VPWR VGND sky130_ef_sc_hd__decap_12
XTAP_TAPCELL_ROW_35_417 VGND VPWR sky130_fd_sc_hd__tapvpwrvgnd_1
XFILLER_0_7_405 VPWR VGND VPWR VGND sky130_ef_sc_hd__decap_12
XFILLER_0_70_377 VPWR VGND VPWR VGND sky130_ef_sc_hd__decap_12
XFILLER_0_70_333 VGND VGND VPWR VPWR sky130_fd_sc_hd__decap_3
XFILLER_0_55_374 VGND VGND VPWR VPWR sky130_fd_sc_hd__decap_4
XTAP_TAPCELL_ROW_43_472 VGND VPWR sky130_fd_sc_hd__tapvpwrvgnd_1
XFILLER_0_23_97 VPWR VGND VPWR VGND sky130_ef_sc_hd__decap_12
XscaleAdd._728_ scaleAdd._293_ scaleAdd._294_ VGND VGND VPWR VPWR accumulator.io_inExp\[1\]
+ sky130_fd_sc_hd__nor2_1
XFILLER_0_23_260 VGND VGND VPWR VPWR sky130_fd_sc_hd__fill_2
XscaleAdd._659_ scaleAdd._318_ scaleAdd._216_ VGND VGND VPWR VPWR scaleAdd._233_ sky130_fd_sc_hd__nand2_1
Xaccumulator._1525_ accumulator._0536_ accumulator._0486_ accumulator._0543_ VGND
+ VGND VPWR VPWR accumulator._0622_ sky130_fd_sc_hd__a21o_1
Xaccumulator._1456_ accumulator._0410_ accumulator._0522_ VGND VGND VPWR VPWR accumulator._0553_
+ sky130_fd_sc_hd__xor2_4
Xaccumulator._1387_ accumulator._0434_ accumulator._0435_ accumulator._0479_ accumulator._0483_
+ VGND VGND VPWR VPWR accumulator._0484_ sky130_fd_sc_hd__a31o_1
XFILLER_0_3_74 VGND VGND VPWR VPWR sky130_fd_sc_hd__fill_1
Xaccumulator._2008_ accumulator._0893_ accumulator._1104_ VGND VGND VPWR VPWR accumulator._1105_
+ sky130_fd_sc_hd__xnor2_2
XFILLER_0_65_127 VGND VGND VPWR VPWR sky130_fd_sc_hd__decap_3
XFILLER_0_46_385 VPWR VGND VPWR VGND sky130_ef_sc_hd__decap_12
XTAP_TAPCELL_ROW_6_197 VGND VPWR sky130_fd_sc_hd__tapvpwrvgnd_1
XFILLER_0_69_27 VPWR VGND VPWR VGND sky130_ef_sc_hd__decap_12
XFILLER_0_60_29 VPWR VGND VPWR VGND sky130_ef_sc_hd__decap_12
XFILLER_0_52_300 VGND VGND VPWR VPWR sky130_fd_sc_hd__decap_8
XTAP_TAPCELL_ROW_40_453 VGND VPWR sky130_fd_sc_hd__tapvpwrvgnd_1
XFILLER_0_37_352 VGND VGND VPWR VPWR sky130_fd_sc_hd__decap_8
XFILLER_0_4_419 VGND VGND VPWR VPWR sky130_fd_sc_hd__fill_1
XscaleAdd._513_ net13 scaleAdd._088_ VGND VGND VPWR VPWR scaleAdd._092_ sky130_fd_sc_hd__or2_1
XscaleAdd._444_ scaleAdd._024_ scaleAdd._001_ VGND VGND VPWR VPWR scaleAdd._025_ sky130_fd_sc_hd__xnor2_2
XscaleAdd._375_ net12 VGND VGND VPWR VPWR scaleAdd._319_ sky130_fd_sc_hd__buf_2
Xaccumulator._2290_ accumulator._0218_ accumulator._0223_ accumulator._0079_ VGND
+ VGND VPWR VPWR accumulator._0224_ sky130_fd_sc_hd__a21o_1
X_15_ accumulator.io_accOut\[15\] VGND VGND VPWR VPWR net28 sky130_fd_sc_hd__buf_1
Xaccumulator._1310_ net21 accumulator.state\[0\] VGND VGND VPWR VPWR accumulator._0408_
+ sky130_fd_sc_hd__and2b_1
Xaccumulator._1241_ accumulator._0225_ accumulator._0293_ accumulator._0338_ accumulator._0273_
+ accumulator._0339_ VGND VGND VPWR VPWR accumulator._0340_ sky130_fd_sc_hd__a311o_1
XFILLER_0_18_42 VGND VGND VPWR VPWR sky130_fd_sc_hd__decap_4
XFILLER_0_34_85 VGND VGND VPWR VPWR sky130_fd_sc_hd__fill_2
XFILLER_0_34_41 VPWR VGND VPWR VGND sky130_ef_sc_hd__decap_12
XFILLER_0_28_363 VGND VGND VPWR VPWR sky130_fd_sc_hd__fill_1
XFILLER_0_7_202 VGND VGND VPWR VPWR sky130_fd_sc_hd__fill_1
XFILLER_0_70_141 VPWR VGND VPWR VGND sky130_ef_sc_hd__decap_12
XFILLER_0_7_279 VGND VGND VPWR VPWR sky130_fd_sc_hd__fill_1
XTAP_TAPCELL_ROW_54_556 VGND VPWR sky130_fd_sc_hd__tapvpwrvgnd_1
Xclone3 accumulator._0401_ VGND VGND VPWR VPWR net60 sky130_fd_sc_hd__buf_2
Xaccumulator._1439_ accumulator._0432_ VGND VGND VPWR VPWR accumulator._0536_ sky130_fd_sc_hd__buf_2
Xaccumulator._1508_ accumulator.io_accOut\[31\] accumulator.io_inSign VGND VGND VPWR
+ VPWR accumulator._0605_ sky130_fd_sc_hd__xnor2_2
XTAP_TAPCELL_ROW_3_178 VGND VPWR sky130_fd_sc_hd__tapvpwrvgnd_1
XFILLER_0_19_341 VGND VGND VPWR VPWR sky130_fd_sc_hd__fill_1
XFILLER_0_44_108 VPWR VGND VPWR VGND sky130_ef_sc_hd__decap_12
Xaccumulator._1790_ accumulator._0885_ accumulator._0886_ VGND VGND VPWR VPWR accumulator._0887_
+ sky130_fd_sc_hd__xnor2_4
XFILLER_0_52_185 VGND VGND VPWR VPWR sky130_fd_sc_hd__decap_6
XFILLER_0_37_193 VPWR VGND VPWR VGND sky130_ef_sc_hd__decap_12
XFILLER_0_25_355 VGND VGND VPWR VPWR sky130_fd_sc_hd__fill_2
XFILLER_0_25_322 VPWR VGND VPWR VGND sky130_ef_sc_hd__decap_12
XFILLER_0_25_311 VGND VGND VPWR VPWR sky130_fd_sc_hd__fill_2
XFILLER_0_4_249 VGND VGND VPWR VPWR sky130_fd_sc_hd__decap_3
XFILLER_0_20_10 VGND VGND VPWR VPWR sky130_fd_sc_hd__fill_1
Xaccumulator._2411_ clknet_2_2__leaf_clock accumulator._0012_ VGND VGND VPWR VPWR
+ accumulator.io_accOut\[10\] sky130_fd_sc_hd__dfxtp_1
XFILLER_0_29_30 VPWR VGND VPWR VGND sky130_ef_sc_hd__decap_12
XscaleAdd._427_ scaleAdd._007_ VGND VGND VPWR VPWR scaleAdd._008_ sky130_fd_sc_hd__inv_2
XTAP_TAPCELL_ROW_68_659 VGND VPWR sky130_fd_sc_hd__tapvpwrvgnd_1
Xaccumulator._2273_ accumulator._0200_ accumulator._0201_ accumulator._0207_ accumulator._0089_
+ VGND VGND VPWR VPWR accumulator._0208_ sky130_fd_sc_hd__o31a_1
XFILLER_0_45_51 VGND VGND VPWR VPWR sky130_fd_sc_hd__decap_4
Xaccumulator._2342_ accumulator._0270_ accumulator._0274_ VGND VGND VPWR VPWR accumulator._0275_
+ sky130_fd_sc_hd__xnor2_1
XFILLER_0_24_6 VGND VGND VPWR VPWR sky130_fd_sc_hd__decap_4
Xaccumulator._1224_ accumulator._0254_ VGND VGND VPWR VPWR accumulator._0263_ sky130_fd_sc_hd__buf_6
XTAP_TAPCELL_ROW_0_148 VGND VPWR sky130_fd_sc_hd__tapvpwrvgnd_1
XTAP_TAPCELL_ROW_51_537 VGND VPWR sky130_fd_sc_hd__tapvpwrvgnd_1
XFILLER_0_43_130 VGND VGND VPWR VPWR sky130_fd_sc_hd__decap_8
XFILLER_0_28_160 VGND VGND VPWR VPWR sky130_fd_sc_hd__decap_8
XFILLER_0_0_53 VGND VGND VPWR VPWR sky130_fd_sc_hd__decap_3
XFILLER_0_0_97 VPWR VGND VPWR VGND sky130_ef_sc_hd__decap_12
XFILLER_0_9_40 VGND VGND VPWR VPWR sky130_fd_sc_hd__fill_2
Xaccumulator._1988_ accumulator._1066_ accumulator._1084_ VGND VGND VPWR VPWR accumulator._1085_
+ sky130_fd_sc_hd__xnor2_2
XFILLER_0_3_271 VGND VGND VPWR VPWR sky130_fd_sc_hd__decap_8
XTAP_TAPCELL_ROW_8_215 VGND VPWR sky130_fd_sc_hd__tapvpwrvgnd_1
XFILLER_0_9_73 VPWR VGND VPWR VGND sky130_ef_sc_hd__decap_12
XFILLER_0_9_95 VGND VGND VPWR VPWR sky130_fd_sc_hd__decap_8
XFILLER_0_16_388 VPWR VGND VPWR VGND sky130_ef_sc_hd__decap_12
XFILLER_0_66_277 VGND VGND VPWR VPWR sky130_fd_sc_hd__decap_4
XFILLER_0_66_200 VPWR VGND VPWR VGND sky130_ef_sc_hd__decap_12
XFILLER_0_66_299 VGND VGND VPWR VPWR sky130_fd_sc_hd__decap_8
XFILLER_0_19_182 VPWR VGND VPWR VGND sky130_ef_sc_hd__decap_12
XPHY_EDGE_ROW_13_Right_13 VGND VGND VPWR VPWR sky130_fd_sc_hd__decap_3
XFILLER_0_15_43 VPWR VGND VPWR VGND sky130_ef_sc_hd__decap_12
XPHY_EDGE_ROW_22_Right_22 VGND VGND VPWR VPWR sky130_fd_sc_hd__decap_3
XTAP_TAPCELL_ROW_13_250 VGND VPWR sky130_fd_sc_hd__tapvpwrvgnd_1
XPHY_EDGE_ROW_68_Left_139 VGND VGND VPWR VPWR sky130_fd_sc_hd__decap_3
Xaccumulator._1773_ accumulator._0867_ accumulator._0868_ VGND VGND VPWR VPWR accumulator._0870_
+ sky130_fd_sc_hd__and2_1
Xaccumulator._1911_ accumulator._1002_ accumulator._1007_ VGND VGND VPWR VPWR accumulator._1008_
+ sky130_fd_sc_hd__xor2_2
Xaccumulator._1842_ accumulator._0936_ accumulator._0794_ accumulator._0930_ accumulator._0937_
+ accumulator._0938_ VGND VGND VPWR VPWR accumulator._0939_ sky130_fd_sc_hd__a311o_1
XFILLER_0_40_166 VGND VGND VPWR VPWR sky130_fd_sc_hd__decap_6
XFILLER_0_40_122 VGND VGND VPWR VPWR sky130_fd_sc_hd__decap_3
XFILLER_0_21_391 VGND VGND VPWR VPWR sky130_fd_sc_hd__fill_1
XPHY_EDGE_ROW_31_Right_31 VGND VGND VPWR VPWR sky130_fd_sc_hd__decap_3
XFILLER_0_22_3 VGND VGND VPWR VPWR sky130_fd_sc_hd__fill_2
Xaccumulator._2187_ accumulator._1010_ accumulator._1008_ accumulator._0051_ VGND
+ VGND VPWR VPWR accumulator._0122_ sky130_fd_sc_hd__mux2_1
XFILLER_0_48_244 VGND VGND VPWR VPWR sky130_fd_sc_hd__decap_8
Xaccumulator._2256_ accumulator._0109_ accumulator._0190_ accumulator._1142_ VGND
+ VGND VPWR VPWR accumulator._0191_ sky130_fd_sc_hd__mux2_1
Xaccumulator._2325_ accumulator._0411_ VGND VGND VPWR VPWR accumulator._0258_ sky130_fd_sc_hd__inv_2
Xaccumulator._1207_ accumulator._0055_ accumulator._0085_ VGND VGND VPWR VPWR accumulator._0095_
+ sky130_fd_sc_hd__or2_4
XFILLER_0_63_214 VGND VGND VPWR VPWR sky130_fd_sc_hd__decap_3
XPHY_EDGE_ROW_40_Right_40 VGND VGND VPWR VPWR sky130_fd_sc_hd__decap_3
XFILLER_0_31_122 VGND VGND VPWR VPWR sky130_fd_sc_hd__fill_2
XFILLER_0_8_363 VGND VGND VPWR VPWR sky130_fd_sc_hd__fill_1
XFILLER_0_31_166 VGND VGND VPWR VPWR sky130_fd_sc_hd__fill_2
XTAP_TAPCELL_ROW_70_687 VGND VPWR sky130_fd_sc_hd__tapvpwrvgnd_1
XTAP_TAPCELL_ROW_70_676 VGND VPWR sky130_fd_sc_hd__tapvpwrvgnd_1
XTAP_TAPCELL_ROW_27_353 VGND VPWR sky130_fd_sc_hd__tapvpwrvgnd_1
XTAP_TAPCELL_ROW_10_231 VGND VPWR sky130_fd_sc_hd__tapvpwrvgnd_1
XscaleAdd._692_ scaleAdd._264_ VGND VGND VPWR VPWR accumulator.io_inMant\[14\] sky130_fd_sc_hd__clkbuf_2
Xaccumulator._2041_ accumulator._1133_ accumulator._1135_ accumulator._1137_ VGND
+ VGND VPWR VPWR accumulator._1138_ sky130_fd_sc_hd__or3_1
XTAP_TAPCELL_ROW_61_610 VGND VPWR sky130_fd_sc_hd__tapvpwrvgnd_1
XFILLER_0_42_41 VPWR VGND VPWR VGND sky130_ef_sc_hd__decap_12
Xaccumulator._2110_ accumulator._0400_ accumulator._0043_ VGND VGND VPWR VPWR accumulator._0044_
+ sky130_fd_sc_hd__and2_1
XFILLER_0_60_228 VGND VGND VPWR VPWR sky130_fd_sc_hd__decap_3
XFILLER_0_45_225 VPWR VGND VPWR VGND sky130_ef_sc_hd__decap_12
XFILLER_0_45_214 VGND VGND VPWR VPWR sky130_fd_sc_hd__decap_8
XFILLER_0_5_333 VGND VGND VPWR VPWR sky130_fd_sc_hd__decap_3
XFILLER_0_13_111 VGND VGND VPWR VPWR sky130_fd_sc_hd__fill_1
XFILLER_0_67_93 VGND VGND VPWR VPWR sky130_fd_sc_hd__fill_1
Xaccumulator._1825_ accumulator._0921_ VGND VGND VPWR VPWR accumulator._0922_ sky130_fd_sc_hd__clkbuf_4
Xaccumulator._1756_ accumulator.io_accOut\[13\] accumulator._0503_ accumulator._0404_
+ VGND VGND VPWR VPWR accumulator._0853_ sky130_fd_sc_hd__mux2_1
XFILLER_0_6_41 VGND VGND VPWR VPWR sky130_fd_sc_hd__decap_6
XFILLER_0_6_74 VGND VGND VPWR VPWR sky130_fd_sc_hd__decap_8
XFILLER_0_6_85 VPWR VGND VPWR VGND sky130_ef_sc_hd__decap_12
XFILLER_0_68_306 VGND VGND VPWR VPWR sky130_fd_sc_hd__fill_2
Xaccumulator._1687_ accumulator._0777_ accumulator._0679_ accumulator._0729_ accumulator._0781_
+ accumulator._0783_ VGND VGND VPWR VPWR accumulator._0784_ sky130_fd_sc_hd__o311a_1
Xaccumulator._2308_ accumulator.io_accOut\[20\] accumulator._0167_ accumulator._0399_
+ VGND VGND VPWR VPWR accumulator._0242_ sky130_fd_sc_hd__o21a_1
Xrebuffer30 net88 VGND VGND VPWR VPWR net87 sky130_fd_sc_hd__dlygate4sd1_1
Xaccumulator._2239_ accumulator._0171_ accumulator._0173_ accumulator._1149_ VGND
+ VGND VPWR VPWR accumulator._0174_ sky130_fd_sc_hd__mux2_4
XTAP_TAPCELL_ROW_24_334 VGND VPWR sky130_fd_sc_hd__tapvpwrvgnd_1
XFILLER_0_44_280 VPWR VGND VPWR VGND sky130_ef_sc_hd__decap_12
XFILLER_0_67_361 VPWR VGND VPWR VGND sky130_ef_sc_hd__decap_12
XscaleAdd._744_ operator.io_outSign VGND VGND VPWR VPWR accumulator.io_inSign sky130_fd_sc_hd__buf_2
XFILLER_0_27_258 VPWR VGND VPWR VGND sky130_ef_sc_hd__decap_12
XFILLER_0_27_225 VGND VGND VPWR VPWR sky130_fd_sc_hd__decap_3
XFILLER_0_6_119 VGND VGND VPWR VPWR sky130_fd_sc_hd__fill_1
XscaleAdd._675_ scaleAdd._248_ net77 VGND VGND VPWR VPWR scaleAdd._249_ sky130_fd_sc_hd__nand2_1
XFILLER_0_12_11 VGND VGND VPWR VPWR sky130_fd_sc_hd__fill_2
XFILLER_0_12_22 VGND VGND VPWR VPWR sky130_fd_sc_hd__decap_6
XFILLER_0_15_409 VGND VGND VPWR VPWR sky130_fd_sc_hd__decap_8
Xaccumulator._1610_ accumulator._0623_ accumulator._0626_ accumulator._0428_ VGND
+ VGND VPWR VPWR accumulator._0707_ sky130_fd_sc_hd__a21oi_1
XTAP_TAPCELL_ROW_38_437 VGND VPWR sky130_fd_sc_hd__tapvpwrvgnd_1
Xaccumulator._1541_ accumulator._0478_ accumulator._0547_ accumulator._0469_ VGND
+ VGND VPWR VPWR accumulator._0638_ sky130_fd_sc_hd__a21o_1
Xaccumulator._1472_ accumulator._0453_ accumulator._0516_ accumulator._0568_ accumulator._0435_
+ VGND VGND VPWR VPWR accumulator._0569_ sky130_fd_sc_hd__o22a_1
XFILLER_0_65_309 VPWR VGND VPWR VGND sky130_ef_sc_hd__decap_12
Xaccumulator._2024_ accumulator._0919_ accumulator._0925_ accumulator._1119_ accumulator._1120_
+ VGND VGND VPWR VPWR accumulator._1121_ sky130_fd_sc_hd__a31o_1
XFILLER_0_53_51 VGND VGND VPWR VPWR sky130_fd_sc_hd__decap_4
XFILLER_0_18_258 VPWR VGND VPWR VGND sky130_ef_sc_hd__decap_12
XFILLER_0_41_261 VGND VGND VPWR VPWR sky130_fd_sc_hd__decap_8
XFILLER_0_5_141 VPWR VGND VPWR VGND sky130_ef_sc_hd__decap_12
Xaccumulator._1739_ accumulator._0833_ accumulator._0834_ VGND VGND VPWR VPWR accumulator._0836_
+ sky130_fd_sc_hd__nor2_1
Xaccumulator._1808_ accumulator.io_accOut\[22\] accumulator._0595_ accumulator._0405_
+ VGND VGND VPWR VPWR accumulator._0905_ sky130_fd_sc_hd__mux2_1
XFILLER_0_1_391 VGND VGND VPWR VPWR sky130_fd_sc_hd__fill_1
XFILLER_0_68_158 VGND VGND VPWR VPWR sky130_fd_sc_hd__decap_6
XFILLER_0_56_309 VPWR VGND VPWR VGND sky130_ef_sc_hd__decap_12
XFILLER_0_64_320 VGND VGND VPWR VPWR sky130_fd_sc_hd__decap_6
Xinput19 io_resetAcc VGND VGND VPWR VPWR net19 sky130_fd_sc_hd__clkbuf_1
XFILLER_0_24_239 VPWR VGND VPWR VGND sky130_ef_sc_hd__decap_12
XFILLER_0_24_206 VGND VGND VPWR VPWR sky130_fd_sc_hd__decap_6
XFILLER_0_17_291 VPWR VGND VPWR VGND sky130_ef_sc_hd__decap_12
XFILLER_0_58_29 VPWR VGND VPWR VGND sky130_ef_sc_hd__decap_12
XscaleAdd._391_ net9 net14 VGND VGND VPWR VPWR scaleAdd._333_ sky130_fd_sc_hd__nand2_1
XscaleAdd._460_ scaleAdd._039_ scaleAdd._040_ VGND VGND VPWR VPWR scaleAdd._041_ sky130_fd_sc_hd__and2_1
XFILLER_0_20_401 VPWR VGND VPWR VGND sky130_ef_sc_hd__decap_12
X_31_ accumulator.io_accOut\[31\] VGND VGND VPWR VPWR net46 sky130_fd_sc_hd__buf_1
XFILLER_0_59_125 VPWR VGND VPWR VGND sky130_ef_sc_hd__decap_12
XTAP_TAPCELL_ROW_43_473 VGND VPWR sky130_fd_sc_hd__tapvpwrvgnd_1
XTAP_TAPCELL_ROW_35_418 VGND VPWR sky130_fd_sc_hd__tapvpwrvgnd_1
XFILLER_0_23_54 VGND VGND VPWR VPWR sky130_fd_sc_hd__fill_2
XFILLER_0_7_417 VGND VGND VPWR VPWR sky130_fd_sc_hd__decap_4
XFILLER_0_70_389 VGND VGND VPWR VPWR sky130_fd_sc_hd__decap_3
XFILLER_0_23_272 VGND VGND VPWR VPWR sky130_fd_sc_hd__decap_8
XscaleAdd._727_ scaleAdd._283_ scaleAdd._292_ VGND VGND VPWR VPWR scaleAdd._294_ sky130_fd_sc_hd__and2_1
XscaleAdd._658_ scaleAdd._210_ scaleAdd._218_ VGND VGND VPWR VPWR scaleAdd._232_ sky130_fd_sc_hd__nor2_1
Xaccumulator._1524_ accumulator._0536_ accumulator._0467_ accumulator._0539_ VGND
+ VGND VPWR VPWR accumulator._0621_ sky130_fd_sc_hd__a21o_1
XscaleAdd._589_ scaleAdd._165_ VGND VGND VPWR VPWR scaleAdd._166_ sky130_fd_sc_hd__inv_2
XFILLER_0_64_83 VGND VGND VPWR VPWR sky130_fd_sc_hd__fill_1
XFILLER_0_64_61 VGND VGND VPWR VPWR sky130_fd_sc_hd__fill_1
Xaccumulator._1455_ accumulator._0548_ accumulator._0551_ accumulator._0498_ VGND
+ VGND VPWR VPWR accumulator._0552_ sky130_fd_sc_hd__a21o_1
Xaccumulator._1386_ accumulator._0434_ accumulator._0480_ accumulator._0482_ accumulator._0453_
+ VGND VGND VPWR VPWR accumulator._0483_ sky130_fd_sc_hd__o211a_1
Xaccumulator._2007_ accumulator._0919_ accumulator._0900_ accumulator._1102_ accumulator._0887_
+ accumulator._1103_ VGND VGND VPWR VPWR accumulator._1104_ sky130_fd_sc_hd__o221a_1
XFILLER_0_61_301 VGND VGND VPWR VPWR sky130_fd_sc_hd__fill_2
XFILLER_0_46_397 VPWR VGND VPWR VGND sky130_ef_sc_hd__decap_12
XTAP_TAPCELL_ROW_6_198 VGND VPWR sky130_fd_sc_hd__tapvpwrvgnd_1
XPHY_EDGE_ROW_69_Right_69 VGND VGND VPWR VPWR sky130_fd_sc_hd__decap_3
XFILLER_0_69_39 VPWR VGND VPWR VGND sky130_ef_sc_hd__decap_12
XFILLER_0_52_345 VPWR VGND VPWR VGND sky130_ef_sc_hd__decap_12
XTAP_TAPCELL_ROW_40_454 VGND VPWR sky130_fd_sc_hd__tapvpwrvgnd_1
XscaleAdd._512_ net13 scaleAdd._089_ VGND VGND VPWR VPWR scaleAdd._091_ sky130_fd_sc_hd__nand2_1
XscaleAdd._443_ scaleAdd._023_ scaleAdd._020_ VGND VGND VPWR VPWR scaleAdd._024_ sky130_fd_sc_hd__xnor2_2
XscaleAdd._374_ scaleAdd._311_ scaleAdd._315_ scaleAdd._317_ scaleAdd._318_ VGND VGND
+ VPWR VPWR accumulator.io_inMant\[3\] sky130_fd_sc_hd__a22o_1
XFILLER_0_20_253 VGND VGND VPWR VPWR sky130_fd_sc_hd__decap_3
XTAP_TAPCELL_ROW_48_510 VGND VPWR sky130_fd_sc_hd__tapvpwrvgnd_1
XFILLER_0_34_53 VPWR VGND VPWR VGND sky130_ef_sc_hd__decap_12
X_14_ accumulator.io_accOut\[14\] VGND VGND VPWR VPWR net27 sky130_fd_sc_hd__buf_1
Xaccumulator._1240_ accumulator.io_inExp\[3\] accumulator._0095_ VGND VGND VPWR VPWR
+ accumulator._0339_ sky130_fd_sc_hd__and2_1
XPHY_EDGE_ROW_25_Left_96 VGND VGND VPWR VPWR sky130_fd_sc_hd__decap_3
XFILLER_0_50_85 VPWR VGND VPWR VGND sky130_ef_sc_hd__decap_12
XFILLER_0_50_41 VPWR VGND VPWR VGND sky130_ef_sc_hd__decap_12
XFILLER_0_47_128 VGND VGND VPWR VPWR sky130_fd_sc_hd__decap_8
XFILLER_0_7_225 VPWR VGND VPWR VGND sky130_ef_sc_hd__decap_12
XFILLER_0_70_197 VPWR VGND VPWR VGND sky130_ef_sc_hd__decap_12
XFILLER_0_70_153 VPWR VGND VPWR VGND sky130_ef_sc_hd__decap_12
XFILLER_0_43_389 VGND VGND VPWR VPWR sky130_fd_sc_hd__decap_3
XFILLER_0_43_345 VPWR VGND VPWR VGND sky130_ef_sc_hd__decap_12
XFILLER_0_52_3 VPWR VGND VPWR VGND sky130_ef_sc_hd__decap_12
Xaccumulator._1507_ accumulator._0602_ accumulator._0603_ VGND VGND VPWR VPWR accumulator._0604_
+ sky130_fd_sc_hd__xnor2_2
XTAP_TAPCELL_ROW_54_557 VGND VPWR sky130_fd_sc_hd__tapvpwrvgnd_1
Xaccumulator._1438_ accumulator._0526_ accumulator._0529_ accumulator._0534_ VGND
+ VGND VPWR VPWR accumulator._0535_ sky130_fd_sc_hd__o21ai_2
Xaccumulator._1369_ accumulator._0453_ accumulator._0458_ accumulator._0465_ accumulator._0435_
+ VGND VGND VPWR VPWR accumulator._0466_ sky130_fd_sc_hd__o22a_1
XFILLER_0_46_172 VGND VGND VPWR VPWR sky130_fd_sc_hd__fill_1
XFILLER_0_19_375 VGND VGND VPWR VPWR sky130_fd_sc_hd__fill_1
XFILLER_0_69_264 VGND VGND VPWR VPWR sky130_fd_sc_hd__fill_1
XFILLER_0_25_334 VGND VGND VPWR VPWR sky130_fd_sc_hd__fill_2
Xaccumulator._2410_ clknet_2_3__leaf_clock accumulator._0011_ VGND VGND VPWR VPWR
+ accumulator.io_accOut\[9\] sky130_fd_sc_hd__dfxtp_1
XFILLER_0_29_42 VPWR VGND VPWR VGND sky130_ef_sc_hd__decap_12
XscaleAdd._426_ scaleAdd._004_ scaleAdd._006_ VGND VGND VPWR VPWR scaleAdd._007_ sky130_fd_sc_hd__xnor2_1
Xaccumulator._2341_ accumulator._1147_ accumulator._0272_ VGND VGND VPWR VPWR accumulator._0274_
+ sky130_fd_sc_hd__xor2_1
XFILLER_0_61_51 VGND VGND VPWR VPWR sky130_fd_sc_hd__decap_4
Xaccumulator._2272_ accumulator._0086_ accumulator._0206_ VGND VGND VPWR VPWR accumulator._0207_
+ sky130_fd_sc_hd__nor2_1
Xaccumulator._1223_ accumulator._0065_ accumulator._0244_ VGND VGND VPWR VPWR accumulator._0254_
+ sky130_fd_sc_hd__or2_1
XTAP_TAPCELL_ROW_0_149 VGND VPWR sky130_fd_sc_hd__tapvpwrvgnd_1
XFILLER_0_61_84 VPWR VGND VPWR VGND sky130_ef_sc_hd__decap_12
XTAP_TAPCELL_ROW_51_538 VGND VPWR sky130_fd_sc_hd__tapvpwrvgnd_1
XFILLER_0_43_153 VGND VGND VPWR VPWR sky130_fd_sc_hd__fill_2
XFILLER_0_9_85 VGND VGND VPWR VPWR sky130_fd_sc_hd__decap_4
XTAP_TAPCELL_ROW_16_270 VGND VPWR sky130_fd_sc_hd__tapvpwrvgnd_1
Xaccumulator._1987_ accumulator._1054_ accumulator._1063_ VGND VGND VPWR VPWR accumulator._1084_
+ sky130_fd_sc_hd__nor2_1
XFILLER_0_31_337 VGND VGND VPWR VPWR sky130_fd_sc_hd__decap_8
XTAP_TAPCELL_ROW_8_216 VGND VPWR sky130_fd_sc_hd__tapvpwrvgnd_1
XFILLER_0_66_212 VPWR VGND VPWR VGND sky130_ef_sc_hd__decap_12
XFILLER_0_19_194 VPWR VGND VPWR VGND sky130_ef_sc_hd__decap_12
XFILLER_0_66_29 VPWR VGND VPWR VGND sky130_ef_sc_hd__decap_12
XFILLER_0_15_55 VGND VGND VPWR VPWR sky130_fd_sc_hd__fill_1
XFILLER_0_15_88 VGND VGND VPWR VPWR sky130_fd_sc_hd__fill_2
Xaccumulator._1910_ accumulator._1003_ accumulator._1006_ accumulator._0992_ VGND
+ VGND VPWR VPWR accumulator._1007_ sky130_fd_sc_hd__a21oi_2
XTAP_TAPCELL_ROW_13_251 VGND VPWR sky130_fd_sc_hd__tapvpwrvgnd_1
Xaccumulator._1772_ accumulator._0867_ accumulator._0868_ VGND VGND VPWR VPWR accumulator._0869_
+ sky130_fd_sc_hd__nor2_1
Xaccumulator._1841_ accumulator._0802_ accumulator._0803_ VGND VGND VPWR VPWR accumulator._0938_
+ sky130_fd_sc_hd__and2_1
XFILLER_0_0_253 VGND VGND VPWR VPWR sky130_fd_sc_hd__decap_4
XscaleAdd._409_ operator.io_outMant\[0\] scaleAdd._350_ VGND VGND VPWR VPWR scaleAdd._351_
+ sky130_fd_sc_hd__and2_1
Xaccumulator._2324_ accumulator._0250_ accumulator._0251_ accumulator._0257_ accumulator._0177_
+ VGND VGND VPWR VPWR accumulator._0024_ sky130_fd_sc_hd__o31a_1
XTAP_TAPCELL_ROW_64_630 VGND VPWR sky130_fd_sc_hd__tapvpwrvgnd_1
Xaccumulator._2186_ accumulator._0119_ accumulator._0120_ accumulator._0061_ VGND
+ VGND VPWR VPWR accumulator._0121_ sky130_fd_sc_hd__mux2_1
Xaccumulator._2255_ accumulator._0152_ accumulator._0189_ accumulator._0110_ VGND
+ VGND VPWR VPWR accumulator._0190_ sky130_fd_sc_hd__mux2_4
XFILLER_0_48_201 VGND VGND VPWR VPWR sky130_fd_sc_hd__fill_1
Xaccumulator._1206_ accumulator._0075_ accumulator._0065_ VGND VGND VPWR VPWR accumulator._0085_
+ sky130_fd_sc_hd__or2_4
XFILLER_0_31_178 VGND VGND VPWR VPWR sky130_fd_sc_hd__decap_4
XFILLER_0_31_101 VGND VGND VPWR VPWR sky130_fd_sc_hd__fill_2
XPHY_EDGE_ROW_12_Left_83 VGND VGND VPWR VPWR sky130_fd_sc_hd__decap_3
XFILLER_0_16_186 VGND VGND VPWR VPWR sky130_fd_sc_hd__fill_1
XFILLER_0_16_197 VGND VGND VPWR VPWR sky130_fd_sc_hd__decap_4
XTAP_TAPCELL_ROW_27_354 VGND VPWR sky130_fd_sc_hd__tapvpwrvgnd_1
XTAP_TAPCELL_ROW_70_688 VGND VPWR sky130_fd_sc_hd__tapvpwrvgnd_1
XTAP_TAPCELL_ROW_70_677 VGND VPWR sky130_fd_sc_hd__tapvpwrvgnd_1
XscaleAdd._691_ scaleAdd._261_ scaleAdd._263_ VGND VGND VPWR VPWR scaleAdd._264_ sky130_fd_sc_hd__and2_1
XFILLER_0_26_32 VGND VGND VPWR VPWR sky130_fd_sc_hd__decap_8
Xaccumulator._2040_ accumulator._1122_ accumulator._1136_ VGND VGND VPWR VPWR accumulator._1137_
+ sky130_fd_sc_hd__xnor2_2
XTAP_TAPCELL_ROW_61_611 VGND VPWR sky130_fd_sc_hd__tapvpwrvgnd_1
XFILLER_0_45_237 VGND VGND VPWR VPWR sky130_fd_sc_hd__fill_1
XFILLER_0_42_53 VPWR VGND VPWR VGND sky130_ef_sc_hd__decap_12
XFILLER_0_18_407 VPWR VGND VPWR VGND sky130_ef_sc_hd__decap_12
XFILLER_0_53_281 VPWR VGND VPWR VGND sky130_ef_sc_hd__decap_12
Xaccumulator._1755_ accumulator._0651_ VGND VGND VPWR VPWR accumulator._0852_ sky130_fd_sc_hd__clkbuf_2
Xaccumulator._1686_ accumulator._0782_ VGND VGND VPWR VPWR accumulator._0783_ sky130_fd_sc_hd__inv_2
Xaccumulator._1824_ accumulator.io_accOut\[31\] accumulator.io_inSign VGND VGND VPWR
+ VPWR accumulator._0921_ sky130_fd_sc_hd__xor2_4
XFILLER_0_6_97 VGND VGND VPWR VPWR sky130_fd_sc_hd__decap_3
Xaccumulator._2238_ accumulator._0151_ accumulator._0172_ accumulator._0035_ VGND
+ VGND VPWR VPWR accumulator._0173_ sky130_fd_sc_hd__mux2_1
Xaccumulator._2307_ accumulator._0080_ accumulator._0174_ accumulator._0240_ VGND
+ VGND VPWR VPWR accumulator._0241_ sky130_fd_sc_hd__a21bo_1
Xrebuffer31 net89 VGND VGND VPWR VPWR net88 sky130_fd_sc_hd__dlygate4sd1_1
Xrebuffer20 net76 VGND VGND VPWR VPWR net77 sky130_fd_sc_hd__dlymetal6s2s_1
Xaccumulator._2169_ accumulator._1132_ VGND VGND VPWR VPWR accumulator._0103_ sky130_fd_sc_hd__buf_2
XFILLER_0_51_207 VGND VGND VPWR VPWR sky130_fd_sc_hd__fill_1
XTAP_TAPCELL_ROW_32_390 VGND VPWR sky130_fd_sc_hd__tapvpwrvgnd_1
XTAP_TAPCELL_ROW_24_335 VGND VPWR sky130_fd_sc_hd__tapvpwrvgnd_1
XFILLER_0_8_161 VPWR VGND VPWR VGND sky130_ef_sc_hd__decap_12
XFILLER_0_4_3 VGND VGND VPWR VPWR sky130_fd_sc_hd__decap_8
XFILLER_0_67_373 VPWR VGND VPWR VGND sky130_ef_sc_hd__decap_12
XFILLER_0_50_251 VGND VGND VPWR VPWR sky130_fd_sc_hd__fill_1
XFILLER_0_35_281 VGND VGND VPWR VPWR sky130_fd_sc_hd__decap_8
XscaleAdd._743_ accumulator.io_inExp\[5\] VGND VGND VPWR VPWR accumulator.io_inExp\[4\]
+ sky130_fd_sc_hd__buf_1
XscaleAdd._674_ scaleAdd._223_ scaleAdd._225_ VGND VGND VPWR VPWR scaleAdd._248_ sky130_fd_sc_hd__or2_1
XFILLER_0_50_273 VGND VGND VPWR VPWR sky130_fd_sc_hd__fill_1
Xaccumulator._1540_ accumulator._0478_ accumulator._0542_ accumulator._0451_ VGND
+ VGND VPWR VPWR accumulator._0637_ sky130_fd_sc_hd__a21o_1
XTAP_TAPCELL_ROW_38_438 VGND VPWR sky130_fd_sc_hd__tapvpwrvgnd_1
Xaccumulator._1471_ accumulator._0492_ accumulator._0567_ accumulator._0434_ VGND
+ VGND VPWR VPWR accumulator._0568_ sky130_fd_sc_hd__mux2_1
Xaccumulator._2023_ accumulator._0923_ accumulator._0903_ VGND VGND VPWR VPWR accumulator._1120_
+ sky130_fd_sc_hd__and2_1
Xaccumulator._1807_ accumulator._0740_ accumulator._0852_ accumulator._0748_ VGND
+ VGND VPWR VPWR accumulator._0904_ sky130_fd_sc_hd__or3_1
XFILLER_0_5_153 VGND VGND VPWR VPWR sky130_fd_sc_hd__decap_6
Xaccumulator._1738_ accumulator._0833_ accumulator._0834_ VGND VGND VPWR VPWR accumulator._0835_
+ sky130_fd_sc_hd__and2_1
Xaccumulator._1669_ accumulator._0764_ accumulator._0765_ VGND VGND VPWR VPWR accumulator._0766_
+ sky130_fd_sc_hd__nor2_1
XFILLER_0_64_365 VGND VGND VPWR VPWR sky130_fd_sc_hd__decap_4
XFILLER_0_64_332 VGND VGND VPWR VPWR sky130_fd_sc_hd__decap_6
XFILLER_0_32_251 VGND VGND VPWR VPWR sky130_fd_sc_hd__fill_1
XscaleAdd._390_ net9 net13 VGND VGND VPWR VPWR scaleAdd._332_ sky130_fd_sc_hd__nand2_1
XFILLER_0_20_413 VGND VGND VPWR VPWR sky130_fd_sc_hd__decap_3
XFILLER_0_59_137 VGND VGND VPWR VPWR sky130_fd_sc_hd__fill_1
X_30_ accumulator.io_accOut\[30\] VGND VGND VPWR VPWR net45 sky130_fd_sc_hd__clkbuf_1
XFILLER_0_59_159 VGND VGND VPWR VPWR sky130_fd_sc_hd__decap_8
XTAP_TAPCELL_ROW_43_474 VGND VPWR sky130_fd_sc_hd__tapvpwrvgnd_1
XFILLER_0_23_11 VGND VGND VPWR VPWR sky130_fd_sc_hd__fill_2
XscaleAdd._726_ scaleAdd._283_ scaleAdd._292_ VGND VGND VPWR VPWR scaleAdd._293_ sky130_fd_sc_hd__nor2_1
XscaleAdd._588_ scaleAdd._163_ scaleAdd._164_ VGND VGND VPWR VPWR scaleAdd._165_ sky130_fd_sc_hd__and2_1
XFILLER_0_2_145 VPWR VGND VPWR VGND sky130_ef_sc_hd__decap_12
XscaleAdd._657_ scaleAdd._211_ scaleAdd._217_ VGND VGND VPWR VPWR scaleAdd._231_ sky130_fd_sc_hd__nor2_1
Xaccumulator._1523_ accumulator._0419_ accumulator._0556_ VGND VGND VPWR VPWR accumulator._0620_
+ sky130_fd_sc_hd__nand2_4
XFILLER_0_48_85 VPWR VGND VPWR VGND sky130_ef_sc_hd__decap_12
XFILLER_0_48_41 VPWR VGND VPWR VGND sky130_ef_sc_hd__decap_12
Xaccumulator._1454_ accumulator._0432_ accumulator._0550_ accumulator._0469_ VGND
+ VGND VPWR VPWR accumulator._0551_ sky130_fd_sc_hd__a21o_1
XFILLER_0_3_21 VGND VGND VPWR VPWR sky130_fd_sc_hd__decap_8
Xaccumulator._1385_ accumulator._0447_ accumulator._0481_ VGND VGND VPWR VPWR accumulator._0482_
+ sky130_fd_sc_hd__or2_1
XFILLER_0_3_98 VGND VGND VPWR VPWR sky130_fd_sc_hd__fill_1
XFILLER_0_3_87 VGND VGND VPWR VPWR sky130_fd_sc_hd__fill_2
Xaccumulator._2006_ accumulator._0923_ net93 VGND VGND VPWR VPWR accumulator._1103_
+ sky130_fd_sc_hd__or2_1
XFILLER_0_61_379 VPWR VGND VPWR VGND sky130_ef_sc_hd__decap_12
XFILLER_0_61_324 VPWR VGND VPWR VGND sky130_ef_sc_hd__decap_12
XFILLER_0_46_321 VPWR VGND VPWR VGND sky130_ef_sc_hd__decap_12
XFILLER_0_14_273 VGND VGND VPWR VPWR sky130_fd_sc_hd__decap_3
XTAP_TAPCELL_ROW_57_577 VGND VPWR sky130_fd_sc_hd__tapvpwrvgnd_1
XTAP_TAPCELL_ROW_6_199 VGND VPWR sky130_fd_sc_hd__tapvpwrvgnd_1
XFILLER_0_49_192 VPWR VGND VPWR VGND sky130_ef_sc_hd__decap_12
XFILLER_0_37_376 VPWR VGND VPWR VGND sky130_ef_sc_hd__decap_12
XFILLER_0_64_184 VGND VGND VPWR VPWR sky130_fd_sc_hd__decap_3
XFILLER_0_52_324 VGND VGND VPWR VPWR sky130_fd_sc_hd__fill_1
XTAP_TAPCELL_ROW_40_455 VGND VPWR sky130_fd_sc_hd__tapvpwrvgnd_1
XscaleAdd._442_ scaleAdd._333_ scaleAdd._343_ scaleAdd._022_ VGND VGND VPWR VPWR scaleAdd._023_
+ sky130_fd_sc_hd__o21a_1
XscaleAdd._511_ scaleAdd._307_ scaleAdd._085_ scaleAdd._087_ VGND VGND VPWR VPWR scaleAdd._090_
+ sky130_fd_sc_hd__a21oi_1
XTAP_TAPCELL_ROW_48_511 VGND VPWR sky130_fd_sc_hd__tapvpwrvgnd_1
XscaleAdd._373_ operator.io_outMant\[1\] VGND VGND VPWR VPWR scaleAdd._318_ sky130_fd_sc_hd__buf_2
XPHY_EDGE_ROW_0_Left_71 VGND VGND VPWR VPWR sky130_fd_sc_hd__decap_3
XFILLER_0_18_77 VGND VGND VPWR VPWR sky130_fd_sc_hd__decap_6
X_13_ accumulator.io_accOut\[13\] VGND VGND VPWR VPWR net26 sky130_fd_sc_hd__clkbuf_1
XFILLER_0_50_97 VGND VGND VPWR VPWR sky130_fd_sc_hd__decap_8
XFILLER_0_50_53 VPWR VGND VPWR VGND sky130_ef_sc_hd__decap_12
XFILLER_0_7_237 VGND VGND VPWR VPWR sky130_fd_sc_hd__fill_1
XFILLER_0_7_248 VPWR VGND VPWR VGND sky130_ef_sc_hd__decap_12
XFILLER_0_70_165 VGND VGND VPWR VPWR sky130_fd_sc_hd__decap_3
XFILLER_0_59_84 VPWR VGND VPWR VGND sky130_ef_sc_hd__decap_12
XFILLER_0_59_51 VGND VGND VPWR VPWR sky130_fd_sc_hd__decap_4
XFILLER_0_11_243 VGND VGND VPWR VPWR sky130_fd_sc_hd__fill_1
XscaleAdd._709_ net67 scaleAdd._277_ VGND VGND VPWR VPWR accumulator.io_inMant\[16\]
+ sky130_fd_sc_hd__xnor2_4
XFILLER_0_45_3 VPWR VGND VPWR VGND sky130_ef_sc_hd__decap_12
Xaccumulator._1506_ accumulator.io_accOut\[2\] accumulator._0394_ VGND VGND VPWR VPWR
+ accumulator._0603_ sky130_fd_sc_hd__nand2_1
Xaccumulator._1437_ accumulator._0526_ accumulator._0533_ VGND VGND VPWR VPWR accumulator._0534_
+ sky130_fd_sc_hd__nand2_1
XTAP_TAPCELL_ROW_54_558 VGND VPWR sky130_fd_sc_hd__tapvpwrvgnd_1
Xaccumulator._1299_ accumulator._0397_ VGND VGND VPWR VPWR accumulator._0398_ sky130_fd_sc_hd__clkbuf_4
Xaccumulator._1368_ accumulator._0461_ accumulator._0464_ accumulator._0434_ VGND
+ VGND VPWR VPWR accumulator._0465_ sky130_fd_sc_hd__mux2_1
XFILLER_0_46_195 VGND VGND VPWR VPWR sky130_fd_sc_hd__fill_1
XFILLER_0_34_313 VPWR VGND VPWR VGND sky130_ef_sc_hd__decap_12
XFILLER_0_69_210 VPWR VGND VPWR VGND sky130_ef_sc_hd__decap_12
XFILLER_0_57_416 VGND VGND VPWR VPWR sky130_fd_sc_hd__decap_4
XFILLER_0_52_110 VGND VGND VPWR VPWR sky130_fd_sc_hd__fill_1
XFILLER_0_37_162 VGND VGND VPWR VPWR sky130_fd_sc_hd__decap_6
XFILLER_0_37_140 VGND VGND VPWR VPWR sky130_fd_sc_hd__decap_4
XFILLER_0_33_390 VGND VGND VPWR VPWR sky130_fd_sc_hd__fill_2
XscaleAdd._425_ net12 scaleAdd._338_ scaleAdd._005_ VGND VGND VPWR VPWR scaleAdd._006_
+ sky130_fd_sc_hd__o21ba_1
Xaccumulator._2271_ accumulator._0111_ accumulator._0203_ accumulator._0204_ VGND
+ VGND VPWR VPWR accumulator._0206_ sky130_fd_sc_hd__a21oi_1
XFILLER_0_29_98 VPWR VGND VPWR VGND sky130_ef_sc_hd__decap_12
XFILLER_0_29_65 VGND VGND VPWR VPWR sky130_fd_sc_hd__fill_1
XFILLER_0_29_54 VGND VGND VPWR VPWR sky130_fd_sc_hd__fill_2
Xaccumulator._2340_ accumulator.io_accOut\[25\] accumulator._0271_ accumulator._0405_
+ VGND VGND VPWR VPWR accumulator._0272_ sky130_fd_sc_hd__mux2_1
XFILLER_0_63_419 VGND VGND VPWR VPWR sky130_fd_sc_hd__fill_2
XFILLER_0_45_75 VPWR VGND VPWR VGND sky130_ef_sc_hd__decap_12
XTAP_TAPCELL_ROW_16_271 VGND VPWR sky130_fd_sc_hd__tapvpwrvgnd_1
Xaccumulator._1222_ accumulator._0234_ accumulator._0045_ accumulator._0075_ VGND
+ VGND VPWR VPWR accumulator._0244_ sky130_fd_sc_hd__a21oi_1
Xaccumulator._1986_ accumulator._1069_ accumulator._1082_ VGND VGND VPWR VPWR accumulator._1083_
+ sky130_fd_sc_hd__xnor2_2
XFILLER_0_61_96 VGND VGND VPWR VPWR sky130_fd_sc_hd__decap_4
XFILLER_0_31_305 VGND VGND VPWR VPWR sky130_fd_sc_hd__decap_6
XFILLER_0_16_379 VGND VGND VPWR VPWR sky130_fd_sc_hd__decap_4
XFILLER_0_66_224 VPWR VGND VPWR VGND sky130_ef_sc_hd__decap_12
XFILLER_0_54_408 VGND VGND VPWR VPWR sky130_fd_sc_hd__decap_8
XFILLER_0_19_151 VGND VGND VPWR VPWR sky130_fd_sc_hd__decap_4
XFILLER_0_34_165 VGND VGND VPWR VPWR sky130_fd_sc_hd__decap_8
XFILLER_0_57_279 VGND VGND VPWR VPWR sky130_fd_sc_hd__fill_1
XFILLER_0_57_235 VPWR VGND VPWR VGND sky130_ef_sc_hd__decap_12
XFILLER_0_57_213 VGND VGND VPWR VPWR sky130_fd_sc_hd__decap_8
Xaccumulator._1840_ accumulator._0750_ accumulator._0751_ VGND VGND VPWR VPWR accumulator._0937_
+ sky130_fd_sc_hd__and2_1
XFILLER_0_40_102 VPWR VGND VPWR VGND sky130_ef_sc_hd__decap_12
XFILLER_0_31_55 VGND VGND VPWR VPWR sky130_fd_sc_hd__fill_1
XFILLER_0_25_165 VGND VGND VPWR VPWR sky130_fd_sc_hd__decap_3
XFILLER_0_25_110 VGND VGND VPWR VPWR sky130_fd_sc_hd__fill_2
XFILLER_0_13_305 VPWR VGND VPWR VGND sky130_ef_sc_hd__decap_12
XTAP_TAPCELL_ROW_13_252 VGND VPWR sky130_fd_sc_hd__tapvpwrvgnd_1
XFILLER_0_56_41 VPWR VGND VPWR VGND sky130_ef_sc_hd__decap_12
Xaccumulator._1771_ accumulator.io_accOut\[15\] accumulator._0484_ accumulator._0404_
+ VGND VGND VPWR VPWR accumulator._0868_ sky130_fd_sc_hd__mux2_1
XFILLER_0_21_393 VPWR VGND VPWR VGND sky130_ef_sc_hd__decap_12
XFILLER_0_0_221 VGND VGND VPWR VPWR sky130_fd_sc_hd__decap_3
XPHY_EDGE_ROW_7_Right_7 VGND VGND VPWR VPWR sky130_fd_sc_hd__decap_3
XscaleAdd._408_ scaleAdd._348_ scaleAdd._349_ VGND VGND VPWR VPWR scaleAdd._350_ sky130_fd_sc_hd__nor2b_2
XTAP_TAPCELL_ROW_64_631 VGND VPWR sky130_fd_sc_hd__tapvpwrvgnd_1
XFILLER_0_56_85 VGND VGND VPWR VPWR sky130_fd_sc_hd__decap_3
XFILLER_0_56_74 VGND VGND VPWR VPWR sky130_fd_sc_hd__decap_8
Xaccumulator._2254_ accumulator._0072_ accumulator._0172_ accumulator._0188_ VGND
+ VGND VPWR VPWR accumulator._0189_ sky130_fd_sc_hd__a21o_1
Xaccumulator._2323_ accumulator._0118_ accumulator._0190_ accumulator._0256_ accumulator._0042_
+ VGND VGND VPWR VPWR accumulator._0257_ sky130_fd_sc_hd__o211a_1
Xaccumulator._2185_ accumulator._0994_ accumulator._0036_ accumulator._0069_ VGND
+ VGND VPWR VPWR accumulator._0120_ sky130_fd_sc_hd__a21oi_1
XFILLER_0_48_257 VGND VGND VPWR VPWR sky130_fd_sc_hd__fill_1
XFILLER_0_8_321 VPWR VGND VPWR VGND sky130_ef_sc_hd__decap_12
XFILLER_0_8_365 VPWR VGND VPWR VGND sky130_ef_sc_hd__decap_12
Xaccumulator._1205_ accumulator.io_inMant\[10\] accumulator.io_inMant\[11\] accumulator.io_inMant\[12\]
+ accumulator.io_inMant\[13\] VGND VGND VPWR VPWR accumulator._0075_ sky130_fd_sc_hd__or4_1
Xaccumulator._1969_ accumulator._0857_ accumulator._1065_ VGND VGND VPWR VPWR accumulator._1066_
+ sky130_fd_sc_hd__xnor2_4
XFILLER_0_16_154 VPWR VGND VPWR VGND sky130_ef_sc_hd__decap_12
XTAP_TAPCELL_ROW_27_355 VGND VPWR sky130_fd_sc_hd__tapvpwrvgnd_1
XTAP_TAPCELL_ROW_70_678 VGND VPWR sky130_fd_sc_hd__tapvpwrvgnd_1
XFILLER_0_62_260 VPWR VGND VPWR VGND sky130_ef_sc_hd__decap_12
XFILLER_0_54_216 VGND VGND VPWR VPWR sky130_fd_sc_hd__decap_8
XFILLER_0_39_279 VGND VGND VPWR VPWR sky130_fd_sc_hd__fill_1
XscaleAdd._690_ scaleAdd._260_ scaleAdd._262_ VGND VGND VPWR VPWR scaleAdd._263_ sky130_fd_sc_hd__nand2_1
XTAP_TAPCELL_ROW_61_612 VGND VPWR sky130_fd_sc_hd__tapvpwrvgnd_1
XFILLER_0_42_65 VGND VGND VPWR VPWR sky130_fd_sc_hd__fill_2
XFILLER_0_18_419 VGND VGND VPWR VPWR sky130_fd_sc_hd__fill_1
Xaccumulator._1823_ accumulator._0739_ accumulator._0916_ accumulator._0917_ accumulator._0919_
+ VGND VGND VPWR VPWR accumulator._0920_ sky130_fd_sc_hd__a211o_2
XFILLER_0_53_293 VPWR VGND VPWR VGND sky130_ef_sc_hd__decap_12
XFILLER_0_67_51 VGND VGND VPWR VPWR sky130_fd_sc_hd__decap_4
Xaccumulator._1754_ accumulator._0849_ accumulator._0850_ VGND VGND VPWR VPWR accumulator._0851_
+ sky130_fd_sc_hd__or2_2
Xaccumulator._1685_ accumulator._0602_ accumulator._0603_ VGND VGND VPWR VPWR accumulator._0782_
+ sky130_fd_sc_hd__and2_1
Xaccumulator._2237_ accumulator._1053_ accumulator._1085_ accumulator._1184_ VGND
+ VGND VPWR VPWR accumulator._0172_ sky130_fd_sc_hd__mux2_2
Xaccumulator._2306_ accumulator._0110_ accumulator._0206_ accumulator._0237_ accumulator._0239_
+ VGND VGND VPWR VPWR accumulator._0240_ sky130_fd_sc_hd__o211a_1
Xrebuffer10 net74 VGND VGND VPWR VPWR net67 sky130_fd_sc_hd__buf_6
Xrebuffer32 net90 VGND VGND VPWR VPWR net89 sky130_fd_sc_hd__dlygate4sd1_1
Xaccumulator._2099_ accumulator._1196_ VGND VGND VPWR VPWR accumulator._1197_ sky130_fd_sc_hd__inv_2
Xaccumulator._2168_ accumulator._0101_ accumulator._0102_ accumulator._0093_ VGND
+ VGND VPWR VPWR accumulator._0007_ sky130_fd_sc_hd__o21a_1
XTAP_TAPCELL_ROW_32_391 VGND VPWR sky130_fd_sc_hd__tapvpwrvgnd_1
XTAP_TAPCELL_ROW_24_336 VGND VPWR sky130_fd_sc_hd__tapvpwrvgnd_1
XFILLER_0_8_173 VGND VGND VPWR VPWR sky130_fd_sc_hd__decap_4
XFILLER_0_12_190 VGND VGND VPWR VPWR sky130_fd_sc_hd__decap_6
XFILLER_0_67_385 VGND VGND VPWR VPWR sky130_fd_sc_hd__decap_6
XFILLER_0_50_241 VGND VGND VPWR VPWR sky130_fd_sc_hd__fill_2
XscaleAdd._742_ scaleAdd._304_ scaleAdd._306_ scaleAdd._302_ VGND VGND VPWR VPWR accumulator.io_inExp\[5\]
+ sky130_fd_sc_hd__a21bo_1
XscaleAdd._673_ scaleAdd._245_ scaleAdd._246_ VGND VGND VPWR VPWR scaleAdd._247_ sky130_fd_sc_hd__and2b_1
XFILLER_0_10_138 VGND VGND VPWR VPWR sky130_fd_sc_hd__fill_2
Xaccumulator._1470_ accumulator._0463_ accumulator._0566_ accumulator._0439_ VGND
+ VGND VPWR VPWR accumulator._0567_ sky130_fd_sc_hd__mux2_1
Xaccumulator._2022_ accumulator._0893_ accumulator._0963_ VGND VGND VPWR VPWR accumulator._1119_
+ sky130_fd_sc_hd__nand2_1
XFILLER_0_58_330 VGND VGND VPWR VPWR sky130_fd_sc_hd__fill_2
XTAP_TAPCELL_ROW_46_494 VGND VPWR sky130_fd_sc_hd__tapvpwrvgnd_1
XTAP_TAPCELL_ROW_38_439 VGND VPWR sky130_fd_sc_hd__tapvpwrvgnd_1
XFILLER_0_18_227 VPWR VGND VPWR VGND sky130_ef_sc_hd__decap_12
Xaccumulator._1806_ accumulator._0876_ accumulator._0884_ accumulator._0894_ accumulator._0902_
+ VGND VGND VPWR VPWR accumulator._0903_ sky130_fd_sc_hd__a31o_1
XFILLER_0_1_393 VPWR VGND VPWR VGND sky130_ef_sc_hd__decap_12
Xaccumulator._1668_ accumulator.io_accOut\[4\] accumulator._0395_ VGND VGND VPWR VPWR
+ accumulator._0765_ sky130_fd_sc_hd__nand2_1
Xaccumulator._1599_ accumulator._0615_ accumulator._0616_ accumulator._0498_ VGND
+ VGND VPWR VPWR accumulator._0696_ sky130_fd_sc_hd__a21oi_1
Xaccumulator._1737_ accumulator.io_accOut\[12\] accumulator._0508_ accumulator._0404_
+ VGND VGND VPWR VPWR accumulator._0834_ sky130_fd_sc_hd__mux2_1
XFILLER_0_32_274 VGND VGND VPWR VPWR sky130_fd_sc_hd__decap_8
XFILLER_0_55_322 VPWR VGND VPWR VGND sky130_ef_sc_hd__decap_12
XTAP_TAPCELL_ROW_43_475 VGND VPWR sky130_fd_sc_hd__tapvpwrvgnd_1
XscaleAdd._725_ scaleAdd._290_ scaleAdd._291_ VGND VGND VPWR VPWR scaleAdd._292_ sky130_fd_sc_hd__or2_1
Xrebuffer1 accumulator._0375_ VGND VGND VPWR VPWR net58 sky130_fd_sc_hd__dlygate4sd1_1
XFILLER_0_23_252 VGND VGND VPWR VPWR sky130_fd_sc_hd__decap_8
XscaleAdd._587_ scaleAdd._132_ scaleAdd._162_ VGND VGND VPWR VPWR scaleAdd._164_ sky130_fd_sc_hd__nand2_1
XscaleAdd._656_ scaleAdd._330_ scaleAdd._195_ VGND VGND VPWR VPWR scaleAdd._230_ sky130_fd_sc_hd__nand2_1
XFILLER_0_2_157 VPWR VGND VPWR VGND sky130_ef_sc_hd__decap_12
XFILLER_0_2_102 VGND VGND VPWR VPWR sky130_fd_sc_hd__decap_4
XFILLER_0_64_41 VPWR VGND VPWR VGND sky130_ef_sc_hd__decap_12
XFILLER_0_48_97 VGND VGND VPWR VPWR sky130_fd_sc_hd__fill_1
XFILLER_0_48_75 VGND VGND VPWR VPWR sky130_fd_sc_hd__fill_1
XFILLER_0_48_53 VGND VGND VPWR VPWR sky130_fd_sc_hd__decap_6
Xaccumulator._1522_ accumulator._0525_ accumulator._0610_ accumulator._0618_ VGND
+ VGND VPWR VPWR accumulator._0619_ sky130_fd_sc_hd__o21bai_2
Xaccumulator._1453_ accumulator.io_accOut\[6\] accumulator._0549_ net78 VGND VGND
+ VPWR VPWR accumulator._0550_ sky130_fd_sc_hd__mux2_1
Xaccumulator._2005_ accumulator._0919_ accumulator._0898_ accumulator._1094_ accumulator._0883_
+ VGND VGND VPWR VPWR accumulator._1102_ sky130_fd_sc_hd__o22a_1
XFILLER_0_64_85 VGND VGND VPWR VPWR sky130_fd_sc_hd__fill_2
XFILLER_0_58_193 VGND VGND VPWR VPWR sky130_fd_sc_hd__decap_3
XFILLER_0_46_333 VGND VGND VPWR VPWR sky130_fd_sc_hd__decap_4
Xaccumulator._1384_ accumulator._0441_ accumulator._0445_ accumulator._0455_ VGND
+ VGND VPWR VPWR accumulator._0481_ sky130_fd_sc_hd__mux2_1
XFILLER_0_46_377 VGND VGND VPWR VPWR sky130_fd_sc_hd__fill_1
XFILLER_0_46_344 VPWR VGND VPWR VGND sky130_ef_sc_hd__decap_12
XTAP_TAPCELL_ROW_57_578 VGND VPWR sky130_fd_sc_hd__tapvpwrvgnd_1
XTAP_TAPCELL_ROW_40_456 VGND VPWR sky130_fd_sc_hd__tapvpwrvgnd_1
XFILLER_0_37_388 VGND VGND VPWR VPWR sky130_fd_sc_hd__decap_4
XFILLER_0_37_366 VGND VGND VPWR VPWR sky130_fd_sc_hd__fill_1
XscaleAdd._441_ scaleAdd._334_ scaleAdd._021_ VGND VGND VPWR VPWR scaleAdd._022_ sky130_fd_sc_hd__nand2_1
XscaleAdd._510_ scaleAdd._083_ scaleAdd._088_ VGND VGND VPWR VPWR scaleAdd._089_ sky130_fd_sc_hd__or2_1
XscaleAdd._372_ scaleAdd._303_ scaleAdd._316_ VGND VGND VPWR VPWR scaleAdd._317_ sky130_fd_sc_hd__nor2_2
XTAP_TAPCELL_ROW_48_512 VGND VPWR sky130_fd_sc_hd__tapvpwrvgnd_1
X_12_ accumulator.io_accOut\[12\] VGND VGND VPWR VPWR net25 sky130_fd_sc_hd__buf_1
XFILLER_0_18_12 VGND VGND VPWR VPWR sky130_fd_sc_hd__fill_1
XFILLER_0_20_299 VGND VGND VPWR VPWR sky130_fd_sc_hd__decap_3
XFILLER_0_55_130 VPWR VGND VPWR VGND sky130_ef_sc_hd__decap_12
XFILLER_0_50_76 VGND VGND VPWR VPWR sky130_fd_sc_hd__decap_8
XFILLER_0_28_399 VPWR VGND VPWR VGND sky130_ef_sc_hd__decap_12
XscaleAdd._708_ scaleAdd._261_ scaleAdd._273_ scaleAdd._278_ scaleAdd._270_ VGND VGND
+ VPWR VPWR scaleAdd._279_ sky130_fd_sc_hd__a31oi_4
XFILLER_0_59_96 VGND VGND VPWR VPWR sky130_fd_sc_hd__decap_4
XFILLER_0_51_391 VGND VGND VPWR VPWR sky130_fd_sc_hd__fill_1
Xclkbuf_2_0__f_clock clknet_0_clock VGND VGND VPWR VPWR clknet_2_0__leaf_clock sky130_fd_sc_hd__clkbuf_16
XscaleAdd._639_ scaleAdd._137_ scaleAdd._212_ scaleAdd._213_ VGND VGND VPWR VPWR scaleAdd._214_
+ sky130_fd_sc_hd__a21o_2
Xaccumulator._1505_ accumulator._0425_ accumulator._0524_ accumulator._0555_ accumulator._0557_
+ accumulator._0601_ VGND VGND VPWR VPWR accumulator._0602_ sky130_fd_sc_hd__a32o_2
Xaccumulator._1436_ accumulator.io_accOut\[3\] accumulator._0468_ accumulator._0531_
+ accumulator._0532_ VGND VGND VPWR VPWR accumulator._0533_ sky130_fd_sc_hd__a31o_1
XFILLER_0_38_3 VPWR VGND VPWR VGND sky130_ef_sc_hd__decap_12
Xaccumulator._1367_ accumulator._0462_ accumulator._0463_ accumulator._0439_ VGND
+ VGND VPWR VPWR accumulator._0464_ sky130_fd_sc_hd__mux2_1
XTAP_TAPCELL_ROW_54_559 VGND VPWR sky130_fd_sc_hd__tapvpwrvgnd_1
XFILLER_0_46_141 VGND VGND VPWR VPWR sky130_fd_sc_hd__decap_4
XFILLER_0_46_130 VGND VGND VPWR VPWR sky130_fd_sc_hd__decap_8
XFILLER_0_34_325 VGND VGND VPWR VPWR sky130_fd_sc_hd__fill_1
Xaccumulator._1298_ accumulator._0396_ VGND VGND VPWR VPWR accumulator._0397_ sky130_fd_sc_hd__buf_2
XFILLER_0_61_122 VGND VGND VPWR VPWR sky130_fd_sc_hd__decap_4
XFILLER_0_69_233 VGND VGND VPWR VPWR sky130_fd_sc_hd__fill_2
XFILLER_0_69_222 VGND VGND VPWR VPWR sky130_fd_sc_hd__fill_2
XTAP_TAPCELL_ROW_2_170 VGND VPWR sky130_fd_sc_hd__tapvpwrvgnd_1
XFILLER_0_52_133 VGND VGND VPWR VPWR sky130_fd_sc_hd__decap_6
XFILLER_0_52_100 VGND VGND VPWR VPWR sky130_fd_sc_hd__fill_2
XscaleAdd._424_ net12 net11 net13 VGND VGND VPWR VPWR scaleAdd._005_ sky130_fd_sc_hd__and3_1
Xaccumulator._2270_ accumulator._0186_ accumulator._0187_ accumulator._0061_ VGND
+ VGND VPWR VPWR accumulator._0204_ sky130_fd_sc_hd__a21oi_1
XFILLER_0_45_87 VPWR VGND VPWR VGND sky130_ef_sc_hd__decap_12
Xaccumulator._1221_ accumulator._0034_ VGND VGND VPWR VPWR accumulator._0234_ sky130_fd_sc_hd__inv_2
XFILLER_0_28_141 VGND VGND VPWR VPWR sky130_fd_sc_hd__decap_3
XTAP_TAPCELL_ROW_16_272 VGND VPWR sky130_fd_sc_hd__tapvpwrvgnd_1
Xaccumulator._1985_ accumulator._1063_ accumulator._1066_ accumulator._1054_ VGND
+ VGND VPWR VPWR accumulator._1082_ sky130_fd_sc_hd__a21oi_1
XFILLER_0_43_111 VGND VGND VPWR VPWR sky130_fd_sc_hd__fill_1
XFILLER_0_31_317 VPWR VGND VPWR VGND sky130_ef_sc_hd__decap_12
XFILLER_0_3_285 VPWR VGND VPWR VGND sky130_ef_sc_hd__decap_12
XFILLER_0_66_236 VPWR VGND VPWR VGND sky130_ef_sc_hd__decap_12
Xaccumulator._2399_ clknet_2_0__leaf_clock accumulator._0000_ VGND VGND VPWR VPWR
+ accumulator.io_accOut\[31\] sky130_fd_sc_hd__dfxtp_2
Xaccumulator._1419_ accumulator._0488_ accumulator._0491_ accumulator._0263_ VGND
+ VGND VPWR VPWR accumulator._0516_ sky130_fd_sc_hd__mux2_1
XFILLER_0_22_339 VGND VGND VPWR VPWR sky130_fd_sc_hd__decap_6
XFILLER_0_57_225 VGND VGND VPWR VPWR sky130_fd_sc_hd__decap_6
XFILLER_0_15_57 VPWR VGND VPWR VGND sky130_ef_sc_hd__decap_12
Xaccumulator._1770_ accumulator._0852_ accumulator._0704_ VGND VGND VPWR VPWR accumulator._0867_
+ sky130_fd_sc_hd__nor2_1
XFILLER_0_53_420 VGND VGND VPWR VPWR sky130_fd_sc_hd__fill_1
XFILLER_0_40_147 VGND VGND VPWR VPWR sky130_fd_sc_hd__fill_1
XFILLER_0_40_114 VGND VGND VPWR VPWR sky130_fd_sc_hd__decap_4
XFILLER_0_13_317 VPWR VGND VPWR VGND sky130_ef_sc_hd__decap_12
XTAP_TAPCELL_ROW_13_253 VGND VPWR sky130_fd_sc_hd__tapvpwrvgnd_1
XFILLER_0_56_53 VGND VGND VPWR VPWR sky130_fd_sc_hd__fill_2
XPHY_EDGE_ROW_37_Left_108 VGND VGND VPWR VPWR sky130_fd_sc_hd__decap_3
XFILLER_0_21_361 VPWR VGND VPWR VGND sky130_ef_sc_hd__decap_12
XscaleAdd._407_ net13 scaleAdd._320_ VGND VGND VPWR VPWR scaleAdd._349_ sky130_fd_sc_hd__nand2_1
XTAP_TAPCELL_ROW_64_632 VGND VPWR sky130_fd_sc_hd__tapvpwrvgnd_1
Xaccumulator._2253_ accumulator._0186_ accumulator._0187_ accumulator._0072_ VGND
+ VGND VPWR VPWR accumulator._0188_ sky130_fd_sc_hd__a21oi_1
Xaccumulator._2322_ accumulator._0252_ accumulator._0255_ accumulator._0079_ VGND
+ VGND VPWR VPWR accumulator._0256_ sky130_fd_sc_hd__a21o_1
Xaccumulator._2184_ accumulator._0978_ accumulator._0036_ accumulator._0046_ VGND
+ VGND VPWR VPWR accumulator._0119_ sky130_fd_sc_hd__a21oi_1
Xaccumulator._1204_ accumulator.io_inMant\[17\] accumulator.io_inMant\[16\] accumulator.io_inMant\[15\]
+ accumulator.io_inMant\[14\] VGND VGND VPWR VPWR accumulator._0065_ sky130_fd_sc_hd__or4_4
XPHY_EDGE_ROW_46_Left_117 VGND VGND VPWR VPWR sky130_fd_sc_hd__decap_3
XscaleAdd._736__56 VGND VGND VPWR VPWR scaleAdd._736__56/HI net56 sky130_fd_sc_hd__conb_1
XFILLER_0_8_333 VPWR VGND VPWR VGND sky130_ef_sc_hd__decap_12
XFILLER_0_8_377 VPWR VGND VPWR VGND sky130_ef_sc_hd__decap_12
XFILLER_0_16_166 VGND VGND VPWR VPWR sky130_fd_sc_hd__decap_4
Xaccumulator._1968_ accumulator._0918_ accumulator._0944_ accumulator._0948_ accumulator._1064_
+ VGND VGND VPWR VPWR accumulator._1065_ sky130_fd_sc_hd__a31o_1
XPHY_EDGE_ROW_55_Left_126 VGND VGND VPWR VPWR sky130_fd_sc_hd__decap_3
Xaccumulator._1899_ accumulator._0991_ accumulator._0995_ VGND VGND VPWR VPWR accumulator._0996_
+ sky130_fd_sc_hd__xnor2_1
XTAP_TAPCELL_ROW_70_679 VGND VPWR sky130_fd_sc_hd__tapvpwrvgnd_1
XPHY_EDGE_ROW_64_Left_135 VGND VGND VPWR VPWR sky130_fd_sc_hd__decap_3
XTAP_TAPCELL_ROW_27_356 VGND VPWR sky130_fd_sc_hd__tapvpwrvgnd_1
XFILLER_0_62_272 VPWR VGND VPWR VGND sky130_ef_sc_hd__decap_12
XFILLER_0_62_250 VGND VGND VPWR VPWR sky130_fd_sc_hd__fill_2
XFILLER_0_50_401 VPWR VGND VPWR VGND sky130_ef_sc_hd__decap_12
XFILLER_0_22_158 VPWR VGND VPWR VGND sky130_ef_sc_hd__decap_12
XFILLER_0_22_125 VPWR VGND VPWR VGND sky130_ef_sc_hd__decap_12
XFILLER_0_30_180 VPWR VGND VPWR VGND sky130_ef_sc_hd__decap_12
XFILLER_0_10_309 VPWR VGND VPWR VGND sky130_ef_sc_hd__decap_12
XTAP_TAPCELL_ROW_61_613 VGND VPWR sky130_fd_sc_hd__tapvpwrvgnd_1
Xaccumulator._1753_ accumulator._0847_ accumulator._0848_ VGND VGND VPWR VPWR accumulator._0850_
+ sky130_fd_sc_hd__and2_1
Xaccumulator._1822_ accumulator._0918_ VGND VGND VPWR VPWR accumulator._0919_ sky130_fd_sc_hd__buf_2
XFILLER_0_53_261 VGND VGND VPWR VPWR sky130_fd_sc_hd__decap_4
XFILLER_0_21_180 VGND VGND VPWR VPWR sky130_fd_sc_hd__decap_4
XFILLER_0_6_55 VGND VGND VPWR VPWR sky130_fd_sc_hd__decap_6
XFILLER_0_6_66 VGND VGND VPWR VPWR sky130_fd_sc_hd__fill_1
Xaccumulator._1684_ accumulator._0779_ accumulator._0780_ VGND VGND VPWR VPWR accumulator._0781_
+ sky130_fd_sc_hd__or2_1
Xrebuffer11 net81 VGND VGND VPWR VPWR net68 sky130_fd_sc_hd__dlygate4sd1_1
XFILLER_0_68_309 VPWR VGND VPWR VGND sky130_ef_sc_hd__decap_12
Xaccumulator._2305_ accumulator._0111_ accumulator._0238_ accumulator._0131_ VGND
+ VGND VPWR VPWR accumulator._0239_ sky130_fd_sc_hd__a21oi_1
Xaccumulator._2236_ accumulator._0061_ accumulator._0134_ accumulator._0135_ VGND
+ VGND VPWR VPWR accumulator._0171_ sky130_fd_sc_hd__a21o_1
Xaccumulator._2167_ accumulator.io_accOut\[5\] accumulator._0091_ VGND VGND VPWR VPWR
+ accumulator._0102_ sky130_fd_sc_hd__and2_1
Xrebuffer33 net91 VGND VGND VPWR VPWR net90 sky130_fd_sc_hd__dlygate4sd1_1
XFILLER_0_8_130 VGND VGND VPWR VPWR sky130_fd_sc_hd__decap_3
Xaccumulator._2098_ accumulator._1188_ accumulator._1195_ accumulator._1133_ VGND
+ VGND VPWR VPWR accumulator._1196_ sky130_fd_sc_hd__a21o_2
XFILLER_0_44_250 VGND VGND VPWR VPWR sky130_fd_sc_hd__fill_2
XTAP_TAPCELL_ROW_32_392 VGND VPWR sky130_fd_sc_hd__tapvpwrvgnd_1
XFILLER_0_8_141 VGND VGND VPWR VPWR sky130_fd_sc_hd__fill_1
XscaleAdd._741_ scaleAdd._304_ scaleAdd._306_ VGND VGND VPWR VPWR accumulator.io_inExp\[3\]
+ sky130_fd_sc_hd__xnor2_1
XFILLER_0_12_36 VGND VGND VPWR VPWR sky130_fd_sc_hd__decap_6
XFILLER_0_12_47 VGND VGND VPWR VPWR sky130_fd_sc_hd__decap_8
XFILLER_0_50_253 VPWR VGND VPWR VGND sky130_ef_sc_hd__decap_12
XFILLER_0_35_294 VPWR VGND VPWR VGND sky130_ef_sc_hd__decap_12
XFILLER_0_35_272 VGND VGND VPWR VPWR sky130_fd_sc_hd__decap_8
XFILLER_0_23_401 VGND VGND VPWR VPWR sky130_fd_sc_hd__fill_2
XscaleAdd._672_ scaleAdd._242_ scaleAdd._244_ VGND VGND VPWR VPWR scaleAdd._246_ sky130_fd_sc_hd__nand2_1
XFILLER_0_10_106 VPWR VGND VPWR VGND sky130_ef_sc_hd__decap_12
XFILLER_0_37_55 VGND VGND VPWR VPWR sky130_fd_sc_hd__fill_1
Xaccumulator._2021_ accumulator._0923_ accumulator._1117_ accumulator._0920_ VGND
+ VGND VPWR VPWR accumulator._1118_ sky130_fd_sc_hd__o21ai_1
XFILLER_0_53_87 VPWR VGND VPWR VGND sky130_ef_sc_hd__decap_12
XTAP_TAPCELL_ROW_46_495 VGND VPWR sky130_fd_sc_hd__tapvpwrvgnd_1
XFILLER_0_18_206 VGND VGND VPWR VPWR sky130_fd_sc_hd__decap_4
XFILLER_0_26_250 VGND VGND VPWR VPWR sky130_fd_sc_hd__fill_2
XTAP_TAPCELL_ROW_21_307 VGND VPWR sky130_fd_sc_hd__tapvpwrvgnd_1
XFILLER_0_5_111 VGND VGND VPWR VPWR sky130_fd_sc_hd__fill_1
XFILLER_0_14_401 VPWR VGND VPWR VGND sky130_ef_sc_hd__decap_12
XFILLER_0_68_3 VPWR VGND VPWR VGND sky130_ef_sc_hd__decap_12
Xaccumulator._1805_ accumulator._0901_ VGND VGND VPWR VPWR accumulator._0902_ sky130_fd_sc_hd__inv_2
Xaccumulator._1736_ accumulator._0832_ VGND VGND VPWR VPWR accumulator._0833_ sky130_fd_sc_hd__inv_2
XFILLER_0_41_253 VGND VGND VPWR VPWR sky130_fd_sc_hd__fill_1
XFILLER_0_1_361 VPWR VGND VPWR VGND sky130_ef_sc_hd__decap_12
Xaccumulator._1667_ accumulator._0758_ accumulator._0425_ accumulator._0761_ accumulator._0557_
+ accumulator._0763_ VGND VGND VPWR VPWR accumulator._0764_ sky130_fd_sc_hd__a32o_2
Xaccumulator._1598_ accumulator._0607_ accumulator._0608_ accumulator._0476_ VGND
+ VGND VPWR VPWR accumulator._0695_ sky130_fd_sc_hd__a21oi_1
XFILLER_0_64_378 VPWR VGND VPWR VGND sky130_ef_sc_hd__decap_12
XFILLER_0_49_375 VGND VGND VPWR VPWR sky130_fd_sc_hd__fill_1
Xaccumulator._2219_ accumulator._0128_ accumulator._0060_ accumulator._0064_ accumulator._1141_
+ VGND VGND VPWR VPWR accumulator._0154_ sky130_fd_sc_hd__a211o_1
XFILLER_0_32_231 VGND VGND VPWR VPWR sky130_fd_sc_hd__decap_4
XFILLER_0_17_261 VPWR VGND VPWR VGND sky130_ef_sc_hd__decap_12
XFILLER_0_23_24 VGND VGND VPWR VPWR sky130_fd_sc_hd__fill_2
XFILLER_0_70_337 VPWR VGND VPWR VGND sky130_ef_sc_hd__decap_12
XFILLER_0_55_345 VGND VGND VPWR VPWR sky130_fd_sc_hd__fill_2
XFILLER_0_55_334 VGND VGND VPWR VPWR sky130_fd_sc_hd__fill_2
XTAP_TAPCELL_ROW_43_476 VGND VPWR sky130_fd_sc_hd__tapvpwrvgnd_1
XscaleAdd._724_ operator.io_outExp\[1\] scaleAdd._289_ VGND VGND VPWR VPWR scaleAdd._291_
+ sky130_fd_sc_hd__nor2_1
XscaleAdd._655_ scaleAdd._229_ VGND VGND VPWR VPWR accumulator.io_inMant\[12\] sky130_fd_sc_hd__buf_1
Xrebuffer2 accumulator._0383_ VGND VGND VPWR VPWR net59 sky130_fd_sc_hd__dlygate4sd1_1
XscaleAdd._586_ scaleAdd._132_ scaleAdd._162_ VGND VGND VPWR VPWR scaleAdd._163_ sky130_fd_sc_hd__or2_1
XFILLER_0_2_169 VGND VGND VPWR VPWR sky130_fd_sc_hd__decap_4
XFILLER_0_64_75 VGND VGND VPWR VPWR sky130_fd_sc_hd__decap_8
XFILLER_0_64_53 VGND VGND VPWR VPWR sky130_fd_sc_hd__decap_8
Xaccumulator._1521_ accumulator._0611_ accumulator._0614_ accumulator._0617_ accumulator._0501_
+ VGND VGND VPWR VPWR accumulator._0618_ sky130_fd_sc_hd__o211a_1
Xaccumulator._1452_ accumulator._0116_ accumulator._0489_ VGND VGND VPWR VPWR accumulator._0549_
+ sky130_fd_sc_hd__nor2_1
Xaccumulator._1383_ accumulator._0444_ accumulator._0438_ accumulator._0455_ VGND
+ VGND VPWR VPWR accumulator._0480_ sky130_fd_sc_hd__mux2_1
Xaccumulator._2004_ accumulator._1096_ accumulator._1100_ VGND VGND VPWR VPWR accumulator._1101_
+ sky130_fd_sc_hd__xor2_2
XFILLER_0_58_161 VGND VGND VPWR VPWR sky130_fd_sc_hd__decap_8
XFILLER_0_46_356 VGND VGND VPWR VPWR sky130_fd_sc_hd__decap_8
XFILLER_0_46_301 VGND VGND VPWR VPWR sky130_fd_sc_hd__fill_1
XTAP_TAPCELL_ROW_34_410 VGND VPWR sky130_fd_sc_hd__tapvpwrvgnd_1
XFILLER_0_14_253 VPWR VGND VPWR VGND sky130_ef_sc_hd__decap_12
Xaccumulator._1719_ accumulator._0559_ accumulator._0586_ accumulator._0600_ VGND
+ VGND VPWR VPWR accumulator._0816_ sky130_fd_sc_hd__o21ai_1
XTAP_TAPCELL_ROW_57_579 VGND VPWR sky130_fd_sc_hd__tapvpwrvgnd_1
XPHY_EDGE_ROW_29_Right_29 VGND VGND VPWR VPWR sky130_fd_sc_hd__decap_3
XPHY_EDGE_ROW_38_Right_38 VGND VGND VPWR VPWR sky130_fd_sc_hd__decap_3
XscaleAdd._440_ scaleAdd._342_ VGND VGND VPWR VPWR scaleAdd._021_ sky130_fd_sc_hd__inv_2
XscaleAdd._371_ scaleAdd._307_ VGND VGND VPWR VPWR scaleAdd._316_ sky130_fd_sc_hd__inv_2
XFILLER_0_20_267 VGND VGND VPWR VPWR sky130_fd_sc_hd__fill_1
XTAP_TAPCELL_ROW_48_513 VGND VPWR sky130_fd_sc_hd__tapvpwrvgnd_1
XPHY_EDGE_ROW_47_Right_47 VGND VGND VPWR VPWR sky130_fd_sc_hd__decap_3
X_11_ accumulator.io_accOut\[11\] VGND VGND VPWR VPWR net24 sky130_fd_sc_hd__buf_1
XTAP_TAPCELL_ROW_5_190 VGND VPWR sky130_fd_sc_hd__tapvpwrvgnd_1
XFILLER_0_18_46 VGND VGND VPWR VPWR sky130_fd_sc_hd__fill_1
XPHY_EDGE_ROW_56_Right_56 VGND VGND VPWR VPWR sky130_fd_sc_hd__decap_3
XFILLER_0_55_142 VGND VGND VPWR VPWR sky130_fd_sc_hd__decap_8
XFILLER_0_43_315 VGND VGND VPWR VPWR sky130_fd_sc_hd__decap_6
XFILLER_0_43_304 VGND VGND VPWR VPWR sky130_fd_sc_hd__decap_3
XscaleAdd._638_ scaleAdd._191_ scaleAdd._163_ scaleAdd._193_ VGND VGND VPWR VPWR scaleAdd._213_
+ sky130_fd_sc_hd__a21oi_1
XscaleAdd._707_ scaleAdd._271_ VGND VGND VPWR VPWR scaleAdd._278_ sky130_fd_sc_hd__inv_2
XPHY_EDGE_ROW_65_Right_65 VGND VGND VPWR VPWR sky130_fd_sc_hd__decap_3
Xaccumulator._1504_ accumulator._0559_ accumulator._0586_ accumulator._0600_ accumulator._0523_
+ VGND VGND VPWR VPWR accumulator._0601_ sky130_fd_sc_hd__o211a_1
XscaleAdd._569_ scaleAdd._144_ scaleAdd._146_ VGND VGND VPWR VPWR scaleAdd._147_ sky130_fd_sc_hd__xor2_1
Xaccumulator._1435_ accumulator.io_accOut\[2\] net60 accumulator._0414_ accumulator._0431_
+ VGND VGND VPWR VPWR accumulator._0532_ sky130_fd_sc_hd__and4_1
Xaccumulator._1366_ accumulator.io_inMant\[9\] accumulator.io_inMant\[10\] accumulator._0436_
+ VGND VGND VPWR VPWR accumulator._0463_ sky130_fd_sc_hd__mux2_1
XTAP_TAPCELL_ROW_19_292 VGND VPWR sky130_fd_sc_hd__tapvpwrvgnd_1
XFILLER_0_61_134 VGND VGND VPWR VPWR sky130_fd_sc_hd__fill_1
XFILLER_0_46_197 VGND VGND VPWR VPWR sky130_fd_sc_hd__decap_8
XFILLER_0_46_164 VGND VGND VPWR VPWR sky130_fd_sc_hd__decap_8
XFILLER_0_34_304 VGND VGND VPWR VPWR sky130_fd_sc_hd__decap_4
Xaccumulator._1297_ accumulator.state\[1\] accumulator.state\[0\] VGND VGND VPWR VPWR
+ accumulator._0396_ sky130_fd_sc_hd__nand2b_2
XFILLER_0_19_323 VPWR VGND VPWR VGND sky130_ef_sc_hd__decap_12
XFILLER_0_61_156 VGND VGND VPWR VPWR sky130_fd_sc_hd__decap_6
XTAP_TAPCELL_ROW_2_171 VGND VPWR sky130_fd_sc_hd__tapvpwrvgnd_1
XFILLER_0_40_307 VGND VGND VPWR VPWR sky130_fd_sc_hd__fill_1
XFILLER_0_25_348 VGND VGND VPWR VPWR sky130_fd_sc_hd__fill_1
XFILLER_0_25_337 VGND VGND VPWR VPWR sky130_fd_sc_hd__decap_6
XFILLER_0_4_209 VPWR VGND VPWR VGND sky130_ef_sc_hd__decap_12
XFILLER_0_20_25 VGND VGND VPWR VPWR sky130_fd_sc_hd__decap_3
XscaleAdd._423_ net10 net14 VGND VGND VPWR VPWR scaleAdd._004_ sky130_fd_sc_hd__nand2_1
XFILLER_0_48_418 VGND VGND VPWR VPWR sky130_fd_sc_hd__fill_2
XFILLER_0_45_99 VGND VGND VPWR VPWR sky130_fd_sc_hd__decap_6
XFILLER_0_45_55 VGND VGND VPWR VPWR sky130_fd_sc_hd__fill_1
Xaccumulator._1220_ accumulator.io_inExp\[1\] accumulator._0215_ VGND VGND VPWR VPWR
+ accumulator._0225_ sky130_fd_sc_hd__or2_1
XFILLER_0_28_197 VPWR VGND VPWR VGND sky130_ef_sc_hd__decap_12
XFILLER_0_0_57 VGND VGND VPWR VPWR sky130_fd_sc_hd__fill_2
XTAP_TAPCELL_ROW_16_273 VGND VPWR sky130_fd_sc_hd__tapvpwrvgnd_1
Xaccumulator._1984_ accumulator._1073_ accumulator._1080_ VGND VGND VPWR VPWR accumulator._1081_
+ sky130_fd_sc_hd__nor2_1
XFILLER_0_43_167 VGND VGND VPWR VPWR sky130_fd_sc_hd__fill_1
XFILLER_0_31_329 VGND VGND VPWR VPWR sky130_fd_sc_hd__fill_1
XFILLER_0_24_392 VGND VGND VPWR VPWR sky130_fd_sc_hd__fill_1
XFILLER_0_3_297 VPWR VGND VPWR VGND sky130_ef_sc_hd__decap_12
XTAP_TAPCELL_ROW_67_652 VGND VPWR sky130_fd_sc_hd__tapvpwrvgnd_1
XFILLER_0_50_3 VPWR VGND VPWR VGND sky130_ef_sc_hd__decap_12
XFILLER_0_66_248 VGND VGND VPWR VPWR sky130_fd_sc_hd__decap_4
Xaccumulator._1418_ accumulator._0478_ accumulator._0514_ accumulator._0451_ VGND
+ VGND VPWR VPWR accumulator._0515_ sky130_fd_sc_hd__a21o_1
Xaccumulator._2398_ net104 net20 accumulator._0398_ accumulator._0329_ VGND VGND VPWR
+ VPWR accumulator._0033_ sky130_fd_sc_hd__o211a_1
XFILLER_0_19_120 VGND VGND VPWR VPWR sky130_fd_sc_hd__fill_1
Xaccumulator._1349_ accumulator._0444_ accumulator._0445_ accumulator._0439_ VGND
+ VGND VPWR VPWR accumulator._0446_ sky130_fd_sc_hd__mux2_1
XTAP_TAPCELL_ROW_50_530 VGND VPWR sky130_fd_sc_hd__tapvpwrvgnd_1
XFILLER_0_22_329 VGND VGND VPWR VPWR sky130_fd_sc_hd__decap_4
XFILLER_0_22_307 VGND VGND VPWR VPWR sky130_fd_sc_hd__fill_1
XFILLER_0_30_362 VGND VGND VPWR VPWR sky130_fd_sc_hd__fill_2
XFILLER_0_65_281 VGND VGND VPWR VPWR sky130_fd_sc_hd__decap_3
XFILLER_0_31_57 VPWR VGND VPWR VGND sky130_ef_sc_hd__decap_12
XFILLER_0_31_13 VPWR VGND VPWR VGND sky130_ef_sc_hd__decap_12
XFILLER_0_15_69 VGND VGND VPWR VPWR sky130_fd_sc_hd__decap_4
XFILLER_0_40_137 VGND VGND VPWR VPWR sky130_fd_sc_hd__decap_3
XFILLER_0_21_373 VPWR VGND VPWR VGND sky130_ef_sc_hd__decap_12
XFILLER_0_13_329 VGND VGND VPWR VPWR sky130_fd_sc_hd__decap_6
Xaccumulator._2321_ accumulator._0072_ accumulator._0238_ accumulator._0253_ VGND
+ VGND VPWR VPWR accumulator._0255_ sky130_fd_sc_hd__a21o_1
XscaleAdd._406_ scaleAdd._346_ scaleAdd._347_ scaleAdd._320_ VGND VGND VPWR VPWR scaleAdd._348_
+ sky130_fd_sc_hd__a21oi_1
XTAP_TAPCELL_ROW_64_633 VGND VPWR sky130_fd_sc_hd__tapvpwrvgnd_1
Xaccumulator._2252_ accumulator._1083_ accumulator._0103_ accumulator._0104_ VGND
+ VGND VPWR VPWR accumulator._0187_ sky130_fd_sc_hd__nand3_1
Xaccumulator._2183_ accumulator._1141_ VGND VGND VPWR VPWR accumulator._0118_ sky130_fd_sc_hd__buf_2
Xaccumulator._1203_ accumulator._0034_ accumulator._0045_ VGND VGND VPWR VPWR accumulator._0055_
+ sky130_fd_sc_hd__nor2_1
XFILLER_0_63_207 VGND VGND VPWR VPWR sky130_fd_sc_hd__fill_2
XFILLER_0_8_345 VPWR VGND VPWR VGND sky130_ef_sc_hd__decap_12
XFILLER_0_8_389 VPWR VGND VPWR VGND sky130_ef_sc_hd__decap_12
Xaccumulator._1967_ accumulator._0922_ accumulator._0845_ VGND VGND VPWR VPWR accumulator._1064_
+ sky130_fd_sc_hd__and2_1
Xaccumulator._1898_ accumulator._0969_ accumulator._0986_ VGND VGND VPWR VPWR accumulator._0995_
+ sky130_fd_sc_hd__nor2_1
XFILLER_0_47_281 VPWR VGND VPWR VGND sky130_ef_sc_hd__decap_12
XFILLER_0_47_270 VGND VGND VPWR VPWR sky130_fd_sc_hd__decap_8
XTAP_TAPCELL_ROW_27_357 VGND VPWR sky130_fd_sc_hd__tapvpwrvgnd_1
XFILLER_0_62_284 VPWR VGND VPWR VGND sky130_ef_sc_hd__decap_12
XFILLER_0_50_413 VGND VGND VPWR VPWR sky130_fd_sc_hd__decap_3
XFILLER_0_22_137 VGND VGND VPWR VPWR sky130_fd_sc_hd__decap_3
XFILLER_0_22_115 VGND VGND VPWR VPWR sky130_fd_sc_hd__fill_1
XTAP_TAPCELL_ROW_10_224 VGND VPWR sky130_fd_sc_hd__tapvpwrvgnd_1
XFILLER_0_30_192 VGND VGND VPWR VPWR sky130_fd_sc_hd__decap_4
XFILLER_0_30_170 VGND VGND VPWR VPWR sky130_fd_sc_hd__fill_1
XFILLER_0_38_292 VPWR VGND VPWR VGND sky130_ef_sc_hd__decap_12
XFILLER_0_5_337 VPWR VGND VPWR VGND sky130_ef_sc_hd__decap_12
Xaccumulator._1752_ accumulator._0847_ accumulator._0848_ VGND VGND VPWR VPWR accumulator._0849_
+ sky130_fd_sc_hd__nor2_1
Xaccumulator._1821_ accumulator._0605_ VGND VGND VPWR VPWR accumulator._0918_ sky130_fd_sc_hd__buf_2
Xaccumulator._1683_ accumulator._0775_ accumulator._0778_ VGND VGND VPWR VPWR accumulator._0780_
+ sky130_fd_sc_hd__nor2_1
Xaccumulator._2304_ accumulator._1111_ accumulator._1137_ accumulator._0036_ VGND
+ VGND VPWR VPWR accumulator._0238_ sky130_fd_sc_hd__mux2_1
Xrebuffer23 accumulator._0085_ VGND VGND VPWR VPWR net80 sky130_fd_sc_hd__dlygate4sd1_1
Xrebuffer34 net92 VGND VGND VPWR VPWR net91 sky130_fd_sc_hd__dlygate4sd1_1
XPHY_EDGE_ROW_16_Left_87 VGND VGND VPWR VPWR sky130_fd_sc_hd__decap_3
Xaccumulator._2097_ accumulator._1189_ accumulator._1194_ accumulator._1114_ VGND
+ VGND VPWR VPWR accumulator._1195_ sky130_fd_sc_hd__a21o_1
Xaccumulator._2166_ accumulator._0080_ accumulator._0098_ accumulator._0100_ accumulator._0089_
+ VGND VGND VPWR VPWR accumulator._0101_ sky130_fd_sc_hd__o211a_1
Xaccumulator._2235_ accumulator._0087_ accumulator._0169_ accumulator._0397_ VGND
+ VGND VPWR VPWR accumulator._0170_ sky130_fd_sc_hd__a21o_1
XFILLER_0_29_281 VGND VGND VPWR VPWR sky130_fd_sc_hd__fill_2
XTAP_TAPCELL_ROW_32_393 VGND VPWR sky130_fd_sc_hd__tapvpwrvgnd_1
XscaleAdd._740_ scaleAdd._305_ scaleAdd._295_ scaleAdd._297_ VGND VGND VPWR VPWR scaleAdd._306_
+ sky130_fd_sc_hd__o21a_1
XscaleAdd._671_ scaleAdd._242_ scaleAdd._244_ VGND VGND VPWR VPWR scaleAdd._245_ sky130_fd_sc_hd__nor2_1
XFILLER_0_50_265 VGND VGND VPWR VPWR sky130_fd_sc_hd__decap_8
XFILLER_0_10_118 VPWR VGND VPWR VGND sky130_ef_sc_hd__decap_12
Xaccumulator._2020_ accumulator._0739_ accumulator._1116_ VGND VGND VPWR VPWR accumulator._1117_
+ sky130_fd_sc_hd__xnor2_1
XFILLER_0_58_365 VGND VGND VPWR VPWR sky130_fd_sc_hd__decap_4
XFILLER_0_53_99 VGND VGND VPWR VPWR sky130_fd_sc_hd__decap_4
XFILLER_0_53_55 VGND VGND VPWR VPWR sky130_fd_sc_hd__fill_1
XTAP_TAPCELL_ROW_46_496 VGND VPWR sky130_fd_sc_hd__tapvpwrvgnd_1
XTAP_TAPCELL_ROW_21_308 VGND VPWR sky130_fd_sc_hd__tapvpwrvgnd_1
XFILLER_0_5_167 VGND VGND VPWR VPWR sky130_fd_sc_hd__fill_1
XFILLER_0_14_413 VGND VGND VPWR VPWR sky130_fd_sc_hd__decap_3
Xaccumulator._1804_ accumulator._0895_ accumulator._0899_ accumulator._0900_ accumulator._0890_
+ VGND VGND VPWR VPWR accumulator._0901_ sky130_fd_sc_hd__a31o_1
Xaccumulator._1735_ accumulator._0740_ accumulator._0757_ accumulator._0831_ accumulator._0733_
+ VGND VGND VPWR VPWR accumulator._0832_ sky130_fd_sc_hd__o211a_1
Xaccumulator._1666_ accumulator._0606_ accumulator._0762_ VGND VGND VPWR VPWR accumulator._0763_
+ sky130_fd_sc_hd__nor2_1
XFILLER_0_1_373 VPWR VGND VPWR VGND sky130_ef_sc_hd__decap_12
Xaccumulator._2218_ accumulator._0108_ accumulator._0152_ accumulator._0110_ VGND
+ VGND VPWR VPWR accumulator._0153_ sky130_fd_sc_hd__mux2_1
Xaccumulator._1597_ accumulator._0525_ accumulator._0690_ accumulator._0692_ accumulator._0693_
+ VGND VGND VPWR VPWR accumulator._0694_ sky130_fd_sc_hd__o211a_1
XTAP_TAPCELL_ROW_37_430 VGND VPWR sky130_fd_sc_hd__tapvpwrvgnd_1
XFILLER_0_64_357 VGND VGND VPWR VPWR sky130_fd_sc_hd__decap_6
Xaccumulator._2149_ accumulator._0059_ accumulator._0082_ accumulator._0035_ VGND
+ VGND VPWR VPWR accumulator._0083_ sky130_fd_sc_hd__mux2_2
XFILLER_0_17_273 VGND VGND VPWR VPWR sky130_fd_sc_hd__decap_6
XFILLER_0_2_3 VPWR VGND VPWR VGND sky130_ef_sc_hd__decap_12
XFILLER_0_59_107 VGND VGND VPWR VPWR sky130_fd_sc_hd__decap_4
XFILLER_0_55_313 VGND VGND VPWR VPWR sky130_fd_sc_hd__fill_2
XTAP_TAPCELL_ROW_43_477 VGND VPWR sky130_fd_sc_hd__tapvpwrvgnd_1
XFILLER_0_23_36 VPWR VGND VPWR VGND sky130_ef_sc_hd__decap_12
XFILLER_0_70_349 VPWR VGND VPWR VGND sky130_ef_sc_hd__decap_12
XFILLER_0_70_305 VGND VGND VPWR VPWR sky130_fd_sc_hd__decap_3
XscaleAdd._723_ operator.io_outExp\[1\] scaleAdd._289_ VGND VGND VPWR VPWR scaleAdd._290_
+ sky130_fd_sc_hd__and2_1
XFILLER_0_2_126 VGND VGND VPWR VPWR sky130_fd_sc_hd__decap_6
XscaleAdd._654_ scaleAdd._227_ scaleAdd._228_ VGND VGND VPWR VPWR scaleAdd._229_ sky130_fd_sc_hd__and2_1
XFILLER_0_11_405 VPWR VGND VPWR VGND sky130_ef_sc_hd__decap_12
Xaccumulator._1520_ accumulator._0498_ accumulator._0615_ accumulator._0616_ VGND
+ VGND VPWR VPWR accumulator._0617_ sky130_fd_sc_hd__nand3_1
XFILLER_0_23_287 VGND VGND VPWR VPWR sky130_fd_sc_hd__fill_1
XscaleAdd._585_ scaleAdd._159_ scaleAdd._161_ VGND VGND VPWR VPWR scaleAdd._162_ sky130_fd_sc_hd__xnor2_1
Xaccumulator._1451_ accumulator._0432_ accumulator._0547_ accumulator._0451_ VGND
+ VGND VPWR VPWR accumulator._0548_ sky130_fd_sc_hd__a21o_1
Xaccumulator._1382_ accumulator._0439_ accumulator._0437_ VGND VGND VPWR VPWR accumulator._0479_
+ sky130_fd_sc_hd__and2_1
Xaccumulator._2003_ accumulator._1076_ accumulator._1077_ accumulator._1054_ VGND
+ VGND VPWR VPWR accumulator._1100_ sky130_fd_sc_hd__a21o_1
XTAP_TAPCELL_ROW_34_411 VGND VPWR sky130_fd_sc_hd__tapvpwrvgnd_1
XFILLER_0_14_232 VGND VGND VPWR VPWR sky130_fd_sc_hd__decap_4
XFILLER_0_14_265 VGND VGND VPWR VPWR sky130_fd_sc_hd__decap_8
Xaccumulator._1718_ accumulator._0813_ accumulator._0814_ VGND VGND VPWR VPWR accumulator._0815_
+ sky130_fd_sc_hd__nor2_2
Xaccumulator._1649_ accumulator._0722_ accumulator._0723_ accumulator._0635_ VGND
+ VGND VPWR VPWR accumulator._0746_ sky130_fd_sc_hd__a21o_1
XFILLER_0_69_405 VPWR VGND VPWR VGND sky130_ef_sc_hd__decap_12
XPHY_EDGE_ROW_19_Left_90 VGND VGND VPWR VPWR sky130_fd_sc_hd__decap_3
XFILLER_0_64_176 VGND VGND VPWR VPWR sky130_fd_sc_hd__decap_8
XFILLER_0_64_121 VGND VGND VPWR VPWR sky130_fd_sc_hd__decap_8
XFILLER_0_9_281 VGND VGND VPWR VPWR sky130_fd_sc_hd__decap_8
XFILLER_0_9_292 VPWR VGND VPWR VGND sky130_ef_sc_hd__decap_12
XscaleAdd._370_ scaleAdd._312_ scaleAdd._303_ scaleAdd._309_ accumulator.io_inMant\[0\]
+ VGND VGND VPWR VPWR scaleAdd._315_ sky130_fd_sc_hd__a22o_1
XTAP_TAPCELL_ROW_48_514 VGND VPWR sky130_fd_sc_hd__tapvpwrvgnd_1
X_10_ accumulator.io_accOut\[10\] VGND VGND VPWR VPWR net23 sky130_fd_sc_hd__buf_1
XTAP_TAPCELL_ROW_5_191 VGND VPWR sky130_fd_sc_hd__tapvpwrvgnd_1
XFILLER_0_28_368 VPWR VGND VPWR VGND sky130_ef_sc_hd__decap_12
XFILLER_0_28_302 VGND VGND VPWR VPWR sky130_fd_sc_hd__decap_6
XFILLER_0_70_113 VPWR VGND VPWR VGND sky130_ef_sc_hd__decap_12
XFILLER_0_55_198 VGND VGND VPWR VPWR sky130_fd_sc_hd__decap_4
XFILLER_0_51_393 VPWR VGND VPWR VGND sky130_ef_sc_hd__decap_12
XFILLER_0_51_371 VPWR VGND VPWR VGND sky130_ef_sc_hd__decap_12
XscaleAdd._568_ scaleAdd._318_ scaleAdd._077_ scaleAdd._109_ scaleAdd._145_ VGND VGND
+ VPWR VPWR scaleAdd._146_ sky130_fd_sc_hd__a31o_1
XscaleAdd._637_ scaleAdd._087_ scaleAdd._099_ scaleAdd._106_ VGND VGND VPWR VPWR scaleAdd._212_
+ sky130_fd_sc_hd__and3_1
XscaleAdd._706_ scaleAdd._275_ scaleAdd._276_ scaleAdd._250_ VGND VGND VPWR VPWR scaleAdd._277_
+ sky130_fd_sc_hd__or3b_1
Xaccumulator._1503_ accumulator._0526_ accumulator._0598_ accumulator._0599_ VGND
+ VGND VPWR VPWR accumulator._0600_ sky130_fd_sc_hd__a21o_1
Xaccumulator._1434_ accumulator._0530_ VGND VGND VPWR VPWR accumulator._0531_ sky130_fd_sc_hd__clkbuf_2
XscaleAdd._499_ operator.io_outMant\[1\] scaleAdd._077_ VGND VGND VPWR VPWR scaleAdd._078_
+ sky130_fd_sc_hd__nand2_1
XFILLER_0_66_419 VGND VGND VPWR VPWR sky130_fd_sc_hd__fill_1
Xaccumulator._1296_ accumulator._0394_ VGND VGND VPWR VPWR accumulator._0395_ sky130_fd_sc_hd__buf_2
Xaccumulator._1365_ accumulator.io_inMant\[7\] accumulator.io_inMant\[8\] accumulator._0345_
+ VGND VGND VPWR VPWR accumulator._0462_ sky130_fd_sc_hd__mux2_1
XTAP_TAPCELL_ROW_19_293 VGND VPWR sky130_fd_sc_hd__tapvpwrvgnd_1
XFILLER_0_6_295 VPWR VGND VPWR VGND sky130_ef_sc_hd__decap_12
XFILLER_0_19_335 VGND VGND VPWR VPWR sky130_fd_sc_hd__fill_1
XFILLER_0_69_279 VGND VGND VPWR VPWR sky130_fd_sc_hd__fill_1
XTAP_TAPCELL_ROW_53_550 VGND VPWR sky130_fd_sc_hd__tapvpwrvgnd_1
XFILLER_0_37_132 VGND VGND VPWR VPWR sky130_fd_sc_hd__fill_2
XFILLER_0_37_110 VGND VGND VPWR VPWR sky130_fd_sc_hd__fill_2
XPHY_EDGE_ROW_4_Left_75 VGND VGND VPWR VPWR sky130_fd_sc_hd__decap_3
XFILLER_0_33_393 VGND VGND VPWR VPWR sky130_fd_sc_hd__decap_6
XFILLER_0_0_405 VPWR VGND VPWR VGND sky130_ef_sc_hd__decap_12
XscaleAdd._422_ scaleAdd._319_ scaleAdd._308_ VGND VGND VPWR VPWR scaleAdd._003_ sky130_fd_sc_hd__nand2_1
XFILLER_0_29_79 VGND VGND VPWR VPWR sky130_fd_sc_hd__fill_1
XFILLER_0_29_57 VGND VGND VPWR VPWR sky130_fd_sc_hd__decap_8
XFILLER_0_61_66 VGND VGND VPWR VPWR sky130_fd_sc_hd__fill_2
XFILLER_0_61_55 VGND VGND VPWR VPWR sky130_fd_sc_hd__fill_1
XFILLER_0_43_113 VGND VGND VPWR VPWR sky130_fd_sc_hd__fill_1
XFILLER_0_28_154 VGND VGND VPWR VPWR sky130_fd_sc_hd__fill_1
XFILLER_0_28_121 VPWR VGND VPWR VGND sky130_ef_sc_hd__decap_12
XTAP_TAPCELL_ROW_16_274 VGND VPWR sky130_fd_sc_hd__tapvpwrvgnd_1
Xaccumulator._1983_ accumulator._1079_ VGND VGND VPWR VPWR accumulator._1080_ sky130_fd_sc_hd__inv_2
XFILLER_0_24_360 VGND VGND VPWR VPWR sky130_fd_sc_hd__fill_1
XTAP_TAPCELL_ROW_8_209 VGND VPWR sky130_fd_sc_hd__tapvpwrvgnd_1
XFILLER_0_9_89 VGND VGND VPWR VPWR sky130_fd_sc_hd__fill_1
XFILLER_0_10_81 VGND VGND VPWR VPWR sky130_fd_sc_hd__decap_3
XTAP_TAPCELL_ROW_67_653 VGND VPWR sky130_fd_sc_hd__tapvpwrvgnd_1
XFILLER_0_43_3 VPWR VGND VPWR VGND sky130_ef_sc_hd__decap_12
Xaccumulator._1417_ accumulator.io_accOut\[11\] accumulator._0513_ net78 VGND VGND
+ VPWR VPWR accumulator._0514_ sky130_fd_sc_hd__mux2_1
Xaccumulator._2397_ net21 net54 VGND VGND VPWR VPWR accumulator._0329_ sky130_fd_sc_hd__nor2_1
XTAP_TAPCELL_ROW_50_531 VGND VPWR sky130_fd_sc_hd__tapvpwrvgnd_1
Xaccumulator._1279_ accumulator._0348_ accumulator._0351_ VGND VGND VPWR VPWR accumulator._0378_
+ sky130_fd_sc_hd__nand2_1
Xaccumulator._1348_ accumulator.io_inMant\[6\] accumulator.io_inMant\[7\] accumulator._0345_
+ VGND VGND VPWR VPWR accumulator._0445_ sky130_fd_sc_hd__mux2_1
XFILLER_0_19_165 VGND VGND VPWR VPWR sky130_fd_sc_hd__decap_3
XFILLER_0_34_157 VGND VGND VPWR VPWR sky130_fd_sc_hd__fill_2
XFILLER_0_15_393 VGND VGND VPWR VPWR sky130_fd_sc_hd__fill_1
XFILLER_0_31_69 VPWR VGND VPWR VGND sky130_ef_sc_hd__decap_12
XFILLER_0_31_25 VPWR VGND VPWR VGND sky130_ef_sc_hd__decap_12
XFILLER_0_21_385 VGND VGND VPWR VPWR sky130_fd_sc_hd__decap_6
XFILLER_0_0_257 VGND VGND VPWR VPWR sky130_fd_sc_hd__fill_1
XFILLER_0_0_279 VGND VGND VPWR VPWR sky130_fd_sc_hd__fill_1
XscaleAdd._405_ scaleAdd._332_ scaleAdd._345_ scaleAdd._344_ VGND VGND VPWR VPWR scaleAdd._347_
+ sky130_fd_sc_hd__o21ai_1
Xaccumulator._2251_ accumulator._0103_ accumulator._0104_ accumulator._1072_ VGND
+ VGND VPWR VPWR accumulator._0186_ sky130_fd_sc_hd__a21o_1
Xaccumulator._2320_ accumulator._1130_ accumulator._1177_ accumulator._1148_ VGND
+ VGND VPWR VPWR accumulator._0253_ sky130_fd_sc_hd__o21ai_1
XTAP_TAPCELL_ROW_64_634 VGND VPWR sky130_fd_sc_hd__tapvpwrvgnd_1
Xaccumulator._2182_ net103 accumulator._0398_ VGND VGND VPWR VPWR accumulator._0117_
+ sky130_fd_sc_hd__nand2_1
XFILLER_0_15_7 VPWR VGND VPWR VGND sky130_ef_sc_hd__decap_12
Xaccumulator._1202_ accumulator.io_inMant\[3\] accumulator.io_inMant\[2\] accumulator.io_inMant\[4\]
+ accumulator.io_inMant\[5\] VGND VGND VPWR VPWR accumulator._0045_ sky130_fd_sc_hd__or4_1
Xaccumulator._1966_ accumulator._1041_ accumulator._1046_ accumulator._1051_ VGND
+ VGND VPWR VPWR accumulator._1063_ sky130_fd_sc_hd__and3_1
XFILLER_0_8_357 VGND VGND VPWR VPWR sky130_fd_sc_hd__decap_6
XFILLER_0_16_102 VPWR VGND VPWR VGND sky130_ef_sc_hd__decap_12
Xaccumulator._1897_ accumulator._0985_ accumulator._0993_ VGND VGND VPWR VPWR accumulator._0994_
+ sky130_fd_sc_hd__xnor2_2
XFILLER_0_12_363 VGND VGND VPWR VPWR sky130_fd_sc_hd__fill_1
XTAP_TAPCELL_ROW_27_358 VGND VPWR sky130_fd_sc_hd__tapvpwrvgnd_1
XFILLER_0_47_293 VPWR VGND VPWR VGND sky130_ef_sc_hd__decap_12
XTAP_TAPCELL_ROW_10_225 VGND VPWR sky130_fd_sc_hd__tapvpwrvgnd_1
XFILLER_0_62_296 VPWR VGND VPWR VGND sky130_ef_sc_hd__decap_12
XFILLER_0_45_208 VGND VGND VPWR VPWR sky130_fd_sc_hd__decap_3
Xaccumulator._1820_ accumulator._0903_ accumulator._0909_ accumulator._0913_ accumulator._0915_
+ accumulator._0739_ VGND VGND VPWR VPWR accumulator._0917_ sky130_fd_sc_hd__a311oi_1
XFILLER_0_53_252 VGND VGND VPWR VPWR sky130_fd_sc_hd__fill_2
XFILLER_0_5_349 VPWR VGND VPWR VGND sky130_ef_sc_hd__decap_12
Xaccumulator._1682_ accumulator._0775_ accumulator._0778_ VGND VGND VPWR VPWR accumulator._0779_
+ sky130_fd_sc_hd__and2_1
Xaccumulator._1751_ accumulator.io_accOut\[14\] accumulator._0494_ accumulator._0404_
+ VGND VGND VPWR VPWR accumulator._0848_ sky130_fd_sc_hd__mux2_2
Xaccumulator._2303_ accumulator._0220_ accumulator._0221_ accumulator._0111_ VGND
+ VGND VPWR VPWR accumulator._0237_ sky130_fd_sc_hd__a21o_1
Xaccumulator._2234_ accumulator._0168_ accumulator._1139_ VGND VGND VPWR VPWR accumulator._0169_
+ sky130_fd_sc_hd__nor2_1
Xrebuffer35 accumulator._0065_ VGND VGND VPWR VPWR net92 sky130_fd_sc_hd__dlymetal6s2s_1
Xrebuffer24 net82 VGND VGND VPWR VPWR net81 sky130_fd_sc_hd__dlygate4sd1_1
Xaccumulator._2096_ accumulator._1086_ accumulator._1193_ accumulator._1081_ VGND
+ VGND VPWR VPWR accumulator._1194_ sky130_fd_sc_hd__a21bo_1
Xaccumulator._2165_ accumulator._0079_ accumulator._0099_ VGND VGND VPWR VPWR accumulator._0100_
+ sky130_fd_sc_hd__nand2_1
XFILLER_0_36_208 VGND VGND VPWR VPWR sky130_fd_sc_hd__fill_1
XFILLER_0_8_110 VPWR VGND VPWR VGND sky130_ef_sc_hd__decap_12
Xaccumulator._1949_ accumulator._0828_ accumulator._1045_ VGND VGND VPWR VPWR accumulator._1046_
+ sky130_fd_sc_hd__xor2_4
XTAP_TAPCELL_ROW_32_394 VGND VPWR sky130_fd_sc_hd__tapvpwrvgnd_1
XFILLER_0_35_241 VGND VGND VPWR VPWR sky130_fd_sc_hd__decap_3
XscaleAdd._670_ scaleAdd._219_ scaleAdd._221_ scaleAdd._243_ VGND VGND VPWR VPWR scaleAdd._244_
+ sky130_fd_sc_hd__a21o_1
XFILLER_0_50_288 VPWR VGND VPWR VGND sky130_ef_sc_hd__decap_12
XFILLER_0_37_57 VGND VGND VPWR VPWR sky130_fd_sc_hd__decap_4
XTAP_TAPCELL_ROW_46_497 VGND VPWR sky130_fd_sc_hd__tapvpwrvgnd_1
XTAP_TAPCELL_ROW_21_309 VGND VPWR sky130_fd_sc_hd__tapvpwrvgnd_1
XFILLER_0_18_219 VGND VGND VPWR VPWR sky130_fd_sc_hd__fill_2
Xaccumulator._1803_ accumulator._0885_ accumulator._0886_ VGND VGND VPWR VPWR accumulator._0900_
+ sky130_fd_sc_hd__nand2_1
XFILLER_0_5_113 VPWR VGND VPWR VGND sky130_ef_sc_hd__decap_12
Xaccumulator._1665_ accumulator._0525_ accumulator._0657_ VGND VGND VPWR VPWR accumulator._0762_
+ sky130_fd_sc_hd__nand2_1
Xaccumulator._1734_ accumulator._0740_ accumulator._0762_ VGND VGND VPWR VPWR accumulator._0831_
+ sky130_fd_sc_hd__nand2_1
Xaccumulator._1596_ accumulator._0558_ accumulator._0526_ accumulator._0647_ accumulator._0523_
+ VGND VGND VPWR VPWR accumulator._0693_ sky130_fd_sc_hd__o31a_1
XFILLER_0_1_385 VGND VGND VPWR VPWR sky130_fd_sc_hd__decap_6
XFILLER_0_68_119 VGND VGND VPWR VPWR sky130_fd_sc_hd__fill_1
XFILLER_0_49_355 VPWR VGND VPWR VGND sky130_ef_sc_hd__decap_12
XFILLER_0_49_300 VPWR VGND VPWR VGND sky130_ef_sc_hd__decap_12
Xaccumulator._2217_ accumulator._0134_ accumulator._0151_ accumulator._0061_ VGND
+ VGND VPWR VPWR accumulator._0152_ sky130_fd_sc_hd__mux2_1
XTAP_TAPCELL_ROW_37_431 VGND VPWR sky130_fd_sc_hd__tapvpwrvgnd_1
Xaccumulator._2079_ accumulator._1099_ accumulator._1175_ accumulator._1113_ VGND
+ VGND VPWR VPWR accumulator._1176_ sky130_fd_sc_hd__o21bai_1
XFILLER_0_64_369 VGND VGND VPWR VPWR sky130_fd_sc_hd__fill_1
Xaccumulator._2148_ accumulator._0994_ accumulator._0081_ accumulator._1181_ VGND
+ VGND VPWR VPWR accumulator._0082_ sky130_fd_sc_hd__mux2_1
XFILLER_0_4_190 VGND VGND VPWR VPWR sky130_fd_sc_hd__decap_6
XFILLER_0_67_152 VGND VGND VPWR VPWR sky130_fd_sc_hd__decap_4
XFILLER_0_67_141 VGND VGND VPWR VPWR sky130_fd_sc_hd__decap_6
XTAP_TAPCELL_ROW_43_478 VGND VPWR sky130_fd_sc_hd__tapvpwrvgnd_1
XFILLER_0_23_48 VGND VGND VPWR VPWR sky130_fd_sc_hd__fill_2
XscaleAdd._722_ scaleAdd._281_ scaleAdd._288_ VGND VGND VPWR VPWR scaleAdd._289_ sky130_fd_sc_hd__xor2_1
XFILLER_0_2_138 VGND VGND VPWR VPWR sky130_fd_sc_hd__fill_2
XFILLER_0_2_116 VGND VGND VPWR VPWR sky130_fd_sc_hd__decap_3
XscaleAdd._653_ scaleAdd._204_ scaleAdd._208_ scaleAdd._226_ scaleAdd._205_ VGND VGND
+ VPWR VPWR scaleAdd._228_ sky130_fd_sc_hd__o211ai_1
XscaleAdd._584_ scaleAdd._003_ scaleAdd._128_ scaleAdd._129_ scaleAdd._160_ VGND VGND
+ VPWR VPWR scaleAdd._161_ sky130_fd_sc_hd__a2bb2o_1
Xrebuffer4 accumulator._0356_ VGND VGND VPWR VPWR net61 sky130_fd_sc_hd__dlymetal6s2s_1
Xaccumulator._1450_ accumulator.io_accOut\[7\] accumulator._0546_ accumulator._0393_
+ VGND VGND VPWR VPWR accumulator._0547_ sky130_fd_sc_hd__mux2_1
XFILLER_0_58_141 VGND VGND VPWR VPWR sky130_fd_sc_hd__fill_1
Xaccumulator._1381_ accumulator._0432_ VGND VGND VPWR VPWR accumulator._0478_ sky130_fd_sc_hd__buf_6
Xaccumulator._2002_ accumulator._1092_ accumulator._1098_ VGND VGND VPWR VPWR accumulator._1099_
+ sky130_fd_sc_hd__xnor2_2
XFILLER_0_58_185 VGND VGND VPWR VPWR sky130_fd_sc_hd__decap_8
XFILLER_0_69_417 VGND VGND VPWR VPWR sky130_fd_sc_hd__decap_4
Xaccumulator._1648_ accumulator._0743_ accumulator._0744_ VGND VGND VPWR VPWR accumulator._0745_
+ sky130_fd_sc_hd__nand2_1
Xaccumulator._1717_ accumulator._0811_ accumulator._0812_ VGND VGND VPWR VPWR accumulator._0814_
+ sky130_fd_sc_hd__nor2_1
Xaccumulator._1579_ accumulator._0661_ accumulator._0674_ accumulator._0675_ VGND
+ VGND VPWR VPWR accumulator._0676_ sky130_fd_sc_hd__a21o_1
XFILLER_0_64_155 VGND VGND VPWR VPWR sky130_fd_sc_hd__decap_4
XFILLER_0_18_26 VGND VGND VPWR VPWR sky130_fd_sc_hd__fill_2
XTAP_TAPCELL_ROW_56_570 VGND VPWR sky130_fd_sc_hd__tapvpwrvgnd_1
XTAP_TAPCELL_ROW_48_515 VGND VPWR sky130_fd_sc_hd__tapvpwrvgnd_1
XTAP_TAPCELL_ROW_5_192 VGND VPWR sky130_fd_sc_hd__tapvpwrvgnd_1
XFILLER_0_70_125 VPWR VGND VPWR VGND sky130_ef_sc_hd__decap_12
XFILLER_0_43_328 VGND VGND VPWR VPWR sky130_fd_sc_hd__fill_1
XscaleAdd._705_ scaleAdd._266_ scaleAdd._268_ VGND VGND VPWR VPWR scaleAdd._276_ sky130_fd_sc_hd__nor2_1
XFILLER_0_70_169 VPWR VGND VPWR VGND sky130_ef_sc_hd__decap_12
XFILLER_0_59_77 VGND VGND VPWR VPWR sky130_fd_sc_hd__fill_2
XFILLER_0_59_55 VGND VGND VPWR VPWR sky130_fd_sc_hd__fill_1
XFILLER_0_51_383 VGND VGND VPWR VPWR sky130_fd_sc_hd__decap_8
XscaleAdd._567_ scaleAdd._079_ scaleAdd._108_ VGND VGND VPWR VPWR scaleAdd._145_ sky130_fd_sc_hd__nor2_1
XscaleAdd._636_ scaleAdd._312_ scaleAdd._140_ VGND VGND VPWR VPWR scaleAdd._211_ sky130_fd_sc_hd__nand2_1
XFILLER_0_11_225 VPWR VGND VPWR VGND sky130_ef_sc_hd__decap_12
Xaccumulator._1502_ accumulator._0501_ VGND VGND VPWR VPWR accumulator._0599_ sky130_fd_sc_hd__buf_2
Xaccumulator._1433_ accumulator._0402_ accumulator._0431_ VGND VGND VPWR VPWR accumulator._0530_
+ sky130_fd_sc_hd__and2_1
XscaleAdd._498_ scaleAdd._060_ scaleAdd._061_ VGND VGND VPWR VPWR scaleAdd._077_ sky130_fd_sc_hd__or2_1
Xaccumulator._1295_ accumulator._0393_ VGND VGND VPWR VPWR accumulator._0394_ sky130_fd_sc_hd__buf_6
XPHY_EDGE_ROW_20_Left_91 VGND VGND VPWR VPWR sky130_fd_sc_hd__decap_3
XTAP_TAPCELL_ROW_19_294 VGND VPWR sky130_fd_sc_hd__tapvpwrvgnd_1
Xaccumulator._1364_ accumulator._0459_ accumulator._0460_ accumulator._0215_ VGND
+ VGND VPWR VPWR accumulator._0461_ sky130_fd_sc_hd__mux2_1
XFILLER_0_6_230 VGND VGND VPWR VPWR sky130_fd_sc_hd__decap_4
XFILLER_0_6_241 VGND VGND VPWR VPWR sky130_fd_sc_hd__decap_4
XFILLER_0_69_225 VGND VGND VPWR VPWR sky130_fd_sc_hd__decap_8
XTAP_TAPCELL_ROW_53_551 VGND VPWR sky130_fd_sc_hd__tapvpwrvgnd_1
XFILLER_0_40_309 VPWR VGND VPWR VGND sky130_ef_sc_hd__decap_12
XscaleAdd._421_ net16 net15 net9 VGND VGND VPWR VPWR scaleAdd._002_ sky130_fd_sc_hd__o21a_4
XFILLER_0_0_417 VGND VGND VPWR VPWR sky130_fd_sc_hd__decap_3
XFILLER_0_45_57 VGND VGND VPWR VPWR sky130_fd_sc_hd__fill_2
XFILLER_0_28_133 VGND VGND VPWR VPWR sky130_fd_sc_hd__decap_6
XFILLER_0_0_15 VPWR VGND VPWR VGND sky130_ef_sc_hd__decap_12
XTAP_TAPCELL_ROW_16_275 VGND VPWR sky130_fd_sc_hd__tapvpwrvgnd_1
Xaccumulator._1982_ accumulator._1076_ accumulator._1078_ VGND VGND VPWR VPWR accumulator._1079_
+ sky130_fd_sc_hd__xor2_1
XFILLER_0_43_169 VGND VGND VPWR VPWR sky130_fd_sc_hd__decap_4
XFILLER_0_3_222 VGND VGND VPWR VPWR sky130_fd_sc_hd__fill_2
XscaleAdd._619_ scaleAdd._190_ scaleAdd._194_ VGND VGND VPWR VPWR scaleAdd._195_ sky130_fd_sc_hd__xnor2_2
XFILLER_0_10_60 VGND VGND VPWR VPWR sky130_fd_sc_hd__decap_4
XTAP_TAPCELL_ROW_67_654 VGND VPWR sky130_fd_sc_hd__tapvpwrvgnd_1
XFILLER_0_36_3 VPWR VGND VPWR VGND sky130_ef_sc_hd__decap_12
Xaccumulator._1416_ accumulator._0453_ accumulator._0512_ VGND VGND VPWR VPWR accumulator._0513_
+ sky130_fd_sc_hd__and2_1
Xaccumulator._2396_ accumulator._0398_ accumulator._0326_ accumulator._0327_ accumulator._0328_
+ VGND VGND VPWR VPWR accumulator._0032_ sky130_fd_sc_hd__o31a_1
Xaccumulator._1347_ accumulator.io_inMant\[4\] accumulator.io_inMant\[5\] accumulator._0436_
+ VGND VGND VPWR VPWR accumulator._0444_ sky130_fd_sc_hd__mux2_1
XFILLER_0_34_125 VGND VGND VPWR VPWR sky130_fd_sc_hd__fill_2
Xaccumulator._1278_ accumulator._0375_ accumulator._0368_ accumulator._0376_ VGND
+ VGND VPWR VPWR accumulator._0377_ sky130_fd_sc_hd__a21o_4
XFILLER_0_19_100 VPWR VGND VPWR VGND sky130_ef_sc_hd__decap_12
XFILLER_0_19_155 VGND VGND VPWR VPWR sky130_fd_sc_hd__fill_1
XFILLER_0_42_180 VGND VGND VPWR VPWR sky130_fd_sc_hd__decap_4
XFILLER_0_30_342 VPWR VGND VPWR VGND sky130_ef_sc_hd__decap_12
XFILLER_0_31_37 VPWR VGND VPWR VGND sky130_ef_sc_hd__decap_12
XFILLER_0_25_169 VGND VGND VPWR VPWR sky130_fd_sc_hd__decap_3
XFILLER_0_25_136 VPWR VGND VPWR VGND sky130_ef_sc_hd__decap_12
XFILLER_0_0_225 VPWR VGND VPWR VGND sky130_ef_sc_hd__decap_12
XscaleAdd._404_ scaleAdd._332_ scaleAdd._344_ scaleAdd._345_ VGND VGND VPWR VPWR scaleAdd._346_
+ sky130_fd_sc_hd__or3_1
XTAP_TAPCELL_ROW_64_635 VGND VPWR sky130_fd_sc_hd__tapvpwrvgnd_1
Xaccumulator._2250_ accumulator._0128_ accumulator._0112_ accumulator._0169_ accumulator._0397_
+ VGND VGND VPWR VPWR accumulator._0184_ sky130_fd_sc_hd__a31o_1
Xaccumulator._1201_ accumulator.io_inMant\[6\] accumulator.io_inMant\[7\] accumulator.io_inMant\[8\]
+ accumulator.io_inMant\[9\] VGND VGND VPWR VPWR accumulator._0034_ sky130_fd_sc_hd__or4_1
Xaccumulator._2181_ accumulator._0114_ accumulator._0115_ accumulator._0093_ VGND
+ VGND VPWR VPWR accumulator._0008_ sky130_fd_sc_hd__o21a_1
XFILLER_0_16_114 VPWR VGND VPWR VGND sky130_ef_sc_hd__decap_12
Xaccumulator._1965_ accumulator._0871_ accumulator._1061_ VGND VGND VPWR VPWR accumulator._1062_
+ sky130_fd_sc_hd__xnor2_2
XFILLER_0_21_92 VGND VGND VPWR VPWR sky130_fd_sc_hd__decap_3
Xaccumulator._1896_ accumulator._0986_ accumulator._0991_ accumulator._0992_ VGND
+ VGND VPWR VPWR accumulator._0993_ sky130_fd_sc_hd__a21oi_2
Xaccumulator._2379_ accumulator._0306_ accumulator._0041_ accumulator._0292_ VGND
+ VGND VPWR VPWR accumulator._0311_ sky130_fd_sc_hd__nor3b_1
XPHY_EDGE_ROW_33_Left_104 VGND VGND VPWR VPWR sky130_fd_sc_hd__decap_3
XFILLER_0_7_391 VGND VGND VPWR VPWR sky130_fd_sc_hd__fill_1
XTAP_TAPCELL_ROW_10_226 VGND VPWR sky130_fd_sc_hd__tapvpwrvgnd_1
XPHY_EDGE_ROW_42_Left_113 VGND VGND VPWR VPWR sky130_fd_sc_hd__decap_3
XPHY_EDGE_ROW_51_Left_122 VGND VGND VPWR VPWR sky130_fd_sc_hd__decap_3
Xaccumulator._1750_ accumulator._0846_ VGND VGND VPWR VPWR accumulator._0847_ sky130_fd_sc_hd__inv_2
XFILLER_0_67_55 VGND VGND VPWR VPWR sky130_fd_sc_hd__fill_1
XPHY_EDGE_ROW_60_Left_131 VGND VGND VPWR VPWR sky130_fd_sc_hd__decap_3
Xaccumulator._1681_ accumulator.io_accOut\[3\] accumulator._0394_ VGND VGND VPWR VPWR
+ accumulator._0778_ sky130_fd_sc_hd__nand2_1
XFILLER_0_6_47 VGND VGND VPWR VPWR sky130_fd_sc_hd__fill_1
Xrebuffer36 accumulator._0963_ VGND VGND VPWR VPWR net93 sky130_fd_sc_hd__dlygate4sd3_1
Xaccumulator._2233_ accumulator._0998_ accumulator._1025_ accumulator._1087_ VGND
+ VGND VPWR VPWR accumulator._0168_ sky130_fd_sc_hd__o21ai_1
Xaccumulator._2164_ accumulator._0086_ accumulator._0072_ accumulator._0053_ VGND
+ VGND VPWR VPWR accumulator._0099_ sky130_fd_sc_hd__or3b_1
Xaccumulator._2302_ accumulator._0406_ accumulator._0041_ VGND VGND VPWR VPWR accumulator._0236_
+ sky130_fd_sc_hd__nand2_1
Xrebuffer25 net83 VGND VGND VPWR VPWR net82 sky130_fd_sc_hd__dlygate4sd1_1
Xrebuffer14 scaleAdd._106_ VGND VGND VPWR VPWR net71 sky130_fd_sc_hd__buf_2
XFILLER_0_20_6 VGND VGND VPWR VPWR sky130_fd_sc_hd__decap_4
Xaccumulator._2095_ accumulator._1057_ accumulator._1192_ VGND VGND VPWR VPWR accumulator._1193_
+ sky130_fd_sc_hd__nand2_1
XFILLER_0_44_242 VGND VGND VPWR VPWR sky130_fd_sc_hd__decap_8
XTAP_TAPCELL_ROW_32_395 VGND VPWR sky130_fd_sc_hd__tapvpwrvgnd_1
XFILLER_0_29_261 VGND VGND VPWR VPWR sky130_fd_sc_hd__fill_1
XTAP_TAPCELL_ROW_24_329 VGND VPWR sky130_fd_sc_hd__tapvpwrvgnd_1
XFILLER_0_8_122 VGND VGND VPWR VPWR sky130_fd_sc_hd__decap_8
Xaccumulator._1948_ accumulator._1042_ accumulator._1043_ accumulator._0918_ accumulator._1044_
+ VGND VGND VPWR VPWR accumulator._1045_ sky130_fd_sc_hd__a2bb2o_2
Xaccumulator._1879_ accumulator._0972_ accumulator._0975_ VGND VGND VPWR VPWR accumulator._0976_
+ sky130_fd_sc_hd__and2_1
XFILLER_0_50_201 VGND VGND VPWR VPWR sky130_fd_sc_hd__fill_1
XFILLER_0_2_309 VPWR VGND VPWR VGND sky130_ef_sc_hd__decap_12
Xoutput50 net50 VGND VGND VPWR VPWR io_accOut[6] sky130_fd_sc_hd__buf_2
XFILLER_0_58_323 VGND VGND VPWR VPWR sky130_fd_sc_hd__fill_2
XFILLER_0_53_57 VPWR VGND VPWR VGND sky130_ef_sc_hd__decap_12
XTAP_TAPCELL_ROW_46_498 VGND VPWR sky130_fd_sc_hd__tapvpwrvgnd_1
XFILLER_0_5_125 VGND VGND VPWR VPWR sky130_fd_sc_hd__decap_6
XFILLER_0_5_103 VGND VGND VPWR VPWR sky130_fd_sc_hd__decap_8
Xaccumulator._1802_ accumulator._0887_ accumulator._0898_ VGND VGND VPWR VPWR accumulator._0899_
+ sky130_fd_sc_hd__or2_1
Xaccumulator._1733_ accumulator._0819_ accumulator._0821_ VGND VGND VPWR VPWR accumulator._0830_
+ sky130_fd_sc_hd__nor2_1
XFILLER_0_41_278 VGND VGND VPWR VPWR sky130_fd_sc_hd__fill_2
XFILLER_0_41_223 VGND VGND VPWR VPWR sky130_fd_sc_hd__fill_1
XFILLER_0_5_169 VPWR VGND VPWR VGND sky130_ef_sc_hd__decap_12
Xaccumulator._1664_ accumulator._0525_ accumulator._0759_ accumulator._0760_ VGND
+ VGND VPWR VPWR accumulator._0761_ sky130_fd_sc_hd__a21o_1
Xaccumulator._1595_ accumulator._0539_ accumulator._0427_ accumulator._0611_ accumulator._0691_
+ VGND VGND VPWR VPWR accumulator._0692_ sky130_fd_sc_hd__or4_1
Xclkbuf_2_3__f_clock clknet_0_clock VGND VGND VPWR VPWR clknet_2_3__leaf_clock sky130_fd_sc_hd__clkbuf_16
XFILLER_0_64_326 VGND VGND VPWR VPWR sky130_fd_sc_hd__fill_1
Xaccumulator._2216_ accumulator._1039_ accumulator._1056_ net69 VGND VGND VPWR VPWR
+ accumulator._0151_ sky130_fd_sc_hd__mux2_2
Xaccumulator._2147_ accumulator._1010_ VGND VGND VPWR VPWR accumulator._0081_ sky130_fd_sc_hd__inv_2
XFILLER_0_49_367 VGND VGND VPWR VPWR sky130_fd_sc_hd__decap_8
XFILLER_0_49_312 VGND VGND VPWR VPWR sky130_fd_sc_hd__decap_3
XTAP_TAPCELL_ROW_37_432 VGND VPWR sky130_fd_sc_hd__tapvpwrvgnd_1
Xaccumulator._2078_ accumulator._1079_ accumulator._1174_ accumulator._1101_ VGND
+ VGND VPWR VPWR accumulator._1175_ sky130_fd_sc_hd__a21oi_1
XFILLER_0_7_90 VGND VGND VPWR VPWR sky130_fd_sc_hd__fill_1
XFILLER_0_55_337 VGND VGND VPWR VPWR sky130_fd_sc_hd__decap_8
XscaleAdd._721_ scaleAdd._286_ scaleAdd._287_ VGND VGND VPWR VPWR scaleAdd._288_ sky130_fd_sc_hd__nand2_1
XscaleAdd._652_ scaleAdd._180_ scaleAdd._207_ scaleAdd._205_ scaleAdd._226_ scaleAdd._204_
+ VGND VGND VPWR VPWR scaleAdd._227_ sky130_fd_sc_hd__a311o_1
XscaleAdd._583_ scaleAdd._091_ VGND VGND VPWR VPWR scaleAdd._160_ sky130_fd_sc_hd__inv_2
Xrebuffer5 net61 VGND VGND VPWR VPWR net62 sky130_fd_sc_hd__dlygate4sd1_1
Xaccumulator._1380_ accumulator._0452_ accumulator._0470_ accumulator._0476_ VGND
+ VGND VPWR VPWR accumulator._0477_ sky130_fd_sc_hd__a21o_1
XFILLER_0_3_15 VGND VGND VPWR VPWR sky130_fd_sc_hd__fill_1
Xaccumulator._2001_ accumulator._1054_ accumulator._1097_ VGND VGND VPWR VPWR accumulator._1098_
+ sky130_fd_sc_hd__nor2_1
XFILLER_0_58_197 VPWR VGND VPWR VGND sky130_ef_sc_hd__decap_12
XFILLER_0_46_337 VGND VGND VPWR VPWR sky130_fd_sc_hd__fill_1
XFILLER_0_6_401 VPWR VGND VPWR VGND sky130_ef_sc_hd__decap_12
XFILLER_0_66_3 VPWR VGND VPWR VGND sky130_ef_sc_hd__decap_12
Xaccumulator._1716_ accumulator._0811_ accumulator._0812_ VGND VGND VPWR VPWR accumulator._0813_
+ sky130_fd_sc_hd__and2_1
XFILLER_0_1_183 VPWR VGND VPWR VGND sky130_ef_sc_hd__decap_12
Xaccumulator._1578_ accumulator.io_accOut\[0\] accumulator._0394_ VGND VGND VPWR VPWR
+ accumulator._0675_ sky130_fd_sc_hd__nand2_1
Xaccumulator._1647_ accumulator.io_accOut\[8\] accumulator._0541_ accumulator._0403_
+ VGND VGND VPWR VPWR accumulator._0744_ sky130_fd_sc_hd__mux2_1
XFILLER_0_64_134 VGND VGND VPWR VPWR sky130_fd_sc_hd__decap_3
XFILLER_0_52_318 VGND VGND VPWR VPWR sky130_fd_sc_hd__fill_1
XFILLER_0_49_175 VGND VGND VPWR VPWR sky130_fd_sc_hd__fill_2
XTAP_TAPCELL_ROW_40_449 VGND VPWR sky130_fd_sc_hd__tapvpwrvgnd_1
XFILLER_0_37_337 VGND VGND VPWR VPWR sky130_fd_sc_hd__decap_6
XFILLER_0_37_304 VGND VGND VPWR VPWR sky130_fd_sc_hd__decap_4
XFILLER_0_60_351 VGND VGND VPWR VPWR sky130_fd_sc_hd__decap_8
XTAP_TAPCELL_ROW_48_516 VGND VPWR sky130_fd_sc_hd__tapvpwrvgnd_1
XFILLER_0_20_259 VGND VGND VPWR VPWR sky130_fd_sc_hd__decap_8
XTAP_TAPCELL_ROW_56_571 VGND VPWR sky130_fd_sc_hd__tapvpwrvgnd_1
XFILLER_0_55_101 VGND VGND VPWR VPWR sky130_fd_sc_hd__decap_8
XFILLER_0_34_15 VPWR VGND VPWR VGND sky130_ef_sc_hd__decap_12
XTAP_TAPCELL_ROW_5_193 VGND VPWR sky130_fd_sc_hd__tapvpwrvgnd_1
XPHY_EDGE_ROW_16_Right_16 VGND VGND VPWR VPWR sky130_fd_sc_hd__decap_3
XFILLER_0_70_137 VGND VGND VPWR VPWR sky130_fd_sc_hd__decap_3
XPHY_EDGE_ROW_25_Right_25 VGND VGND VPWR VPWR sky130_fd_sc_hd__decap_3
XscaleAdd._635_ scaleAdd._318_ scaleAdd._195_ VGND VGND VPWR VPWR scaleAdd._210_ sky130_fd_sc_hd__nand2_1
XscaleAdd._704_ scaleAdd._216_ scaleAdd._251_ VGND VGND VPWR VPWR scaleAdd._275_ sky130_fd_sc_hd__and2_1
XscaleAdd._566_ scaleAdd._124_ scaleAdd._143_ VGND VGND VPWR VPWR scaleAdd._144_ sky130_fd_sc_hd__xnor2_1
XscaleAdd._497_ operator.io_outMant\[2\] scaleAdd._025_ VGND VGND VPWR VPWR scaleAdd._076_
+ sky130_fd_sc_hd__nand2_1
XFILLER_0_11_237 VGND VGND VPWR VPWR sky130_fd_sc_hd__decap_6
Xaccumulator._1432_ accumulator._0527_ accumulator._0528_ VGND VGND VPWR VPWR accumulator._0529_
+ sky130_fd_sc_hd__nand2_1
XPHY_EDGE_ROW_34_Right_34 VGND VGND VPWR VPWR sky130_fd_sc_hd__decap_3
Xaccumulator._1501_ accumulator._0543_ accumulator._0536_ accumulator._0592_ accumulator._0597_
+ VGND VGND VPWR VPWR accumulator._0598_ sky130_fd_sc_hd__a31o_1
Xaccumulator._1363_ accumulator.io_inMant\[5\] accumulator.io_inMant\[6\] accumulator._0345_
+ VGND VGND VPWR VPWR accumulator._0460_ sky130_fd_sc_hd__mux2_1
Xaccumulator._1294_ accumulator.io_accOut\[30\] accumulator._0392_ VGND VGND VPWR
+ VPWR accumulator._0393_ sky130_fd_sc_hd__xnor2_2
XTAP_TAPCELL_ROW_19_295 VGND VPWR sky130_fd_sc_hd__tapvpwrvgnd_1
XFILLER_0_19_337 VGND VGND VPWR VPWR sky130_fd_sc_hd__decap_4
XFILLER_0_61_126 VGND VGND VPWR VPWR sky130_fd_sc_hd__fill_1
XFILLER_0_46_189 VGND VGND VPWR VPWR sky130_fd_sc_hd__decap_6
XFILLER_0_46_178 VGND VGND VPWR VPWR sky130_fd_sc_hd__decap_3
XPHY_EDGE_ROW_43_Right_43 VGND VGND VPWR VPWR sky130_fd_sc_hd__decap_3
XFILLER_0_42_395 VPWR VGND VPWR VGND sky130_ef_sc_hd__decap_12
XFILLER_0_42_373 VPWR VGND VPWR VGND sky130_ef_sc_hd__decap_12
XFILLER_0_6_253 VGND VGND VPWR VPWR sky130_fd_sc_hd__decap_4
XFILLER_0_6_264 VPWR VGND VPWR VGND sky130_ef_sc_hd__decap_12
XFILLER_0_6_286 VGND VGND VPWR VPWR sky130_fd_sc_hd__decap_6
XPHY_EDGE_ROW_52_Right_52 VGND VGND VPWR VPWR sky130_fd_sc_hd__decap_3
XFILLER_0_10_292 VPWR VGND VPWR VGND sky130_ef_sc_hd__decap_12
XFILLER_0_69_248 VPWR VGND VPWR VGND sky130_ef_sc_hd__decap_12
Xoperator._19_ net2 net3 net6 net7 VGND VGND VPWR VPWR operator._04_ sky130_fd_sc_hd__a22oi_1
XFILLER_0_4_80 VGND VGND VPWR VPWR sky130_fd_sc_hd__decap_4
XPHY_EDGE_ROW_61_Right_61 VGND VGND VPWR VPWR sky130_fd_sc_hd__decap_3
XTAP_TAPCELL_ROW_53_552 VGND VPWR sky130_fd_sc_hd__tapvpwrvgnd_1
XPHY_EDGE_ROW_70_Right_70 VGND VGND VPWR VPWR sky130_fd_sc_hd__decap_3
XscaleAdd._420_ scaleAdd._346_ scaleAdd._349_ VGND VGND VPWR VPWR scaleAdd._001_ sky130_fd_sc_hd__and2_1
XFILLER_0_68_292 VGND VGND VPWR VPWR sky130_fd_sc_hd__fill_1
XFILLER_0_61_57 VGND VGND VPWR VPWR sky130_fd_sc_hd__decap_3
XFILLER_0_0_27 VGND VGND VPWR VPWR sky130_fd_sc_hd__fill_1
XFILLER_0_16_307 VGND VGND VPWR VPWR sky130_fd_sc_hd__fill_1
XTAP_TAPCELL_ROW_16_276 VGND VPWR sky130_fd_sc_hd__tapvpwrvgnd_1
Xaccumulator._1981_ accumulator._1054_ accumulator._1077_ VGND VGND VPWR VPWR accumulator._1078_
+ sky130_fd_sc_hd__nor2_1
XFILLER_0_43_159 VGND VGND VPWR VPWR sky130_fd_sc_hd__decap_8
XFILLER_0_24_384 VGND VGND VPWR VPWR sky130_fd_sc_hd__decap_8
XFILLER_0_3_201 VGND VGND VPWR VPWR sky130_fd_sc_hd__decap_6
XscaleAdd._618_ scaleAdd._191_ scaleAdd._193_ VGND VGND VPWR VPWR scaleAdd._194_ sky130_fd_sc_hd__xor2_1
XFILLER_0_9_25 VPWR VGND VPWR VGND sky130_ef_sc_hd__decap_12
XFILLER_0_9_47 VGND VGND VPWR VPWR sky130_fd_sc_hd__decap_4
XFILLER_0_16_329 VPWR VGND VPWR VGND sky130_ef_sc_hd__decap_12
XscaleAdd._549_ scaleAdd._014_ scaleAdd._083_ scaleAdd._088_ scaleAdd._090_ VGND VGND
+ VPWR VPWR scaleAdd._127_ sky130_fd_sc_hd__nor4_1
XFILLER_0_10_94 VPWR VGND VPWR VGND sky130_ef_sc_hd__decap_12
XTAP_TAPCELL_ROW_67_655 VGND VPWR sky130_fd_sc_hd__tapvpwrvgnd_1
Xaccumulator._1415_ accumulator._0479_ accumulator._0480_ accumulator._0263_ VGND
+ VGND VPWR VPWR accumulator._0512_ sky130_fd_sc_hd__mux2_1
Xaccumulator._2395_ accumulator.io_accOut\[30\] accumulator._0167_ accumulator._0400_
+ VGND VGND VPWR VPWR accumulator._0328_ sky130_fd_sc_hd__o21a_1
Xaccumulator._1346_ accumulator._0441_ accumulator._0442_ accumulator._0439_ VGND
+ VGND VPWR VPWR accumulator._0443_ sky130_fd_sc_hd__mux2_1
Xaccumulator._1277_ accumulator.io_accOut\[25\] accumulator._0367_ VGND VGND VPWR
+ VPWR accumulator._0376_ sky130_fd_sc_hd__and2_1
XFILLER_0_30_365 VPWR VGND VPWR VGND sky130_ef_sc_hd__decap_12
XFILLER_0_30_354 VGND VGND VPWR VPWR sky130_fd_sc_hd__decap_8
XFILLER_0_15_384 VGND VGND VPWR VPWR sky130_fd_sc_hd__decap_8
XFILLER_0_40_129 VGND VGND VPWR VPWR sky130_fd_sc_hd__decap_8
XFILLER_0_31_49 VGND VGND VPWR VPWR sky130_fd_sc_hd__decap_6
XFILLER_0_25_148 VGND VGND VPWR VPWR sky130_fd_sc_hd__decap_3
XFILLER_0_0_237 VPWR VGND VPWR VGND sky130_ef_sc_hd__decap_12
XscaleAdd._403_ scaleAdd._316_ scaleAdd._308_ VGND VGND VPWR VPWR scaleAdd._345_ sky130_fd_sc_hd__and2_1
XTAP_TAPCELL_ROW_64_636 VGND VPWR sky130_fd_sc_hd__tapvpwrvgnd_1
XFILLER_0_56_68 VGND VGND VPWR VPWR sky130_fd_sc_hd__decap_3
XFILLER_0_48_218 VPWR VGND VPWR VGND sky130_ef_sc_hd__decap_12
Xaccumulator._2180_ accumulator.io_accOut\[6\] accumulator._0091_ VGND VGND VPWR VPWR
+ accumulator._0115_ sky130_fd_sc_hd__and2_1
Xaccumulator._1200_ accumulator._1178_ VGND VGND VPWR VPWR net54 sky130_fd_sc_hd__clkbuf_1
XFILLER_0_56_295 VGND VGND VPWR VPWR sky130_fd_sc_hd__decap_4
XFILLER_0_56_251 VGND VGND VPWR VPWR sky130_fd_sc_hd__fill_1
XFILLER_0_16_126 VGND VGND VPWR VPWR sky130_fd_sc_hd__decap_6
Xaccumulator._1964_ accumulator._0919_ accumulator._0946_ accumulator._1059_ accumulator._1060_
+ VGND VGND VPWR VPWR accumulator._1061_ sky130_fd_sc_hd__a31o_1
Xaccumulator._1895_ accumulator._0969_ VGND VGND VPWR VPWR accumulator._0992_ sky130_fd_sc_hd__buf_6
XFILLER_0_21_82 VGND VGND VPWR VPWR sky130_fd_sc_hd__decap_6
XFILLER_0_12_321 VPWR VGND VPWR VGND sky130_ef_sc_hd__decap_12
XFILLER_0_12_365 VPWR VGND VPWR VGND sky130_ef_sc_hd__decap_12
XPHY_EDGE_ROW_2_Right_2 VGND VGND VPWR VPWR sky130_fd_sc_hd__decap_3
XFILLER_0_46_90 VGND VGND VPWR VPWR sky130_fd_sc_hd__decap_6
Xaccumulator._1329_ accumulator._0402_ accumulator._0415_ VGND VGND VPWR VPWR accumulator._0426_
+ sky130_fd_sc_hd__nand2_2
Xaccumulator._2378_ accumulator._0398_ accumulator._0309_ accumulator._0310_ accumulator._0177_
+ VGND VGND VPWR VPWR accumulator._0030_ sky130_fd_sc_hd__o211a_1
XTAP_TAPCELL_ROW_10_227 VGND VPWR sky130_fd_sc_hd__tapvpwrvgnd_1
Xhold50 accumulator.io_accOut\[23\] VGND VGND VPWR VPWR net107 sky130_fd_sc_hd__dlygate4sd3_1
XFILLER_0_42_15 VPWR VGND VPWR VGND sky130_ef_sc_hd__decap_12
XFILLER_0_38_273 VPWR VGND VPWR VGND sky130_ef_sc_hd__decap_12
XFILLER_0_53_265 VGND VGND VPWR VPWR sky130_fd_sc_hd__fill_1
XFILLER_0_41_416 VGND VGND VPWR VPWR sky130_fd_sc_hd__fill_1
XFILLER_0_21_140 VGND VGND VPWR VPWR sky130_fd_sc_hd__decap_6
XFILLER_0_6_15 VPWR VGND VPWR VGND sky130_ef_sc_hd__decap_12
Xaccumulator._1680_ accumulator._0602_ accumulator._0603_ VGND VGND VPWR VPWR accumulator._0777_
+ sky130_fd_sc_hd__nor2_1
Xaccumulator._2301_ accumulator._0080_ accumulator._0084_ accumulator._0088_ VGND
+ VGND VPWR VPWR accumulator._0235_ sky130_fd_sc_hd__o21a_1
Xaccumulator._2094_ accumulator._1143_ accumulator._1191_ accumulator._1040_ VGND
+ VGND VPWR VPWR accumulator._1192_ sky130_fd_sc_hd__a21bo_1
Xaccumulator._2163_ accumulator._0049_ accumulator._0097_ accumulator._1149_ VGND
+ VGND VPWR VPWR accumulator._0098_ sky130_fd_sc_hd__mux2_4
Xaccumulator._2232_ accumulator._0406_ VGND VGND VPWR VPWR accumulator._0167_ sky130_fd_sc_hd__buf_2
Xrebuffer26 net84 VGND VGND VPWR VPWR net83 sky130_fd_sc_hd__dlygate4sd1_1
XFILLER_0_16_93 VGND VGND VPWR VPWR sky130_fd_sc_hd__fill_2
XFILLER_0_44_221 VGND VGND VPWR VPWR sky130_fd_sc_hd__decap_8
XTAP_TAPCELL_ROW_32_396 VGND VPWR sky130_fd_sc_hd__tapvpwrvgnd_1
Xaccumulator._1947_ accumulator._0926_ accumulator._0943_ VGND VGND VPWR VPWR accumulator._1044_
+ sky130_fd_sc_hd__and2_1
Xaccumulator._1878_ accumulator._0728_ accumulator._0974_ VGND VGND VPWR VPWR accumulator._0975_
+ sky130_fd_sc_hd__xnor2_1
XFILLER_0_67_335 VGND VGND VPWR VPWR sky130_fd_sc_hd__fill_1
XFILLER_0_50_279 VGND VGND VPWR VPWR sky130_fd_sc_hd__decap_6
XFILLER_0_35_254 VPWR VGND VPWR VGND sky130_ef_sc_hd__decap_12
XFILLER_0_37_15 VPWR VGND VPWR VGND sky130_ef_sc_hd__decap_12
Xoutput51 net51 VGND VGND VPWR VPWR io_accOut[7] sky130_fd_sc_hd__buf_2
Xoutput40 net40 VGND VGND VPWR VPWR io_accOut[26] sky130_fd_sc_hd__buf_2
XFILLER_0_53_69 VGND VGND VPWR VPWR sky130_fd_sc_hd__decap_4
XTAP_TAPCELL_ROW_46_499 VGND VPWR sky130_fd_sc_hd__tapvpwrvgnd_1
XFILLER_0_26_210 VGND VGND VPWR VPWR sky130_fd_sc_hd__fill_2
XFILLER_0_5_159 VGND VGND VPWR VPWR sky130_fd_sc_hd__fill_1
Xaccumulator._1732_ accumulator._0822_ accumulator._0828_ VGND VGND VPWR VPWR accumulator._0829_
+ sky130_fd_sc_hd__or2_1
Xaccumulator._1801_ accumulator._0877_ accumulator._0878_ accumulator._0897_ VGND
+ VGND VPWR VPWR accumulator._0898_ sky130_fd_sc_hd__a21oi_1
Xaccumulator._1663_ accumulator._0559_ accumulator._0662_ accumulator._0663_ accumulator._0606_
+ VGND VGND VPWR VPWR accumulator._0760_ sky130_fd_sc_hd__a31o_1
XFILLER_0_41_257 VGND VGND VPWR VPWR sky130_fd_sc_hd__fill_1
Xaccumulator._1594_ accumulator.io_accOut\[0\] accumulator._0531_ VGND VGND VPWR VPWR
+ accumulator._0691_ sky130_fd_sc_hd__nand2_1
XTAP_TAPCELL_ROW_37_433 VGND VPWR sky130_fd_sc_hd__tapvpwrvgnd_1
Xaccumulator._2077_ accumulator._1083_ accumulator._1173_ accumulator._1072_ VGND
+ VGND VPWR VPWR accumulator._1174_ sky130_fd_sc_hd__o21ai_1
XFILLER_0_64_338 VGND VGND VPWR VPWR sky130_fd_sc_hd__fill_1
Xaccumulator._2146_ accumulator._0079_ VGND VGND VPWR VPWR accumulator._0080_ sky130_fd_sc_hd__buf_2
Xaccumulator._2215_ accumulator.io_accOut\[10\] accumulator._0091_ VGND VGND VPWR
+ VPWR accumulator._0150_ sky130_fd_sc_hd__and2_1
XFILLER_0_11_3 VPWR VGND VPWR VGND sky130_ef_sc_hd__decap_12
XTAP_TAPCELL_ROW_20_300 VGND VPWR sky130_fd_sc_hd__tapvpwrvgnd_1
XFILLER_0_67_110 VGND VGND VPWR VPWR sky130_fd_sc_hd__fill_2
XFILLER_0_63_360 VGND VGND VPWR VPWR sky130_fd_sc_hd__fill_2
XFILLER_0_55_305 VGND VGND VPWR VPWR sky130_fd_sc_hd__decap_8
XscaleAdd._720_ net16 net18 VGND VGND VPWR VPWR scaleAdd._287_ sky130_fd_sc_hd__nand2_1
XscaleAdd._651_ scaleAdd._223_ scaleAdd._225_ VGND VGND VPWR VPWR scaleAdd._226_ sky130_fd_sc_hd__xnor2_1
XscaleAdd._582_ scaleAdd._157_ scaleAdd._158_ VGND VGND VPWR VPWR scaleAdd._159_ sky130_fd_sc_hd__nor2_1
Xrebuffer6 net61 VGND VGND VPWR VPWR net63 sky130_fd_sc_hd__dlygate4sd1_1
XFILLER_0_48_69 VGND VGND VPWR VPWR sky130_fd_sc_hd__decap_6
Xaccumulator._2000_ accumulator._1076_ accumulator._1077_ accumulator._1096_ VGND
+ VGND VPWR VPWR accumulator._1097_ sky130_fd_sc_hd__and3_1
XFILLER_0_54_371 VPWR VGND VPWR VGND sky130_ef_sc_hd__decap_12
XFILLER_0_6_413 VGND VGND VPWR VPWR sky130_fd_sc_hd__decap_6
XFILLER_0_59_3 VPWR VGND VPWR VGND sky130_ef_sc_hd__decap_12
Xaccumulator._1646_ accumulator._0740_ accumulator._0741_ accumulator._0742_ VGND
+ VGND VPWR VPWR accumulator._0743_ sky130_fd_sc_hd__a21o_1
Xaccumulator._1715_ accumulator.io_accOut\[9\] accumulator._0537_ accumulator._0403_
+ VGND VGND VPWR VPWR accumulator._0812_ sky130_fd_sc_hd__mux2_2
XFILLER_0_1_151 VGND VGND VPWR VPWR sky130_fd_sc_hd__decap_6
XFILLER_0_1_195 VGND VGND VPWR VPWR sky130_fd_sc_hd__decap_4
Xaccumulator._1577_ accumulator._0606_ accumulator._0664_ accumulator._0667_ accumulator._0673_
+ accumulator._0650_ VGND VGND VPWR VPWR accumulator._0674_ sky130_fd_sc_hd__a311o_1
Xaccumulator._2129_ accumulator._0715_ accumulator._0036_ accumulator._0035_ VGND
+ VGND VPWR VPWR accumulator._0063_ sky130_fd_sc_hd__a21oi_1
XFILLER_0_60_363 VGND VGND VPWR VPWR sky130_fd_sc_hd__fill_1
XFILLER_0_45_393 VGND VGND VPWR VPWR sky130_fd_sc_hd__decap_8
XFILLER_0_0_3 VPWR VGND VPWR VGND sky130_ef_sc_hd__decap_12
XTAP_TAPCELL_ROW_56_572 VGND VPWR sky130_fd_sc_hd__tapvpwrvgnd_1
XFILLER_0_50_15 VPWR VGND VPWR VGND sky130_ef_sc_hd__decap_12
XFILLER_0_34_27 VGND VGND VPWR VPWR sky130_fd_sc_hd__fill_1
XFILLER_0_28_338 VGND VGND VPWR VPWR sky130_fd_sc_hd__fill_1
XFILLER_0_51_330 VGND VGND VPWR VPWR sky130_fd_sc_hd__decap_6
XFILLER_0_3_405 VPWR VGND VPWR VGND sky130_ef_sc_hd__decap_12
XscaleAdd._634_ scaleAdd._330_ scaleAdd._188_ VGND VGND VPWR VPWR scaleAdd._209_ sky130_fd_sc_hd__nand2_1
XscaleAdd._703_ scaleAdd._272_ scaleAdd._274_ VGND VGND VPWR VPWR accumulator.io_inMant\[15\]
+ sky130_fd_sc_hd__xnor2_1
XFILLER_0_59_57 VPWR VGND VPWR VGND sky130_ef_sc_hd__decap_12
Xaccumulator._1500_ accumulator._0451_ accumulator._0478_ accumulator._0596_ VGND
+ VGND VPWR VPWR accumulator._0597_ sky130_fd_sc_hd__and3_1
XscaleAdd._565_ scaleAdd._141_ scaleAdd._142_ VGND VGND VPWR VPWR scaleAdd._143_ sky130_fd_sc_hd__and2b_1
XscaleAdd._496_ scaleAdd._069_ scaleAdd._070_ VGND VGND VPWR VPWR scaleAdd._075_ sky130_fd_sc_hd__or2_1
Xaccumulator._1431_ accumulator.io_accOut\[4\] net60 accumulator._0431_ accumulator._0468_
+ VGND VGND VPWR VPWR accumulator._0528_ sky130_fd_sc_hd__a31o_1
Xaccumulator._1293_ accumulator._0390_ accumulator._0389_ accumulator._0391_ VGND
+ VGND VPWR VPWR accumulator._0392_ sky130_fd_sc_hd__a21boi_4
Xaccumulator._1362_ accumulator.io_inMant\[3\] accumulator.io_inMant\[4\] accumulator._0345_
+ VGND VGND VPWR VPWR accumulator._0459_ sky130_fd_sc_hd__mux2_1
XFILLER_0_46_102 VPWR VGND VPWR VGND sky130_ef_sc_hd__decap_12
XFILLER_0_24_82 VGND VGND VPWR VPWR sky130_fd_sc_hd__fill_2
XTAP_TAPCELL_ROW_19_296 VGND VPWR sky130_fd_sc_hd__tapvpwrvgnd_1
XFILLER_0_42_385 VGND VGND VPWR VPWR sky130_fd_sc_hd__decap_3
XFILLER_0_42_341 VPWR VGND VPWR VGND sky130_ef_sc_hd__decap_12
XFILLER_0_27_393 VPWR VGND VPWR VGND sky130_ef_sc_hd__decap_12
XFILLER_0_6_276 VGND VGND VPWR VPWR sky130_fd_sc_hd__decap_3
Xaccumulator._1629_ accumulator._0651_ accumulator._0718_ accumulator._0721_ accumulator._0620_
+ accumulator._0725_ VGND VGND VPWR VPWR accumulator._0726_ sky130_fd_sc_hd__o32ai_4
XTAP_TAPCELL_ROW_53_553 VGND VPWR sky130_fd_sc_hd__tapvpwrvgnd_1
XFILLER_0_37_124 VGND VGND VPWR VPWR sky130_fd_sc_hd__fill_2
XFILLER_0_37_113 VGND VGND VPWR VPWR sky130_fd_sc_hd__decap_4
XFILLER_0_37_102 VGND VGND VPWR VPWR sky130_fd_sc_hd__decap_8
Xoperator._18_ operator._03_ VGND VGND VPWR VPWR operator.io_outExp\[2\] sky130_fd_sc_hd__buf_1
XTAP_TAPCELL_ROW_2_164 VGND VPWR sky130_fd_sc_hd__tapvpwrvgnd_1
XFILLER_0_52_149 VPWR VGND VPWR VGND sky130_ef_sc_hd__decap_12
XFILLER_0_33_341 VGND VGND VPWR VPWR sky130_fd_sc_hd__fill_1
XFILLER_0_18_371 VPWR VGND VPWR VGND sky130_ef_sc_hd__decap_12
XFILLER_0_20_29 VGND VGND VPWR VPWR sky130_fd_sc_hd__decap_6
XFILLER_0_45_15 VPWR VGND VPWR VGND sky130_ef_sc_hd__decap_12
XFILLER_0_28_179 VGND VGND VPWR VPWR sky130_fd_sc_hd__decap_4
Xaccumulator._1980_ accumulator._1062_ accumulator._1070_ VGND VGND VPWR VPWR accumulator._1077_
+ sky130_fd_sc_hd__and2_1
XFILLER_0_43_138 VGND VGND VPWR VPWR sky130_fd_sc_hd__decap_3
XFILLER_0_3_279 VGND VGND VPWR VPWR sky130_fd_sc_hd__fill_1
XscaleAdd._548_ scaleAdd._082_ scaleAdd._097_ VGND VGND VPWR VPWR scaleAdd._126_ sky130_fd_sc_hd__and2_1
XscaleAdd._617_ net13 scaleAdd._128_ scaleAdd._192_ scaleAdd._158_ VGND VGND VPWR
+ VPWR scaleAdd._193_ sky130_fd_sc_hd__a31oi_2
XFILLER_0_10_73 VGND VGND VPWR VPWR sky130_fd_sc_hd__decap_8
XscaleAdd._479_ scaleAdd._056_ scaleAdd._058_ VGND VGND VPWR VPWR scaleAdd._059_ sky130_fd_sc_hd__xor2_1
XTAP_TAPCELL_ROW_67_656 VGND VPWR sky130_fd_sc_hd__tapvpwrvgnd_1
Xaccumulator._1414_ accumulator._0505_ accumulator._0510_ accumulator._0475_ VGND
+ VGND VPWR VPWR accumulator._0511_ sky130_fd_sc_hd__a21o_1
XFILLER_0_35_81 VGND VGND VPWR VPWR sky130_fd_sc_hd__decap_8
Xaccumulator._1276_ accumulator._0373_ accumulator._0371_ accumulator._0374_ VGND
+ VGND VPWR VPWR accumulator._0375_ sky130_fd_sc_hd__a21o_1
Xaccumulator._1345_ accumulator.io_inMant\[10\] accumulator.io_inMant\[11\] accumulator._0436_
+ VGND VGND VPWR VPWR accumulator._0442_ sky130_fd_sc_hd__mux2_1
Xaccumulator._2394_ accumulator._0320_ accumulator._0322_ accumulator._0325_ VGND
+ VGND VPWR VPWR accumulator._0327_ sky130_fd_sc_hd__a21oi_1
XFILLER_0_34_105 VPWR VGND VPWR VGND sky130_ef_sc_hd__decap_12
XFILLER_0_30_399 VGND VGND VPWR VPWR sky130_fd_sc_hd__fill_2
XFILLER_0_30_377 VGND VGND VPWR VPWR sky130_fd_sc_hd__decap_6
XFILLER_0_2_290 VPWR VGND VPWR VGND sky130_ef_sc_hd__decap_12
XPHY_EDGE_ROW_8_Left_79 VGND VGND VPWR VPWR sky130_fd_sc_hd__decap_3
XFILLER_0_25_116 VPWR VGND VPWR VGND sky130_ef_sc_hd__decap_12
XTAP_TAPCELL_ROW_13_247 VGND VPWR sky130_fd_sc_hd__tapvpwrvgnd_1
XFILLER_0_21_322 VGND VGND VPWR VPWR sky130_fd_sc_hd__fill_2
XscaleAdd._402_ scaleAdd._333_ scaleAdd._343_ VGND VGND VPWR VPWR scaleAdd._344_ sky130_fd_sc_hd__xnor2_1
XFILLER_0_0_249 VGND VGND VPWR VPWR sky130_fd_sc_hd__decap_3
Xaccumulator._1963_ accumulator._0918_ accumulator._0861_ VGND VGND VPWR VPWR accumulator._1060_
+ sky130_fd_sc_hd__nor2_1
Xaccumulator._1894_ accumulator._0781_ accumulator._0990_ VGND VGND VPWR VPWR accumulator._0991_
+ sky130_fd_sc_hd__xor2_2
XFILLER_0_24_171 VGND VGND VPWR VPWR sky130_fd_sc_hd__decap_6
XFILLER_0_12_333 VPWR VGND VPWR VGND sky130_ef_sc_hd__decap_12
XFILLER_0_12_377 VPWR VGND VPWR VGND sky130_ef_sc_hd__decap_12
XFILLER_0_46_80 VGND VGND VPWR VPWR sky130_fd_sc_hd__decap_4
XFILLER_0_41_3 VPWR VGND VPWR VGND sky130_ef_sc_hd__decap_12
XFILLER_0_62_200 VPWR VGND VPWR VGND sky130_ef_sc_hd__decap_12
Xaccumulator._1328_ accumulator._0419_ accumulator._0424_ VGND VGND VPWR VPWR accumulator._0425_
+ sky130_fd_sc_hd__nor2_1
XFILLER_0_39_208 VGND VGND VPWR VPWR sky130_fd_sc_hd__decap_4
Xaccumulator._2377_ accumulator.io_accOut\[28\] accumulator._0406_ VGND VGND VPWR
+ VPWR accumulator._0310_ sky130_fd_sc_hd__or2_1
Xaccumulator._1259_ accumulator.io_accOut\[27\] accumulator._0357_ VGND VGND VPWR
+ VPWR accumulator._0358_ sky130_fd_sc_hd__and2_1
XFILLER_0_62_244 VGND VGND VPWR VPWR sky130_fd_sc_hd__fill_2
XFILLER_0_7_393 VPWR VGND VPWR VGND sky130_ef_sc_hd__decap_12
XTAP_TAPCELL_ROW_10_228 VGND VPWR sky130_fd_sc_hd__tapvpwrvgnd_1
XFILLER_0_30_141 VGND VGND VPWR VPWR sky130_fd_sc_hd__decap_8
XTAP_TAPCELL_ROW_61_607 VGND VPWR sky130_fd_sc_hd__tapvpwrvgnd_1
XFILLER_0_53_244 VGND VGND VPWR VPWR sky130_fd_sc_hd__decap_4
XFILLER_0_42_27 VGND VGND VPWR VPWR sky130_fd_sc_hd__fill_1
XFILLER_0_38_285 VGND VGND VPWR VPWR sky130_fd_sc_hd__decap_4
XTAP_TAPCELL_ROW_26_350 VGND VPWR sky130_fd_sc_hd__tapvpwrvgnd_1
XFILLER_0_67_57 VPWR VGND VPWR VGND sky130_ef_sc_hd__decap_12
XFILLER_0_53_277 VGND VGND VPWR VPWR sky130_fd_sc_hd__decap_3
XFILLER_0_6_27 VGND VGND VPWR VPWR sky130_fd_sc_hd__fill_1
XFILLER_0_13_119 VGND VGND VPWR VPWR sky130_fd_sc_hd__fill_1
Xaccumulator._2231_ accumulator._0157_ accumulator._0165_ accumulator._0093_ VGND
+ VGND VPWR VPWR accumulator._0013_ sky130_fd_sc_hd__o21a_1
Xaccumulator._2300_ accumulator._0398_ accumulator._0228_ accumulator._0232_ accumulator._0233_
+ accumulator._0400_ VGND VGND VPWR VPWR accumulator._0021_ sky130_fd_sc_hd__o311a_1
Xrebuffer16 scaleAdd._118_ VGND VGND VPWR VPWR net73 sky130_fd_sc_hd__dlymetal6s4s_1
Xrebuffer27 net85 VGND VGND VPWR VPWR net84 sky130_fd_sc_hd__dlygate4sd1_1
Xaccumulator._2093_ accumulator._0997_ accumulator._1190_ accumulator._1011_ VGND
+ VGND VPWR VPWR accumulator._1191_ sky130_fd_sc_hd__a21o_1
Xaccumulator._2162_ accumulator._0070_ accumulator._0096_ accumulator._0061_ VGND
+ VGND VPWR VPWR accumulator._0097_ sky130_fd_sc_hd__mux2_1
XFILLER_0_29_241 VPWR VGND VPWR VGND sky130_ef_sc_hd__decap_12
XFILLER_0_13_7 VGND VGND VPWR VPWR sky130_fd_sc_hd__decap_6
XFILLER_0_16_72 VPWR VGND VPWR VGND sky130_ef_sc_hd__decap_12
Xaccumulator._1946_ accumulator._0815_ accumulator._0809_ accumulator._0840_ VGND
+ VGND VPWR VPWR accumulator._1043_ sky130_fd_sc_hd__o21a_1
XFILLER_0_4_363 VGND VGND VPWR VPWR sky130_fd_sc_hd__fill_1
XFILLER_0_8_146 VGND VGND VPWR VPWR sky130_fd_sc_hd__decap_3
Xaccumulator._1877_ accumulator._0921_ accumulator._0680_ accumulator._0727_ accumulator._0973_
+ VGND VGND VPWR VPWR accumulator._0974_ sky130_fd_sc_hd__a31o_1
XFILLER_0_12_141 VGND VGND VPWR VPWR sky130_fd_sc_hd__decap_3
XFILLER_0_57_90 VPWR VGND VPWR VGND sky130_ef_sc_hd__decap_12
Xaccumulator._2429_ clknet_2_1__leaf_clock accumulator._0030_ VGND VGND VPWR VPWR
+ accumulator.io_accOut\[28\] sky130_fd_sc_hd__dfxtp_1
XFILLER_0_50_247 VGND VGND VPWR VPWR sky130_fd_sc_hd__decap_4
Xoutput52 net52 VGND VGND VPWR VPWR io_accOut[8] sky130_fd_sc_hd__buf_2
Xoutput30 net30 VGND VGND VPWR VPWR io_accOut[17] sky130_fd_sc_hd__buf_2
Xoutput41 net41 VGND VGND VPWR VPWR io_accOut[27] sky130_fd_sc_hd__buf_2
XFILLER_0_37_27 VPWR VGND VPWR VGND sky130_ef_sc_hd__decap_12
XFILLER_0_53_15 VPWR VGND VPWR VGND sky130_ef_sc_hd__decap_12
Xaccumulator._1800_ accumulator._0877_ accumulator._0878_ accumulator._0896_ VGND
+ VGND VPWR VPWR accumulator._0897_ sky130_fd_sc_hd__o21a_1
XFILLER_0_41_225 VPWR VGND VPWR VGND sky130_ef_sc_hd__decap_12
Xaccumulator._1731_ accumulator._0826_ accumulator._0827_ VGND VGND VPWR VPWR accumulator._0828_
+ sky130_fd_sc_hd__and2b_2
XFILLER_0_41_269 VGND VGND VPWR VPWR sky130_fd_sc_hd__decap_3
Xaccumulator._1662_ accumulator._0611_ accumulator._0548_ accumulator._0551_ accumulator._0668_
+ VGND VGND VPWR VPWR accumulator._0759_ sky130_fd_sc_hd__a31o_1
.ends
