* NGSPICE file created from DotProductUnit_E2M3_x_E3M2_scale_UE5M3.ext - technology: sky130A

* Black-box entry subcircuit for sky130_fd_sc_hd__a31o_1 abstract view
.subckt sky130_fd_sc_hd__a31o_1 A1 A2 A3 B1 VGND VNB VPB VPWR X
.ends

* Black-box entry subcircuit for sky130_fd_sc_hd__o21a_1 abstract view
.subckt sky130_fd_sc_hd__o21a_1 A1 A2 B1 VGND VNB VPB VPWR X
.ends

* Black-box entry subcircuit for sky130_fd_sc_hd__mux2_4 abstract view
.subckt sky130_fd_sc_hd__mux2_4 A0 A1 S VGND VNB VPB VPWR X
.ends

* Black-box entry subcircuit for sky130_fd_sc_hd__fill_1 abstract view
.subckt sky130_fd_sc_hd__fill_1 VGND VNB VPB VPWR
.ends

* Black-box entry subcircuit for sky130_fd_sc_hd__o221a_1 abstract view
.subckt sky130_fd_sc_hd__o221a_1 A1 A2 B1 B2 C1 VGND VNB VPB VPWR X
.ends

* Black-box entry subcircuit for sky130_ef_sc_hd__decap_12 abstract view
.subckt sky130_ef_sc_hd__decap_12 VPWR VGND VPB VNB
.ends

* Black-box entry subcircuit for sky130_fd_sc_hd__decap_4 abstract view
.subckt sky130_fd_sc_hd__decap_4 VGND VNB VPB VPWR
.ends

* Black-box entry subcircuit for sky130_fd_sc_hd__a21oi_2 abstract view
.subckt sky130_fd_sc_hd__a21oi_2 A1 A2 B1 VGND VNB VPB VPWR Y
.ends

* Black-box entry subcircuit for sky130_fd_sc_hd__fill_2 abstract view
.subckt sky130_fd_sc_hd__fill_2 VGND VNB VPB VPWR
.ends

* Black-box entry subcircuit for sky130_fd_sc_hd__tapvpwrvgnd_1 abstract view
.subckt sky130_fd_sc_hd__tapvpwrvgnd_1 VGND VPWR
.ends

* Black-box entry subcircuit for sky130_fd_sc_hd__decap_8 abstract view
.subckt sky130_fd_sc_hd__decap_8 VGND VNB VPB VPWR
.ends

* Black-box entry subcircuit for sky130_fd_sc_hd__decap_3 abstract view
.subckt sky130_fd_sc_hd__decap_3 VGND VNB VPB VPWR
.ends

* Black-box entry subcircuit for sky130_fd_sc_hd__and2_1 abstract view
.subckt sky130_fd_sc_hd__and2_1 A B VGND VNB VPB VPWR X
.ends

* Black-box entry subcircuit for sky130_fd_sc_hd__nor2_1 abstract view
.subckt sky130_fd_sc_hd__nor2_1 A B VGND VNB VPB VPWR Y
.ends

* Black-box entry subcircuit for sky130_fd_sc_hd__o21bai_1 abstract view
.subckt sky130_fd_sc_hd__o21bai_1 A1 A2 B1_N VGND VNB VPB VPWR Y
.ends

* Black-box entry subcircuit for sky130_fd_sc_hd__mux2_1 abstract view
.subckt sky130_fd_sc_hd__mux2_1 A0 A1 S VGND VNB VPB VPWR X
.ends

* Black-box entry subcircuit for sky130_fd_sc_hd__decap_6 abstract view
.subckt sky130_fd_sc_hd__decap_6 VGND VNB VPB VPWR
.ends

* Black-box entry subcircuit for sky130_fd_sc_hd__a22o_1 abstract view
.subckt sky130_fd_sc_hd__a22o_1 A1 A2 B1 B2 VGND VNB VPB VPWR X
.ends

* Black-box entry subcircuit for sky130_fd_sc_hd__nand2_1 abstract view
.subckt sky130_fd_sc_hd__nand2_1 A B VGND VNB VPB VPWR Y
.ends

* Black-box entry subcircuit for sky130_fd_sc_hd__buf_2 abstract view
.subckt sky130_fd_sc_hd__buf_2 A VGND VNB VPB VPWR X
.ends

* Black-box entry subcircuit for sky130_fd_sc_hd__o31a_1 abstract view
.subckt sky130_fd_sc_hd__o31a_1 A1 A2 A3 B1 VGND VNB VPB VPWR X
.ends

* Black-box entry subcircuit for sky130_fd_sc_hd__a21o_1 abstract view
.subckt sky130_fd_sc_hd__a21o_1 A1 A2 B1 VGND VNB VPB VPWR X
.ends

* Black-box entry subcircuit for sky130_fd_sc_hd__and3_1 abstract view
.subckt sky130_fd_sc_hd__and3_1 A B C VGND VNB VPB VPWR X
.ends

* Black-box entry subcircuit for sky130_fd_sc_hd__o211ai_1 abstract view
.subckt sky130_fd_sc_hd__o211ai_1 A1 A2 B1 C1 VGND VNB VPB VPWR Y
.ends

* Black-box entry subcircuit for sky130_fd_sc_hd__or4b_2 abstract view
.subckt sky130_fd_sc_hd__or4b_2 A B C D_N VGND VNB VPB VPWR X
.ends

* Black-box entry subcircuit for sky130_fd_sc_hd__xnor2_2 abstract view
.subckt sky130_fd_sc_hd__xnor2_2 A B VGND VNB VPB VPWR Y
.ends

* Black-box entry subcircuit for sky130_fd_sc_hd__clkbuf_4 abstract view
.subckt sky130_fd_sc_hd__clkbuf_4 A VGND VNB VPB VPWR X
.ends

* Black-box entry subcircuit for sky130_fd_sc_hd__nor3_1 abstract view
.subckt sky130_fd_sc_hd__nor3_1 A B C VGND VNB VPB VPWR Y
.ends

* Black-box entry subcircuit for sky130_fd_sc_hd__dlygate4sd3_1 abstract view
.subckt sky130_fd_sc_hd__dlygate4sd3_1 A VGND VNB VPB VPWR X
.ends

* Black-box entry subcircuit for sky130_fd_sc_hd__xnor2_1 abstract view
.subckt sky130_fd_sc_hd__xnor2_1 A B VGND VNB VPB VPWR Y
.ends

* Black-box entry subcircuit for sky130_fd_sc_hd__dlygate4sd1_1 abstract view
.subckt sky130_fd_sc_hd__dlygate4sd1_1 A VGND VNB VPB VPWR X
.ends

* Black-box entry subcircuit for sky130_fd_sc_hd__mux2_2 abstract view
.subckt sky130_fd_sc_hd__mux2_2 A0 A1 S VGND VNB VPB VPWR X
.ends

* Black-box entry subcircuit for sky130_fd_sc_hd__o211a_1 abstract view
.subckt sky130_fd_sc_hd__o211a_1 A1 A2 B1 C1 VGND VNB VPB VPWR X
.ends

* Black-box entry subcircuit for sky130_fd_sc_hd__nand3_1 abstract view
.subckt sky130_fd_sc_hd__nand3_1 A B C VGND VNB VPB VPWR Y
.ends

* Black-box entry subcircuit for sky130_fd_sc_hd__and4_1 abstract view
.subckt sky130_fd_sc_hd__and4_1 A B C D VGND VNB VPB VPWR X
.ends

* Black-box entry subcircuit for sky130_fd_sc_hd__a221o_1 abstract view
.subckt sky130_fd_sc_hd__a221o_1 A1 A2 B1 B2 C1 VGND VNB VPB VPWR X
.ends

* Black-box entry subcircuit for sky130_fd_sc_hd__and3_2 abstract view
.subckt sky130_fd_sc_hd__and3_2 A B C VGND VNB VPB VPWR X
.ends

* Black-box entry subcircuit for sky130_fd_sc_hd__clkbuf_2 abstract view
.subckt sky130_fd_sc_hd__clkbuf_2 A VGND VNB VPB VPWR X
.ends

* Black-box entry subcircuit for sky130_fd_sc_hd__and2b_1 abstract view
.subckt sky130_fd_sc_hd__and2b_1 A_N B VGND VNB VPB VPWR X
.ends

* Black-box entry subcircuit for sky130_fd_sc_hd__o2bb2a_1 abstract view
.subckt sky130_fd_sc_hd__o2bb2a_1 A1_N A2_N B1 B2 VGND VNB VPB VPWR X
.ends

* Black-box entry subcircuit for sky130_fd_sc_hd__or2_1 abstract view
.subckt sky130_fd_sc_hd__or2_1 A B VGND VNB VPB VPWR X
.ends

* Black-box entry subcircuit for sky130_fd_sc_hd__nand2b_2 abstract view
.subckt sky130_fd_sc_hd__nand2b_2 A_N B VGND VNB VPB VPWR Y
.ends

* Black-box entry subcircuit for sky130_fd_sc_hd__o21ba_1 abstract view
.subckt sky130_fd_sc_hd__o21ba_1 A1 A2 B1_N VGND VNB VPB VPWR X
.ends

* Black-box entry subcircuit for sky130_fd_sc_hd__o21ai_1 abstract view
.subckt sky130_fd_sc_hd__o21ai_1 A1 A2 B1 VGND VNB VPB VPWR Y
.ends

* Black-box entry subcircuit for sky130_fd_sc_hd__nor2b_2 abstract view
.subckt sky130_fd_sc_hd__nor2b_2 A B_N VGND VNB VPB VPWR Y
.ends

* Black-box entry subcircuit for sky130_fd_sc_hd__o41a_1 abstract view
.subckt sky130_fd_sc_hd__o41a_1 A1 A2 A3 A4 B1 VGND VNB VPB VPWR X
.ends

* Black-box entry subcircuit for sky130_fd_sc_hd__o211ai_2 abstract view
.subckt sky130_fd_sc_hd__o211ai_2 A1 A2 B1 C1 VGND VNB VPB VPWR Y
.ends

* Black-box entry subcircuit for sky130_fd_sc_hd__a211o_1 abstract view
.subckt sky130_fd_sc_hd__a211o_1 A1 A2 B1 C1 VGND VNB VPB VPWR X
.ends

* Black-box entry subcircuit for sky130_fd_sc_hd__a21oi_1 abstract view
.subckt sky130_fd_sc_hd__a21oi_1 A1 A2 B1 VGND VNB VPB VPWR Y
.ends

* Black-box entry subcircuit for sky130_fd_sc_hd__or3_1 abstract view
.subckt sky130_fd_sc_hd__or3_1 A B C VGND VNB VPB VPWR X
.ends

* Black-box entry subcircuit for sky130_fd_sc_hd__xor2_4 abstract view
.subckt sky130_fd_sc_hd__xor2_4 A B VGND VNB VPB VPWR X
.ends

* Black-box entry subcircuit for sky130_fd_sc_hd__o21bai_4 abstract view
.subckt sky130_fd_sc_hd__o21bai_4 A1 A2 B1_N VGND VNB VPB VPWR Y
.ends

* Black-box entry subcircuit for sky130_fd_sc_hd__xnor2_4 abstract view
.subckt sky130_fd_sc_hd__xnor2_4 A B VGND VNB VPB VPWR Y
.ends

* Black-box entry subcircuit for sky130_fd_sc_hd__nor2_2 abstract view
.subckt sky130_fd_sc_hd__nor2_2 A B VGND VNB VPB VPWR Y
.ends

* Black-box entry subcircuit for sky130_fd_sc_hd__xor2_2 abstract view
.subckt sky130_fd_sc_hd__xor2_2 A B VGND VNB VPB VPWR X
.ends

* Black-box entry subcircuit for sky130_fd_sc_hd__a311o_1 abstract view
.subckt sky130_fd_sc_hd__a311o_1 A1 A2 A3 B1 C1 VGND VNB VPB VPWR X
.ends

* Black-box entry subcircuit for sky130_fd_sc_hd__and3b_1 abstract view
.subckt sky130_fd_sc_hd__and3b_1 A_N B C VGND VNB VPB VPWR X
.ends

* Black-box entry subcircuit for sky130_fd_sc_hd__inv_2 abstract view
.subckt sky130_fd_sc_hd__inv_2 A VGND VNB VPB VPWR Y
.ends

* Black-box entry subcircuit for sky130_fd_sc_hd__buf_6 abstract view
.subckt sky130_fd_sc_hd__buf_6 A VGND VNB VPB VPWR X
.ends

* Black-box entry subcircuit for sky130_fd_sc_hd__o21ai_4 abstract view
.subckt sky130_fd_sc_hd__o21ai_4 A1 A2 B1 VGND VNB VPB VPWR Y
.ends

* Black-box entry subcircuit for sky130_fd_sc_hd__a31o_2 abstract view
.subckt sky130_fd_sc_hd__a31o_2 A1 A2 A3 B1 VGND VNB VPB VPWR X
.ends

* Black-box entry subcircuit for sky130_fd_sc_hd__a21boi_1 abstract view
.subckt sky130_fd_sc_hd__a21boi_1 A1 A2 B1_N VGND VNB VPB VPWR Y
.ends

* Black-box entry subcircuit for sky130_fd_sc_hd__buf_1 abstract view
.subckt sky130_fd_sc_hd__buf_1 A VGND VNB VPB VPWR X
.ends

* Black-box entry subcircuit for sky130_fd_sc_hd__clkbuf_1 abstract view
.subckt sky130_fd_sc_hd__clkbuf_1 A VGND VNB VPB VPWR X
.ends

* Black-box entry subcircuit for sky130_fd_sc_hd__or4_2 abstract view
.subckt sky130_fd_sc_hd__or4_2 A B C D VGND VNB VPB VPWR X
.ends

* Black-box entry subcircuit for sky130_fd_sc_hd__or2b_2 abstract view
.subckt sky130_fd_sc_hd__or2b_2 A B_N VGND VNB VPB VPWR X
.ends

* Black-box entry subcircuit for sky130_fd_sc_hd__a32o_2 abstract view
.subckt sky130_fd_sc_hd__a32o_2 A1 A2 A3 B1 B2 VGND VNB VPB VPWR X
.ends

* Black-box entry subcircuit for sky130_fd_sc_hd__clkbuf_16 abstract view
.subckt sky130_fd_sc_hd__clkbuf_16 A VGND VNB VPB VPWR X
.ends

* Black-box entry subcircuit for sky130_fd_sc_hd__nor2_4 abstract view
.subckt sky130_fd_sc_hd__nor2_4 A B VGND VNB VPB VPWR Y
.ends

* Black-box entry subcircuit for sky130_fd_sc_hd__buf_8 abstract view
.subckt sky130_fd_sc_hd__buf_8 A VGND VNB VPB VPWR X
.ends

* Black-box entry subcircuit for sky130_fd_sc_hd__or2_4 abstract view
.subckt sky130_fd_sc_hd__or2_4 A B VGND VNB VPB VPWR X
.ends

* Black-box entry subcircuit for sky130_fd_sc_hd__or4_1 abstract view
.subckt sky130_fd_sc_hd__or4_1 A B C D VGND VNB VPB VPWR X
.ends

* Black-box entry subcircuit for sky130_fd_sc_hd__o32a_1 abstract view
.subckt sky130_fd_sc_hd__o32a_1 A1 A2 A3 B1 B2 VGND VNB VPB VPWR X
.ends

* Black-box entry subcircuit for sky130_fd_sc_hd__clkinvlp_4 abstract view
.subckt sky130_fd_sc_hd__clkinvlp_4 A VGND VNB VPB VPWR Y
.ends

* Black-box entry subcircuit for sky130_fd_sc_hd__or2b_1 abstract view
.subckt sky130_fd_sc_hd__or2b_1 A B_N VGND VNB VPB VPWR X
.ends

* Black-box entry subcircuit for sky130_fd_sc_hd__or3b_4 abstract view
.subckt sky130_fd_sc_hd__or3b_4 A B C_N VGND VNB VPB VPWR X
.ends

* Black-box entry subcircuit for sky130_fd_sc_hd__o311a_4 abstract view
.subckt sky130_fd_sc_hd__o311a_4 A1 A2 A3 B1 C1 VGND VNB VPB VPWR X
.ends

* Black-box entry subcircuit for sky130_fd_sc_hd__o31a_2 abstract view
.subckt sky130_fd_sc_hd__o31a_2 A1 A2 A3 B1 VGND VNB VPB VPWR X
.ends

* Black-box entry subcircuit for sky130_fd_sc_hd__or4b_4 abstract view
.subckt sky130_fd_sc_hd__or4b_4 A B C D_N VGND VNB VPB VPWR X
.ends

* Black-box entry subcircuit for sky130_fd_sc_hd__nor2b_1 abstract view
.subckt sky130_fd_sc_hd__nor2b_1 A B_N VGND VNB VPB VPWR Y
.ends

* Black-box entry subcircuit for sky130_fd_sc_hd__or2_2 abstract view
.subckt sky130_fd_sc_hd__or2_2 A B VGND VNB VPB VPWR X
.ends

* Black-box entry subcircuit for sky130_fd_sc_hd__a31oi_2 abstract view
.subckt sky130_fd_sc_hd__a31oi_2 A1 A2 A3 B1 VGND VNB VPB VPWR Y
.ends

* Black-box entry subcircuit for sky130_fd_sc_hd__nand3_2 abstract view
.subckt sky130_fd_sc_hd__nand3_2 A B C VGND VNB VPB VPWR Y
.ends

* Black-box entry subcircuit for sky130_fd_sc_hd__a211oi_2 abstract view
.subckt sky130_fd_sc_hd__a211oi_2 A1 A2 B1 C1 VGND VNB VPB VPWR Y
.ends

* Black-box entry subcircuit for sky130_fd_sc_hd__a32o_1 abstract view
.subckt sky130_fd_sc_hd__a32o_1 A1 A2 A3 B1 B2 VGND VNB VPB VPWR X
.ends

* Black-box entry subcircuit for sky130_fd_sc_hd__a211oi_1 abstract view
.subckt sky130_fd_sc_hd__a211oi_1 A1 A2 B1 C1 VGND VNB VPB VPWR Y
.ends

* Black-box entry subcircuit for sky130_fd_sc_hd__bufinv_16 abstract view
.subckt sky130_fd_sc_hd__bufinv_16 A VGND VNB VPB VPWR Y
.ends

* Black-box entry subcircuit for sky130_fd_sc_hd__dfxtp_1 abstract view
.subckt sky130_fd_sc_hd__dfxtp_1 CLK D VGND VNB VPB VPWR Q
.ends

* Black-box entry subcircuit for sky130_fd_sc_hd__o311a_1 abstract view
.subckt sky130_fd_sc_hd__o311a_1 A1 A2 A3 B1 C1 VGND VNB VPB VPWR X
.ends

* Black-box entry subcircuit for sky130_fd_sc_hd__or4b_1 abstract view
.subckt sky130_fd_sc_hd__or4b_1 A B C D_N VGND VNB VPB VPWR X
.ends

* Black-box entry subcircuit for sky130_fd_sc_hd__or4_4 abstract view
.subckt sky130_fd_sc_hd__or4_4 A B C D VGND VNB VPB VPWR X
.ends

* Black-box entry subcircuit for sky130_fd_sc_hd__o22a_1 abstract view
.subckt sky130_fd_sc_hd__o22a_1 A1 A2 B1 B2 VGND VNB VPB VPWR X
.ends

* Black-box entry subcircuit for sky130_fd_sc_hd__a311oi_1 abstract view
.subckt sky130_fd_sc_hd__a311oi_1 A1 A2 A3 B1 C1 VGND VNB VPB VPWR Y
.ends

* Black-box entry subcircuit for sky130_fd_sc_hd__a2bb2o_1 abstract view
.subckt sky130_fd_sc_hd__a2bb2o_1 A1_N A2_N B1 B2 VGND VNB VPB VPWR X
.ends

* Black-box entry subcircuit for sky130_fd_sc_hd__a22oi_1 abstract view
.subckt sky130_fd_sc_hd__a22oi_1 A1 A2 B1 B2 VGND VNB VPB VPWR Y
.ends

* Black-box entry subcircuit for sky130_fd_sc_hd__a21bo_1 abstract view
.subckt sky130_fd_sc_hd__a21bo_1 A1 A2 B1_N VGND VNB VPB VPWR X
.ends

* Black-box entry subcircuit for sky130_fd_sc_hd__a21o_4 abstract view
.subckt sky130_fd_sc_hd__a21o_4 A1 A2 B1 VGND VNB VPB VPWR X
.ends

* Black-box entry subcircuit for sky130_fd_sc_hd__xor2_1 abstract view
.subckt sky130_fd_sc_hd__xor2_1 A B VGND VNB VPB VPWR X
.ends

* Black-box entry subcircuit for sky130_fd_sc_hd__or3_4 abstract view
.subckt sky130_fd_sc_hd__or3_4 A B C VGND VNB VPB VPWR X
.ends

* Black-box entry subcircuit for sky130_fd_sc_hd__a31oi_4 abstract view
.subckt sky130_fd_sc_hd__a31oi_4 A1 A2 A3 B1 VGND VNB VPB VPWR Y
.ends

* Black-box entry subcircuit for sky130_fd_sc_hd__nand2_2 abstract view
.subckt sky130_fd_sc_hd__nand2_2 A B VGND VNB VPB VPWR Y
.ends

* Black-box entry subcircuit for sky130_fd_sc_hd__a311o_4 abstract view
.subckt sky130_fd_sc_hd__a311o_4 A1 A2 A3 B1 C1 VGND VNB VPB VPWR X
.ends

* Black-box entry subcircuit for sky130_fd_sc_hd__a31oi_1 abstract view
.subckt sky130_fd_sc_hd__a31oi_1 A1 A2 A3 B1 VGND VNB VPB VPWR Y
.ends

* Black-box entry subcircuit for sky130_fd_sc_hd__a21bo_4 abstract view
.subckt sky130_fd_sc_hd__a21bo_4 A1 A2 B1_N VGND VNB VPB VPWR X
.ends

* Black-box entry subcircuit for sky130_fd_sc_hd__a32oi_1 abstract view
.subckt sky130_fd_sc_hd__a32oi_1 A1 A2 A3 B1 B2 VGND VNB VPB VPWR Y
.ends

* Black-box entry subcircuit for sky130_fd_sc_hd__dlymetal6s2s_1 abstract view
.subckt sky130_fd_sc_hd__dlymetal6s2s_1 A VGND VNB VPB VPWR X
.ends

* Black-box entry subcircuit for sky130_fd_sc_hd__a32oi_4 abstract view
.subckt sky130_fd_sc_hd__a32oi_4 A1 A2 A3 B1 B2 VGND VNB VPB VPWR Y
.ends

* Black-box entry subcircuit for sky130_fd_sc_hd__o21ba_2 abstract view
.subckt sky130_fd_sc_hd__o21ba_2 A1 A2 B1_N VGND VNB VPB VPWR X
.ends

* Black-box entry subcircuit for sky130_fd_sc_hd__o31ai_2 abstract view
.subckt sky130_fd_sc_hd__o31ai_2 A1 A2 A3 B1 VGND VNB VPB VPWR Y
.ends

* Black-box entry subcircuit for sky130_fd_sc_hd__or2b_4 abstract view
.subckt sky130_fd_sc_hd__or2b_4 A B_N VGND VNB VPB VPWR X
.ends

* Black-box entry subcircuit for sky130_fd_sc_hd__o21ai_2 abstract view
.subckt sky130_fd_sc_hd__o21ai_2 A1 A2 B1 VGND VNB VPB VPWR Y
.ends

* Black-box entry subcircuit for sky130_fd_sc_hd__o31a_4 abstract view
.subckt sky130_fd_sc_hd__o31a_4 A1 A2 A3 B1 VGND VNB VPB VPWR X
.ends

* Black-box entry subcircuit for sky130_fd_sc_hd__nor4b_4 abstract view
.subckt sky130_fd_sc_hd__nor4b_4 A B C D_N VGND VNB VPB VPWR Y
.ends

* Black-box entry subcircuit for sky130_fd_sc_hd__or3b_1 abstract view
.subckt sky130_fd_sc_hd__or3b_1 A B C_N VGND VNB VPB VPWR X
.ends

* Black-box entry subcircuit for sky130_fd_sc_hd__nand2_4 abstract view
.subckt sky130_fd_sc_hd__nand2_4 A B VGND VNB VPB VPWR Y
.ends

* Black-box entry subcircuit for sky130_fd_sc_hd__buf_4 abstract view
.subckt sky130_fd_sc_hd__buf_4 A VGND VNB VPB VPWR X
.ends

* Black-box entry subcircuit for sky130_fd_sc_hd__and2_4 abstract view
.subckt sky130_fd_sc_hd__and2_4 A B VGND VNB VPB VPWR X
.ends

* Black-box entry subcircuit for sky130_fd_sc_hd__nor3b_2 abstract view
.subckt sky130_fd_sc_hd__nor3b_2 A B C_N VGND VNB VPB VPWR Y
.ends

* Black-box entry subcircuit for sky130_fd_sc_hd__nor3b_1 abstract view
.subckt sky130_fd_sc_hd__nor3b_1 A B C_N VGND VNB VPB VPWR Y
.ends

* Black-box entry subcircuit for sky130_fd_sc_hd__nand4_1 abstract view
.subckt sky130_fd_sc_hd__nand4_1 A B C D VGND VNB VPB VPWR Y
.ends

* Black-box entry subcircuit for sky130_fd_sc_hd__o32ai_2 abstract view
.subckt sky130_fd_sc_hd__o32ai_2 A1 A2 A3 B1 B2 VGND VNB VPB VPWR Y
.ends

* Black-box entry subcircuit for sky130_fd_sc_hd__a31o_4 abstract view
.subckt sky130_fd_sc_hd__a31o_4 A1 A2 A3 B1 VGND VNB VPB VPWR X
.ends

* Black-box entry subcircuit for sky130_fd_sc_hd__nand3b_1 abstract view
.subckt sky130_fd_sc_hd__nand3b_1 A_N B C VGND VNB VPB VPWR Y
.ends

* Black-box entry subcircuit for sky130_fd_sc_hd__and4b_1 abstract view
.subckt sky130_fd_sc_hd__and4b_1 A_N B C D VGND VNB VPB VPWR X
.ends

* Black-box entry subcircuit for sky130_fd_sc_hd__o2111ai_2 abstract view
.subckt sky130_fd_sc_hd__o2111ai_2 A1 A2 B1 C1 D1 VGND VNB VPB VPWR Y
.ends

* Black-box entry subcircuit for sky130_fd_sc_hd__o32a_4 abstract view
.subckt sky130_fd_sc_hd__o32a_4 A1 A2 A3 B1 B2 VGND VNB VPB VPWR X
.ends

* Black-box entry subcircuit for sky130_fd_sc_hd__nor2_8 abstract view
.subckt sky130_fd_sc_hd__nor2_8 A B VGND VNB VPB VPWR Y
.ends

* Black-box entry subcircuit for sky130_fd_sc_hd__a2111o_1 abstract view
.subckt sky130_fd_sc_hd__a2111o_1 A1 A2 B1 C1 D1 VGND VNB VPB VPWR X
.ends

* Black-box entry subcircuit for sky130_fd_sc_hd__dfxtp_2 abstract view
.subckt sky130_fd_sc_hd__dfxtp_2 CLK D VGND VNB VPB VPWR Q
.ends

* Black-box entry subcircuit for sky130_fd_sc_hd__and3_4 abstract view
.subckt sky130_fd_sc_hd__and3_4 A B C VGND VNB VPB VPWR X
.ends

* Black-box entry subcircuit for sky130_fd_sc_hd__o21bai_2 abstract view
.subckt sky130_fd_sc_hd__o21bai_2 A1 A2 B1_N VGND VNB VPB VPWR Y
.ends

* Black-box entry subcircuit for sky130_fd_sc_hd__a41o_1 abstract view
.subckt sky130_fd_sc_hd__a41o_1 A1 A2 A3 A4 B1 VGND VNB VPB VPWR X
.ends

* Black-box entry subcircuit for sky130_fd_sc_hd__or4bb_4 abstract view
.subckt sky130_fd_sc_hd__or4bb_4 A B C_N D_N VGND VNB VPB VPWR X
.ends

* Black-box entry subcircuit for sky130_fd_sc_hd__a211oi_4 abstract view
.subckt sky130_fd_sc_hd__a211oi_4 A1 A2 B1 C1 VGND VNB VPB VPWR Y
.ends

* Black-box entry subcircuit for sky130_fd_sc_hd__a211o_4 abstract view
.subckt sky130_fd_sc_hd__a211o_4 A1 A2 B1 C1 VGND VNB VPB VPWR X
.ends

* Black-box entry subcircuit for sky130_fd_sc_hd__o311a_2 abstract view
.subckt sky130_fd_sc_hd__o311a_2 A1 A2 A3 B1 C1 VGND VNB VPB VPWR X
.ends

* Black-box entry subcircuit for sky130_fd_sc_hd__nor4_1 abstract view
.subckt sky130_fd_sc_hd__nor4_1 A B C D VGND VNB VPB VPWR Y
.ends

* Black-box entry subcircuit for sky130_fd_sc_hd__nor3_2 abstract view
.subckt sky130_fd_sc_hd__nor3_2 A B C VGND VNB VPB VPWR Y
.ends

* Black-box entry subcircuit for sky130_fd_sc_hd__o2bb2a_2 abstract view
.subckt sky130_fd_sc_hd__o2bb2a_2 A1_N A2_N B1 B2 VGND VNB VPB VPWR X
.ends

* Black-box entry subcircuit for sky130_fd_sc_hd__a2111o_4 abstract view
.subckt sky130_fd_sc_hd__a2111o_4 A1 A2 B1 C1 D1 VGND VNB VPB VPWR X
.ends

* Black-box entry subcircuit for sky130_fd_sc_hd__o21a_2 abstract view
.subckt sky130_fd_sc_hd__o21a_2 A1 A2 B1 VGND VNB VPB VPWR X
.ends

* Black-box entry subcircuit for sky130_fd_sc_hd__nand4_2 abstract view
.subckt sky130_fd_sc_hd__nand4_2 A B C D VGND VNB VPB VPWR Y
.ends

* Black-box entry subcircuit for sky130_fd_sc_hd__o31ai_4 abstract view
.subckt sky130_fd_sc_hd__o31ai_4 A1 A2 A3 B1 VGND VNB VPB VPWR Y
.ends

* Black-box entry subcircuit for sky130_fd_sc_hd__dlymetal6s4s_1 abstract view
.subckt sky130_fd_sc_hd__dlymetal6s4s_1 A VGND VNB VPB VPWR X
.ends

* Black-box entry subcircuit for sky130_fd_sc_hd__or3_2 abstract view
.subckt sky130_fd_sc_hd__or3_2 A B C VGND VNB VPB VPWR X
.ends

* Black-box entry subcircuit for sky130_fd_sc_hd__diode_2 abstract view
.subckt sky130_fd_sc_hd__diode_2 DIODE VGND VNB VPB VPWR
.ends

* Black-box entry subcircuit for sky130_fd_sc_hd__a21oi_4 abstract view
.subckt sky130_fd_sc_hd__a21oi_4 A1 A2 B1 VGND VNB VPB VPWR Y
.ends

* Black-box entry subcircuit for sky130_fd_sc_hd__and2_2 abstract view
.subckt sky130_fd_sc_hd__and2_2 A B VGND VNB VPB VPWR X
.ends

* Black-box entry subcircuit for sky130_fd_sc_hd__a2111oi_1 abstract view
.subckt sky130_fd_sc_hd__a2111oi_1 A1 A2 B1 C1 D1 VGND VNB VPB VPWR Y
.ends

.subckt DotProductUnit_E2M3_x_E3M2_scale_UE5M3 VGND VPWR clock io_accOut[0] io_accOut[10]
+ io_accOut[11] io_accOut[12] io_accOut[13] io_accOut[14] io_accOut[15] io_accOut[16]
+ io_accOut[17] io_accOut[18] io_accOut[19] io_accOut[1] io_accOut[20] io_accOut[21]
+ io_accOut[22] io_accOut[23] io_accOut[24] io_accOut[25] io_accOut[26] io_accOut[27]
+ io_accOut[28] io_accOut[29] io_accOut[2] io_accOut[30] io_accOut[31] io_accOut[3]
+ io_accOut[4] io_accOut[5] io_accOut[6] io_accOut[7] io_accOut[8] io_accOut[9] io_done
+ io_inA[0] io_inA[1] io_inA[2] io_inA[3] io_inA[4] io_inA[5] io_inB[0] io_inB[1]
+ io_inB[2] io_inB[3] io_inB[4] io_inB[5] io_inScaleA[0] io_inScaleA[1] io_inScaleA[2]
+ io_inScaleA[3] io_inScaleA[4] io_inScaleA[5] io_inScaleA[6] io_inScaleA[7] io_inScaleB[0]
+ io_inScaleB[1] io_inScaleB[2] io_inScaleB[3] io_inScaleB[4] io_inScaleB[5] io_inScaleB[6]
+ io_inScaleB[7] io_resetAcc io_start reset
Xaccumulator._1593_ accumulator.io_accOut\[0\] accumulator._0455_ accumulator._0574_
+ accumulator._0690_ VGND VGND VPWR VPWR accumulator._0691_ sky130_fd_sc_hd__a31o_1
Xaccumulator._2214_ accumulator._0192_ accumulator._0196_ accumulator._0092_ VGND
+ VGND VPWR VPWR accumulator._0023_ sky130_fd_sc_hd__o21a_1
Xaccumulator._2076_ accumulator._1076_ accumulator._1055_ accumulator._1119_ VGND
+ VGND VPWR VPWR accumulator._0062_ sky130_fd_sc_hd__mux2_4
XFILLER_0_57_391 VGND VGND VPWR VPWR sky130_fd_sc_hd__fill_1
Xaccumulator._2145_ accumulator.io_accOut\[12\] accumulator._0120_ accumulator._0123_
+ accumulator._0129_ accumulator._0092_ VGND VGND VPWR VPWR accumulator._0014_ sky130_fd_sc_hd__o221a_1
XFILLER_0_17_255 VPWR VGND VPWR VGND sky130_ef_sc_hd__decap_12
Xaccumulator._1929_ accumulator._0997_ accumulator._1001_ accumulator._0903_ VGND
+ VGND VPWR VPWR accumulator._1027_ sky130_fd_sc_hd__o21a_1
XFILLER_0_32_269 VGND VGND VPWR VPWR sky130_fd_sc_hd__decap_4
XFILLER_0_32_203 VGND VGND VPWR VPWR sky130_fd_sc_hd__fill_1
Xoperator._116_ operator._047_ operator._049_ operator._046_ VGND VGND VPWR VPWR operator._051_
+ sky130_fd_sc_hd__a21oi_2
XFILLER_0_67_166 VGND VGND VPWR VPWR sky130_fd_sc_hd__fill_2
XFILLER_0_67_111 VGND VGND VPWR VPWR sky130_fd_sc_hd__fill_1
XTAP_TAPCELL_ROW_43_448 VGND VPWR sky130_fd_sc_hd__tapvpwrvgnd_1
XFILLER_0_67_199 VGND VGND VPWR VPWR sky130_fd_sc_hd__decap_8
XFILLER_0_55_328 VGND VGND VPWR VPWR sky130_fd_sc_hd__decap_8
XFILLER_0_23_225 VGND VGND VPWR VPWR sky130_fd_sc_hd__decap_4
XFILLER_0_48_37 VGND VGND VPWR VPWR sky130_fd_sc_hd__decap_3
XFILLER_0_48_15 VPWR VGND VPWR VGND sky130_ef_sc_hd__decap_12
XFILLER_0_64_69 VGND VGND VPWR VPWR sky130_fd_sc_hd__decap_8
XFILLER_0_58_188 VGND VGND VPWR VPWR sky130_fd_sc_hd__decap_8
XFILLER_0_58_122 VPWR VGND VPWR VGND sky130_ef_sc_hd__decap_12
XFILLER_0_13_51 VGND VGND VPWR VPWR sky130_fd_sc_hd__decap_4
XFILLER_0_1_130 VGND VGND VPWR VPWR sky130_fd_sc_hd__fill_1
XFILLER_0_14_247 VGND VGND VPWR VPWR sky130_fd_sc_hd__decap_4
Xaccumulator._1645_ accumulator._0534_ accumulator._0740_ VGND VGND VPWR VPWR accumulator._0743_
+ sky130_fd_sc_hd__and2_1
Xaccumulator._1576_ accumulator._0493_ accumulator._0604_ VGND VGND VPWR VPWR accumulator._0674_
+ sky130_fd_sc_hd__nor2_1
Xaccumulator._1714_ accumulator._0445_ accumulator._0810_ accumulator._0811_ VGND
+ VGND VPWR VPWR accumulator._0812_ sky130_fd_sc_hd__o21bai_1
Xaccumulator._2128_ accumulator._1040_ accumulator._1042_ net94 VGND VGND VPWR VPWR
+ accumulator._0113_ sky130_fd_sc_hd__mux2_1
XFILLER_0_60_331 VGND VGND VPWR VPWR sky130_fd_sc_hd__fill_2
XFILLER_0_52_309 VGND VGND VPWR VPWR sky130_fd_sc_hd__decap_6
Xaccumulator._2059_ accumulator._0363_ accumulator._0045_ VGND VGND VPWR VPWR accumulator._0004_
+ sky130_fd_sc_hd__nor2_1
XTAP_TAPCELL_ROW_40_429 VGND VPWR sky130_fd_sc_hd__tapvpwrvgnd_1
XFILLER_0_37_317 VPWR VGND VPWR VGND sky130_ef_sc_hd__decap_12
XTAP_TAPCELL_ROW_56_540 VGND VPWR sky130_fd_sc_hd__tapvpwrvgnd_1
XTAP_TAPCELL_ROW_5_184 VGND VPWR sky130_fd_sc_hd__tapvpwrvgnd_1
XFILLER_0_18_29 VGND VGND VPWR VPWR sky130_fd_sc_hd__fill_1
XFILLER_0_55_147 VPWR VGND VPWR VGND sky130_ef_sc_hd__decap_12
XFILLER_0_55_125 VGND VGND VPWR VPWR sky130_fd_sc_hd__decap_4
XFILLER_0_50_27 VGND VGND VPWR VPWR sky130_fd_sc_hd__fill_1
XFILLER_0_55_169 VPWR VGND VPWR VGND sky130_ef_sc_hd__decap_12
XFILLER_0_51_375 VGND VGND VPWR VPWR sky130_fd_sc_hd__decap_4
XFILLER_0_36_394 VGND VGND VPWR VPWR sky130_fd_sc_hd__decap_4
XFILLER_0_11_239 VGND VGND VPWR VPWR sky130_fd_sc_hd__decap_8
XFILLER_0_59_69 VPWR VGND VPWR VGND sky130_ef_sc_hd__decap_12
Xaccumulator._1430_ accumulator._0034_ accumulator._0485_ accumulator._0484_ accumulator._0513_
+ VGND VGND VPWR VPWR accumulator._0528_ sky130_fd_sc_hd__a22o_1
XscaleAdd._495_ scaleAdd._165_ scaleAdd._166_ VGND VGND VPWR VPWR scaleAdd._167_ sky130_fd_sc_hd__nand2_1
Xaccumulator._1292_ accumulator._0389_ VGND VGND VPWR VPWR accumulator._0390_ sky130_fd_sc_hd__buf_2
Xaccumulator._1361_ accumulator.io_inMant\[4\] accumulator.io_inMant\[3\] accumulator._0415_
+ VGND VGND VPWR VPWR accumulator._0459_ sky130_fd_sc_hd__mux2_1
XFILLER_0_61_139 VPWR VGND VPWR VGND sky130_ef_sc_hd__decap_12
XFILLER_0_27_350 VGND VGND VPWR VPWR sky130_fd_sc_hd__decap_4
XFILLER_0_24_61 VGND VGND VPWR VPWR sky130_fd_sc_hd__decap_3
Xaccumulator._1628_ accumulator._0390_ accumulator._0546_ accumulator._0562_ accumulator._0563_
+ VGND VGND VPWR VPWR accumulator._0726_ sky130_fd_sc_hd__o31a_1
Xaccumulator._1559_ accumulator.io_accOut\[4\] accumulator._0348_ VGND VGND VPWR VPWR
+ accumulator._0657_ sky130_fd_sc_hd__and2_1
XTAP_TAPCELL_ROW_2_165 VGND VPWR sky130_fd_sc_hd__tapvpwrvgnd_1
XTAP_TAPCELL_ROW_53_521 VGND VPWR sky130_fd_sc_hd__tapvpwrvgnd_1
XFILLER_0_60_194 VGND VGND VPWR VPWR sky130_fd_sc_hd__fill_2
XscaleAdd._280_ operator.io_outMant\[2\] scaleAdd._226_ scaleAdd._224_ accumulator.io_inMant\[1\]
+ VGND VGND VPWR VPWR scaleAdd._231_ sky130_fd_sc_hd__a22o_1
XFILLER_0_61_15 VPWR VGND VPWR VGND sky130_ef_sc_hd__decap_12
XFILLER_0_45_27 VPWR VGND VPWR VGND sky130_ef_sc_hd__decap_12
XFILLER_0_0_29 VPWR VGND VPWR VGND sky130_ef_sc_hd__decap_12
XFILLER_0_43_117 VGND VGND VPWR VPWR sky130_fd_sc_hd__fill_1
XFILLER_0_9_38 VGND VGND VPWR VPWR sky130_fd_sc_hd__fill_1
XFILLER_0_16_309 VPWR VGND VPWR VGND sky130_ef_sc_hd__decap_12
XscaleAdd._547_ scaleAdd._207_ scaleAdd._209_ scaleAdd._214_ VGND VGND VPWR VPWR scaleAdd._215_
+ sky130_fd_sc_hd__a21o_1
XFILLER_0_24_397 VGND VGND VPWR VPWR sky130_fd_sc_hd__fill_1
XFILLER_0_24_353 VGND VGND VPWR VPWR sky130_fd_sc_hd__fill_2
XFILLER_0_3_225 VPWR VGND VPWR VGND sky130_ef_sc_hd__decap_12
XFILLER_0_10_85 VGND VGND VPWR VPWR sky130_fd_sc_hd__decap_6
Xaccumulator._1413_ accumulator._0493_ accumulator._0503_ accumulator._0510_ VGND
+ VGND VPWR VPWR accumulator._0511_ sky130_fd_sc_hd__and3_1
XscaleAdd._478_ scaleAdd._111_ scaleAdd._133_ scaleAdd._262_ scaleAdd._014_ VGND VGND
+ VPWR VPWR scaleAdd._153_ sky130_fd_sc_hd__o211ai_1
XFILLER_0_66_209 VGND VGND VPWR VPWR sky130_fd_sc_hd__decap_6
XFILLER_0_59_261 VGND VGND VPWR VPWR sky130_fd_sc_hd__fill_1
Xaccumulator._1344_ accumulator._0391_ accumulator._0396_ accumulator._0411_ accumulator._0441_
+ VGND VGND VPWR VPWR accumulator._0442_ sky130_fd_sc_hd__or4b_2
XFILLER_0_35_82 VGND VGND VPWR VPWR sky130_fd_sc_hd__decap_6
Xaccumulator._1275_ accumulator._0337_ accumulator._0372_ VGND VGND VPWR VPWR accumulator._0373_
+ sky130_fd_sc_hd__xnor2_2
XFILLER_0_19_125 VPWR VGND VPWR VGND sky130_ef_sc_hd__decap_12
XFILLER_0_42_161 VPWR VGND VPWR VGND sky130_ef_sc_hd__decap_12
XFILLER_0_34_139 VGND VGND VPWR VPWR sky130_fd_sc_hd__fill_1
XFILLER_0_15_353 VGND VGND VPWR VPWR sky130_fd_sc_hd__fill_1
XFILLER_0_15_386 VGND VGND VPWR VPWR sky130_fd_sc_hd__decap_6
XFILLER_0_19_158 VGND VGND VPWR VPWR sky130_fd_sc_hd__decap_8
XFILLER_0_19_169 VGND VGND VPWR VPWR sky130_fd_sc_hd__decap_8
XFILLER_0_65_275 VGND VGND VPWR VPWR sky130_fd_sc_hd__decap_4
XFILLER_0_65_264 VGND VGND VPWR VPWR sky130_fd_sc_hd__fill_1
XFILLER_0_31_18 VPWR VGND VPWR VGND sky130_ef_sc_hd__decap_12
XTAP_TAPCELL_ROW_13_237 VGND VPWR sky130_fd_sc_hd__tapvpwrvgnd_1
XFILLER_0_40_109 VGND VGND VPWR VPWR sky130_fd_sc_hd__decap_8
XscaleAdd._401_ scaleAdd._040_ scaleAdd._052_ scaleAdd._080_ VGND VGND VPWR VPWR scaleAdd._081_
+ sky130_fd_sc_hd__a21oi_2
XscaleAdd._332_ scaleAdd._236_ VGND VGND VPWR VPWR scaleAdd._014_ sky130_fd_sc_hd__clkbuf_4
XTAP_TAPCELL_ROW_21_292 VGND VPWR sky130_fd_sc_hd__tapvpwrvgnd_1
XFILLER_0_21_301 VPWR VGND VPWR VGND sky130_ef_sc_hd__decap_12
XFILLER_0_21_367 VGND VGND VPWR VPWR sky130_fd_sc_hd__decap_8
XFILLER_0_56_15 VPWR VGND VPWR VGND sky130_ef_sc_hd__decap_12
XFILLER_0_56_297 VGND VGND VPWR VPWR sky130_fd_sc_hd__decap_8
XFILLER_0_56_253 VPWR VGND VPWR VGND sky130_ef_sc_hd__decap_12
Xaccumulator._1962_ accumulator._0839_ accumulator._0844_ accumulator._0850_ VGND
+ VGND VPWR VPWR accumulator._1060_ sky130_fd_sc_hd__nor3_1
Xoperator._080_ net7 net2 VGND VGND VPWR VPWR operator._019_ sky130_fd_sc_hd__nand2_1
XFILLER_0_21_73 VGND VGND VPWR VPWR sky130_fd_sc_hd__fill_1
Xaccumulator._1893_ accumulator._0875_ accumulator._0990_ accumulator._0367_ VGND
+ VGND VPWR VPWR accumulator._0991_ sky130_fd_sc_hd__mux2_1
XFILLER_0_12_345 VPWR VGND VPWR VGND sky130_ef_sc_hd__decap_12
XFILLER_0_12_389 VPWR VGND VPWR VGND sky130_ef_sc_hd__decap_12
XFILLER_0_34_3 VPWR VGND VPWR VGND sky130_ef_sc_hd__decap_12
Xaccumulator._1327_ accumulator.io_inMant\[7\] accumulator.io_inMant\[6\] accumulator._0415_
+ VGND VGND VPWR VPWR accumulator._0425_ sky130_fd_sc_hd__mux2_1
XFILLER_0_47_220 VGND VGND VPWR VPWR sky130_fd_sc_hd__decap_4
XTAP_TAPCELL_ROW_35_395 VGND VPWR sky130_fd_sc_hd__tapvpwrvgnd_1
Xaccumulator._1189_ accumulator.io_inExp\[6\] accumulator._0286_ VGND VGND VPWR VPWR
+ accumulator._0289_ sky130_fd_sc_hd__xnor2_2
Xaccumulator._1258_ accumulator._0357_ VGND VGND VPWR VPWR accumulator._0358_ sky130_fd_sc_hd__buf_2
XFILLER_0_62_289 VGND VGND VPWR VPWR sky130_fd_sc_hd__fill_1
XFILLER_0_62_245 VGND VGND VPWR VPWR sky130_fd_sc_hd__decap_6
XFILLER_0_7_361 VPWR VGND VPWR VGND sky130_ef_sc_hd__decap_12
XTAP_TAPCELL_ROW_10_218 VGND VPWR sky130_fd_sc_hd__tapvpwrvgnd_1
XFILLER_0_30_197 VGND VGND VPWR VPWR sky130_fd_sc_hd__decap_8
Xhold52 accumulator.io_accOut\[19\] VGND VGND VPWR VPWR net115 sky130_fd_sc_hd__dlygate4sd3_1
XFILLER_0_26_29 VGND VGND VPWR VPWR sky130_fd_sc_hd__fill_1
XFILLER_0_26_18 VGND VGND VPWR VPWR sky130_fd_sc_hd__decap_8
XFILLER_0_53_278 VGND VGND VPWR VPWR sky130_fd_sc_hd__fill_2
XFILLER_0_53_201 VGND VGND VPWR VPWR sky130_fd_sc_hd__decap_8
XFILLER_0_38_242 VGND VGND VPWR VPWR sky130_fd_sc_hd__decap_8
XFILLER_0_13_109 VGND VGND VPWR VPWR sky130_fd_sc_hd__decap_3
XFILLER_0_67_69 VPWR VGND VPWR VGND sky130_ef_sc_hd__decap_12
XscaleAdd._315_ scaleAdd._228_ scaleAdd._224_ VGND VGND VPWR VPWR scaleAdd._264_ sky130_fd_sc_hd__and2_1
Xaccumulator._2230_ accumulator._1096_ accumulator._0211_ VGND VGND VPWR VPWR accumulator._0212_
+ sky130_fd_sc_hd__xnor2_1
Xrebuffer17 accumulator._0181_ VGND VGND VPWR VPWR net80 sky130_fd_sc_hd__dlygate4sd1_1
Xrebuffer28 accumulator._0171_ VGND VGND VPWR VPWR net91 sky130_fd_sc_hd__dlygate4sd1_1
Xaccumulator._2092_ accumulator._1052_ accumulator._1046_ net92 VGND VGND VPWR VPWR
+ accumulator._0078_ sky130_fd_sc_hd__mux2_2
Xaccumulator._2161_ net108 accumulator._0120_ accumulator._0092_ accumulator._0145_
+ VGND VGND VPWR VPWR accumulator._0016_ sky130_fd_sc_hd__o211a_1
Xaccumulator._1945_ accumulator._1040_ accumulator._1042_ VGND VGND VPWR VPWR accumulator._1043_
+ sky130_fd_sc_hd__nor2_1
Xoperator._063_ net4 net5 VGND VGND VPWR VPWR operator._007_ sky130_fd_sc_hd__nand2_1
Xaccumulator._1876_ accumulator._0819_ accumulator._0934_ accumulator._0823_ VGND
+ VGND VPWR VPWR accumulator._0974_ sky130_fd_sc_hd__o21bai_1
XFILLER_0_12_197 VGND VGND VPWR VPWR sky130_fd_sc_hd__decap_6
XFILLER_0_67_337 VPWR VGND VPWR VGND sky130_ef_sc_hd__decap_12
XTAP_TAPCELL_ROW_23_310 VGND VPWR sky130_fd_sc_hd__tapvpwrvgnd_1
Xoutput31 net31 VGND VGND VPWR VPWR io_accOut[11] sky130_fd_sc_hd__buf_2
Xoutput42 net42 VGND VGND VPWR VPWR io_accOut[21] sky130_fd_sc_hd__buf_2
Xoutput53 net53 VGND VGND VPWR VPWR io_accOut[31] sky130_fd_sc_hd__buf_2
XFILLER_0_53_27 VPWR VGND VPWR VGND sky130_ef_sc_hd__decap_12
XFILLER_0_37_39 VGND VGND VPWR VPWR sky130_fd_sc_hd__fill_2
XTAP_TAPCELL_ROW_46_468 VGND VPWR sky130_fd_sc_hd__tapvpwrvgnd_1
Xaccumulator._1730_ accumulator.io_accOut\[3\] accumulator._0349_ accumulator._0636_
+ VGND VGND VPWR VPWR accumulator._0828_ sky130_fd_sc_hd__nand3_1
XFILLER_0_41_237 VGND VGND VPWR VPWR sky130_fd_sc_hd__decap_4
Xaccumulator._1661_ accumulator._0752_ accumulator._0758_ VGND VGND VPWR VPWR accumulator._0759_
+ sky130_fd_sc_hd__nand2_1
Xaccumulator._1592_ accumulator.io_accOut\[1\] net65 accumulator._0381_ accumulator._0575_
+ VGND VGND VPWR VPWR accumulator._0690_ sky130_fd_sc_hd__and4_1
XFILLER_0_49_337 VPWR VGND VPWR VGND sky130_ef_sc_hd__decap_12
XFILLER_0_49_315 VPWR VGND VPWR VGND sky130_ef_sc_hd__decap_12
Xaccumulator._2213_ accumulator.io_accOut\[21\] accumulator._0364_ accumulator._0090_
+ accumulator._0137_ accumulator._0195_ VGND VGND VPWR VPWR accumulator._0196_ sky130_fd_sc_hd__a221o_1
Xaccumulator._2144_ accumulator._0124_ accumulator._0128_ accumulator._0061_ VGND
+ VGND VPWR VPWR accumulator._0129_ sky130_fd_sc_hd__mux2_1
XFILLER_0_27_50 VGND VGND VPWR VPWR sky130_fd_sc_hd__decap_6
Xaccumulator._2075_ accumulator._0060_ VGND VGND VPWR VPWR accumulator._0061_ sky130_fd_sc_hd__buf_2
Xoperator._115_ operator._040_ operator._030_ operator._032_ VGND VGND VPWR VPWR operator._050_
+ sky130_fd_sc_hd__and3_2
XFILLER_0_17_245 VGND VGND VPWR VPWR sky130_fd_sc_hd__fill_1
XFILLER_0_17_267 VPWR VGND VPWR VGND sky130_ef_sc_hd__decap_12
Xaccumulator._1859_ accumulator._0672_ accumulator._0956_ VGND VGND VPWR VPWR accumulator._0957_
+ sky130_fd_sc_hd__xnor2_2
Xaccumulator._1928_ accumulator._0906_ accumulator._1025_ VGND VGND VPWR VPWR accumulator._1026_
+ sky130_fd_sc_hd__xnor2_2
XFILLER_0_40_281 VPWR VGND VPWR VGND sky130_ef_sc_hd__decap_12
XFILLER_0_4_172 VGND VGND VPWR VPWR sky130_fd_sc_hd__fill_1
XFILLER_0_48_381 VGND VGND VPWR VPWR sky130_fd_sc_hd__decap_8
XTAP_TAPCELL_ROW_43_449 VGND VPWR sky130_fd_sc_hd__tapvpwrvgnd_1
Xrebuffer8 accumulator._0353_ VGND VGND VPWR VPWR net71 sky130_fd_sc_hd__clkbuf_2
XFILLER_0_48_27 VGND VGND VPWR VPWR sky130_fd_sc_hd__fill_1
XFILLER_0_31_281 VGND VGND VPWR VPWR sky130_fd_sc_hd__fill_2
XFILLER_0_64_15 VPWR VGND VPWR VGND sky130_ef_sc_hd__decap_12
XTAP_TAPCELL_ROW_59_560 VGND VPWR sky130_fd_sc_hd__tapvpwrvgnd_1
XFILLER_0_58_134 VGND VGND VPWR VPWR sky130_fd_sc_hd__decap_6
XFILLER_0_39_381 VGND VGND VPWR VPWR sky130_fd_sc_hd__fill_2
XFILLER_0_13_85 VGND VGND VPWR VPWR sky130_fd_sc_hd__fill_1
XFILLER_0_54_395 VGND VGND VPWR VPWR sky130_fd_sc_hd__decap_6
Xaccumulator._1713_ accumulator._0443_ accumulator._0442_ VGND VGND VPWR VPWR accumulator._0811_
+ sky130_fd_sc_hd__and2b_1
XFILLER_0_1_120 VGND VGND VPWR VPWR sky130_fd_sc_hd__decap_3
XFILLER_0_14_215 VGND VGND VPWR VPWR sky130_fd_sc_hd__fill_2
Xaccumulator._1644_ accumulator._0534_ accumulator._0740_ accumulator._0741_ VGND
+ VGND VPWR VPWR accumulator._0742_ sky130_fd_sc_hd__and3_1
Xaccumulator._1575_ accumulator._0586_ accumulator._0587_ VGND VGND VPWR VPWR accumulator._0673_
+ sky130_fd_sc_hd__nand2_1
XFILLER_0_38_82 VGND VGND VPWR VPWR sky130_fd_sc_hd__fill_2
XFILLER_0_54_81 VGND VGND VPWR VPWR sky130_fd_sc_hd__decap_3
XFILLER_0_49_167 VGND VGND VPWR VPWR sky130_fd_sc_hd__fill_1
Xaccumulator._2127_ accumulator._0363_ accumulator._0111_ VGND VGND VPWR VPWR accumulator._0012_
+ sky130_fd_sc_hd__nor2_1
XFILLER_0_37_329 VGND VGND VPWR VPWR sky130_fd_sc_hd__decap_6
XFILLER_0_60_365 VGND VGND VPWR VPWR sky130_fd_sc_hd__decap_3
Xaccumulator._2058_ accumulator.io_accOut\[2\] accumulator._0364_ accumulator._1032_
+ accumulator._0043_ VGND VGND VPWR VPWR accumulator._0045_ sky130_fd_sc_hd__o2bb2a_1
XFILLER_0_20_229 VPWR VGND VPWR VGND sky130_ef_sc_hd__decap_12
XTAP_TAPCELL_ROW_56_541 VGND VPWR sky130_fd_sc_hd__tapvpwrvgnd_1
XFILLER_0_34_29 VPWR VGND VPWR VGND sky130_ef_sc_hd__decap_12
XTAP_TAPCELL_ROW_5_185 VGND VPWR sky130_fd_sc_hd__tapvpwrvgnd_1
XFILLER_0_55_159 VGND VGND VPWR VPWR sky130_fd_sc_hd__decap_8
XFILLER_0_28_318 VPWR VGND VPWR VGND sky130_ef_sc_hd__decap_12
XFILLER_0_59_15 VPWR VGND VPWR VGND sky130_ef_sc_hd__decap_12
XscaleAdd._494_ operator.io_outExp\[1\] scaleAdd._164_ VGND VGND VPWR VPWR scaleAdd._166_
+ sky130_fd_sc_hd__or2_1
Xaccumulator._1360_ accumulator.io_inMant\[2\] accumulator.io_inMant\[1\] accumulator._0415_
+ VGND VGND VPWR VPWR accumulator._0458_ sky130_fd_sc_hd__mux2_1
Xaccumulator._1291_ accumulator._0386_ accumulator._0388_ VGND VGND VPWR VPWR accumulator._0389_
+ sky130_fd_sc_hd__nand2b_2
XFILLER_0_42_365 VGND VGND VPWR VPWR sky130_fd_sc_hd__decap_8
XFILLER_0_40_83 VGND VGND VPWR VPWR sky130_fd_sc_hd__fill_1
XFILLER_0_64_3 VPWR VGND VPWR VGND sky130_ef_sc_hd__decap_12
XPHY_EDGE_ROW_12_Right_12 VGND VGND VPWR VPWR sky130_fd_sc_hd__decap_3
Xaccumulator._1627_ accumulator._0720_ accumulator._0721_ VGND VGND VPWR VPWR accumulator._0725_
+ sky130_fd_sc_hd__nor2_1
Xaccumulator._1558_ accumulator._0645_ accumulator._0652_ accumulator._0655_ accumulator._0581_
+ VGND VGND VPWR VPWR accumulator._0656_ sky130_fd_sc_hd__o2bb2a_1
Xaccumulator._1489_ accumulator._0518_ accumulator._0523_ accumulator._0439_ VGND
+ VGND VPWR VPWR accumulator._0587_ sky130_fd_sc_hd__a21o_1
XPHY_EDGE_ROW_21_Right_21 VGND VGND VPWR VPWR sky130_fd_sc_hd__decap_3
XTAP_TAPCELL_ROW_53_522 VGND VPWR sky130_fd_sc_hd__tapvpwrvgnd_1
XFILLER_0_37_126 VPWR VGND VPWR VGND sky130_ef_sc_hd__decap_12
XFILLER_0_60_173 VGND VGND VPWR VPWR sky130_fd_sc_hd__fill_1
XPHY_EDGE_ROW_30_Right_30 VGND VGND VPWR VPWR sky130_fd_sc_hd__decap_3
XFILLER_0_29_18 VGND VGND VPWR VPWR sky130_fd_sc_hd__decap_8
XFILLER_0_61_27 VPWR VGND VPWR VGND sky130_ef_sc_hd__decap_12
XFILLER_0_45_39 VGND VGND VPWR VPWR sky130_fd_sc_hd__fill_2
XTAP_TAPCELL_ROW_16_257 VGND VPWR sky130_fd_sc_hd__tapvpwrvgnd_1
XFILLER_0_43_129 VGND VGND VPWR VPWR sky130_fd_sc_hd__decap_8
XFILLER_0_36_192 VGND VGND VPWR VPWR sky130_fd_sc_hd__decap_4
XFILLER_0_36_170 VGND VGND VPWR VPWR sky130_fd_sc_hd__decap_4
XFILLER_0_51_173 VPWR VGND VPWR VGND sky130_ef_sc_hd__decap_12
XscaleAdd._546_ scaleAdd._212_ scaleAdd._213_ scaleAdd._199_ VGND VGND VPWR VPWR scaleAdd._214_
+ sky130_fd_sc_hd__a21o_1
XFILLER_0_24_365 VGND VGND VPWR VPWR sky130_fd_sc_hd__decap_6
XFILLER_0_3_237 VPWR VGND VPWR VGND sky130_ef_sc_hd__decap_12
XscaleAdd._477_ scaleAdd._149_ scaleAdd._151_ scaleAdd._152_ VGND VGND VPWR VPWR accumulator.io_inMant\[13\]
+ sky130_fd_sc_hd__o21ba_1
XTAP_TAPCELL_ROW_67_614 VGND VPWR sky130_fd_sc_hd__tapvpwrvgnd_1
Xaccumulator._1343_ accumulator._0434_ accumulator._0440_ VGND VGND VPWR VPWR accumulator._0441_
+ sky130_fd_sc_hd__nor2_1
Xaccumulator._1412_ accumulator._0506_ accumulator._0509_ accumulator._0439_ VGND
+ VGND VPWR VPWR accumulator._0510_ sky130_fd_sc_hd__a21o_1
XFILLER_0_29_6 VPWR VGND VPWR VGND sky130_ef_sc_hd__decap_12
XFILLER_0_19_51 VGND VGND VPWR VPWR sky130_fd_sc_hd__decap_4
XFILLER_0_19_62 VGND VGND VPWR VPWR sky130_fd_sc_hd__decap_4
Xaccumulator._1274_ accumulator._0340_ accumulator._0339_ VGND VGND VPWR VPWR accumulator._0372_
+ sky130_fd_sc_hd__and2b_1
XFILLER_0_19_137 VGND VGND VPWR VPWR sky130_fd_sc_hd__decap_8
XFILLER_0_51_82 VGND VGND VPWR VPWR sky130_fd_sc_hd__fill_1
XFILLER_0_42_173 VPWR VGND VPWR VGND sky130_ef_sc_hd__decap_12
XFILLER_0_15_332 VGND VGND VPWR VPWR sky130_fd_sc_hd__decap_4
XFILLER_0_53_405 VGND VGND VPWR VPWR sky130_fd_sc_hd__decap_4
XFILLER_0_25_107 VGND VGND VPWR VPWR sky130_fd_sc_hd__decap_4
XTAP_TAPCELL_ROW_13_238 VGND VPWR sky130_fd_sc_hd__tapvpwrvgnd_1
XFILLER_0_33_140 VGND VGND VPWR VPWR sky130_fd_sc_hd__fill_1
XscaleAdd._400_ scaleAdd._021_ scaleAdd._051_ VGND VGND VPWR VPWR scaleAdd._080_ sky130_fd_sc_hd__nor2_1
XscaleAdd._331_ scaleAdd._260_ scaleAdd._012_ scaleAdd._013_ VGND VGND VPWR VPWR accumulator.io_inMant\[6\]
+ sky130_fd_sc_hd__o21a_1
XTAP_TAPCELL_ROW_21_293 VGND VPWR sky130_fd_sc_hd__tapvpwrvgnd_1
XFILLER_0_21_313 VPWR VGND VPWR VGND sky130_ef_sc_hd__decap_12
XFILLER_0_21_357 VGND VGND VPWR VPWR sky130_fd_sc_hd__fill_1
XFILLER_0_56_49 VGND VGND VPWR VPWR sky130_fd_sc_hd__fill_2
XFILLER_0_56_27 VGND VGND VPWR VPWR sky130_fd_sc_hd__fill_1
XFILLER_0_56_265 VPWR VGND VPWR VGND sky130_ef_sc_hd__decap_12
XPHY_EDGE_ROW_28_Left_97 VGND VGND VPWR VPWR sky130_fd_sc_hd__decap_3
XFILLER_0_8_307 VGND VGND VPWR VPWR sky130_fd_sc_hd__fill_1
Xaccumulator._1892_ accumulator._0772_ accumulator._0767_ accumulator._0780_ VGND
+ VGND VPWR VPWR accumulator._0990_ sky130_fd_sc_hd__o21ai_1
Xaccumulator._1961_ accumulator._0699_ accumulator._0835_ VGND VGND VPWR VPWR accumulator._1059_
+ sky130_fd_sc_hd__nand2_1
XFILLER_0_21_30 VGND VGND VPWR VPWR sky130_fd_sc_hd__fill_1
XFILLER_0_21_85 VGND VGND VPWR VPWR sky130_fd_sc_hd__fill_1
XscaleAdd._529_ net20 net25 VGND VGND VPWR VPWR scaleAdd._198_ sky130_fd_sc_hd__or2_1
XFILLER_0_12_357 VGND VGND VPWR VPWR sky130_fd_sc_hd__decap_6
Xaccumulator._1326_ accumulator._0419_ accumulator._0423_ accumulator._0273_ VGND
+ VGND VPWR VPWR accumulator._0424_ sky130_fd_sc_hd__mux2_1
XFILLER_0_1_51 VGND VGND VPWR VPWR sky130_fd_sc_hd__decap_4
XTAP_TAPCELL_ROW_35_396 VGND VPWR sky130_fd_sc_hd__tapvpwrvgnd_1
Xaccumulator._1257_ accumulator.state\[1\] accumulator.state\[0\] VGND VGND VPWR VPWR
+ accumulator._0357_ sky130_fd_sc_hd__nor2b_2
Xaccumulator._1188_ accumulator._0275_ accumulator._0280_ accumulator._0284_ accumulator._0282_
+ accumulator._0287_ VGND VGND VPWR VPWR accumulator._0288_ sky130_fd_sc_hd__o41a_1
XFILLER_0_7_373 VPWR VGND VPWR VGND sky130_ef_sc_hd__decap_12
XTAP_TAPCELL_ROW_10_219 VGND VPWR sky130_fd_sc_hd__tapvpwrvgnd_1
Xhold53 accumulator.io_accOut\[24\] VGND VGND VPWR VPWR net116 sky130_fd_sc_hd__dlygate4sd3_1
XFILLER_0_42_29 VPWR VGND VPWR VGND sky130_ef_sc_hd__decap_12
XTAP_TAPCELL_ROW_26_330 VGND VPWR sky130_fd_sc_hd__tapvpwrvgnd_1
XFILLER_0_67_15 VPWR VGND VPWR VGND sky130_ef_sc_hd__decap_12
XscaleAdd._314_ scaleAdd._221_ scaleAdd._262_ scaleAdd._226_ operator.io_outMant\[4\]
+ VGND VGND VPWR VPWR scaleAdd._263_ sky130_fd_sc_hd__a22o_1
XFILLER_0_21_187 VPWR VGND VPWR VGND sky130_ef_sc_hd__decap_12
XTAP_TAPCELL_ROW_49_488 VGND VPWR sky130_fd_sc_hd__tapvpwrvgnd_1
Xaccumulator._2160_ accumulator._0077_ accumulator._0130_ accumulator._0144_ accumulator._0358_
+ VGND VGND VPWR VPWR accumulator._0145_ sky130_fd_sc_hd__o211ai_2
Xrebuffer18 scaleAdd._122_ VGND VGND VPWR VPWR net81 sky130_fd_sc_hd__dlygate4sd1_1
XFILLER_0_16_85 VPWR VGND VPWR VGND sky130_ef_sc_hd__decap_12
XFILLER_0_44_202 VGND VGND VPWR VPWR sky130_fd_sc_hd__decap_8
Xaccumulator._2091_ accumulator._1138_ accumulator._0039_ VGND VGND VPWR VPWR accumulator._0077_
+ sky130_fd_sc_hd__nand2_1
XFILLER_0_29_254 VPWR VGND VPWR VGND sky130_ef_sc_hd__decap_12
XFILLER_0_29_210 VPWR VGND VPWR VGND sky130_ef_sc_hd__decap_12
XFILLER_0_8_126 VPWR VGND VPWR VGND sky130_ef_sc_hd__decap_12
Xaccumulator._1944_ accumulator._0982_ accumulator._1041_ VGND VGND VPWR VPWR accumulator._1042_
+ sky130_fd_sc_hd__xnor2_1
Xaccumulator._1875_ accumulator._0717_ accumulator._0723_ accumulator._0725_ accumulator._0728_
+ VGND VGND VPWR VPWR accumulator._0973_ sky130_fd_sc_hd__a211o_1
XFILLER_0_32_408 VGND VGND VPWR VPWR sky130_fd_sc_hd__fill_1
XFILLER_0_4_365 VPWR VGND VPWR VGND sky130_ef_sc_hd__decap_12
XFILLER_0_4_321 VPWR VGND VPWR VGND sky130_ef_sc_hd__decap_12
XPHY_EDGE_ROW_6_Right_6 VGND VGND VPWR VPWR sky130_fd_sc_hd__decap_3
Xoperator._062_ operator._002_ operator._005_ operator._003_ VGND VGND VPWR VPWR operator._006_
+ sky130_fd_sc_hd__a21oi_1
XFILLER_0_67_349 VPWR VGND VPWR VGND sky130_ef_sc_hd__decap_12
Xaccumulator._1309_ accumulator._0382_ accumulator._0405_ accumulator._0406_ VGND
+ VGND VPWR VPWR accumulator._0407_ sky130_fd_sc_hd__or3_1
XTAP_TAPCELL_ROW_23_311 VGND VPWR sky130_fd_sc_hd__tapvpwrvgnd_1
Xaccumulator._2289_ accumulator.io_accOut\[30\] accumulator._0357_ VGND VGND VPWR
+ VPWR accumulator._0271_ sky130_fd_sc_hd__or2_1
XFILLER_0_35_279 VGND VGND VPWR VPWR sky130_fd_sc_hd__fill_1
Xoutput32 net32 VGND VGND VPWR VPWR io_accOut[12] sky130_fd_sc_hd__buf_2
Xoutput54 net54 VGND VGND VPWR VPWR io_accOut[3] sky130_fd_sc_hd__buf_2
Xoutput43 net43 VGND VGND VPWR VPWR io_accOut[22] sky130_fd_sc_hd__buf_2
XFILLER_0_53_39 VPWR VGND VPWR VGND sky130_ef_sc_hd__decap_12
XPHY_EDGE_ROW_59_Right_59 VGND VGND VPWR VPWR sky130_fd_sc_hd__decap_3
XTAP_TAPCELL_ROW_46_469 VGND VPWR sky130_fd_sc_hd__tapvpwrvgnd_1
XFILLER_0_26_246 VGND VGND VPWR VPWR sky130_fd_sc_hd__decap_6
XFILLER_0_41_205 VGND VGND VPWR VPWR sky130_fd_sc_hd__decap_3
XFILLER_0_1_335 VGND VGND VPWR VPWR sky130_fd_sc_hd__fill_1
XPHY_EDGE_ROW_68_Right_68 VGND VGND VPWR VPWR sky130_fd_sc_hd__decap_3
Xaccumulator._1660_ accumulator._0756_ accumulator._0757_ VGND VGND VPWR VPWR accumulator._0758_
+ sky130_fd_sc_hd__xor2_4
Xaccumulator._1591_ accumulator._0473_ accumulator._0648_ accumulator._0688_ accumulator._0448_
+ VGND VGND VPWR VPWR accumulator._0689_ sky130_fd_sc_hd__a211o_1
XFILLER_0_49_349 VGND VGND VPWR VPWR sky130_fd_sc_hd__decap_8
XFILLER_0_49_327 VGND VGND VPWR VPWR sky130_fd_sc_hd__decap_8
Xaccumulator._2212_ accumulator._0193_ accumulator._0194_ accumulator._1031_ VGND
+ VGND VPWR VPWR accumulator._0195_ sky130_fd_sc_hd__o21ba_1
Xaccumulator._2143_ accumulator._0125_ accumulator._0127_ accumulator._1138_ VGND
+ VGND VPWR VPWR accumulator._0128_ sky130_fd_sc_hd__mux2_4
XFILLER_0_57_393 VPWR VGND VPWR VGND sky130_ef_sc_hd__decap_12
Xaccumulator._2074_ accumulator._0056_ accumulator._0059_ accumulator._1030_ VGND
+ VGND VPWR VPWR accumulator._0060_ sky130_fd_sc_hd__o21bai_4
Xoperator._114_ operator._048_ operator._049_ VGND VGND VPWR VPWR operator.io_outMant\[4\]
+ sky130_fd_sc_hd__xnor2_4
XFILLER_0_17_279 VGND VGND VPWR VPWR sky130_fd_sc_hd__fill_1
Xaccumulator._1858_ accumulator._0365_ accumulator._0954_ accumulator._0831_ accumulator._0955_
+ VGND VGND VPWR VPWR accumulator._0956_ sky130_fd_sc_hd__o31a_1
Xaccumulator._1927_ accumulator._1006_ accumulator._1014_ VGND VGND VPWR VPWR accumulator._1025_
+ sky130_fd_sc_hd__nor2_2
XFILLER_0_40_293 VPWR VGND VPWR VGND sky130_ef_sc_hd__decap_12
XFILLER_0_4_195 VGND VGND VPWR VPWR sky130_fd_sc_hd__fill_1
XFILLER_0_7_72 VGND VGND VPWR VPWR sky130_fd_sc_hd__fill_2
XPHY_EDGE_ROW_15_Left_84 VGND VGND VPWR VPWR sky130_fd_sc_hd__decap_3
Xaccumulator._1789_ accumulator._0442_ accumulator._0443_ VGND VGND VPWR VPWR accumulator._0887_
+ sky130_fd_sc_hd__nand2_1
XFILLER_0_67_179 VPWR VGND VPWR VGND sky130_ef_sc_hd__decap_12
XFILLER_0_67_113 VPWR VGND VPWR VGND sky130_ef_sc_hd__decap_12
Xrebuffer9 accumulator._0405_ VGND VGND VPWR VPWR net72 sky130_fd_sc_hd__dlygate4sd3_1
XFILLER_0_64_27 VGND VGND VPWR VPWR sky130_fd_sc_hd__fill_1
XFILLER_0_3_19 VGND VGND VPWR VPWR sky130_fd_sc_hd__fill_1
XTAP_TAPCELL_ROW_59_561 VGND VPWR sky130_fd_sc_hd__tapvpwrvgnd_1
XFILLER_0_54_385 VGND VGND VPWR VPWR sky130_fd_sc_hd__fill_1
XFILLER_0_13_97 VPWR VGND VPWR VGND sky130_ef_sc_hd__decap_12
Xaccumulator._1712_ accumulator._0796_ accumulator._0807_ accumulator._0809_ VGND
+ VGND VPWR VPWR accumulator._0810_ sky130_fd_sc_hd__a21o_1
Xaccumulator._1643_ accumulator.io_accOut\[13\] accumulator._0499_ accumulator._0354_
+ VGND VGND VPWR VPWR accumulator._0741_ sky130_fd_sc_hd__mux2_1
Xaccumulator._1574_ accumulator._0670_ accumulator._0671_ VGND VGND VPWR VPWR accumulator._0672_
+ sky130_fd_sc_hd__xnor2_2
XFILLER_0_49_146 VGND VGND VPWR VPWR sky130_fd_sc_hd__fill_1
Xaccumulator._2057_ accumulator._0040_ accumulator._0042_ accumulator._0035_ VGND
+ VGND VPWR VPWR accumulator._0043_ sky130_fd_sc_hd__mux2_1
Xaccumulator._2126_ accumulator._0043_ accumulator._0089_ accumulator._0109_ accumulator._1032_
+ accumulator._0110_ VGND VGND VPWR VPWR accumulator._0111_ sky130_fd_sc_hd__o221a_1
XFILLER_0_20_219 VGND VGND VPWR VPWR sky130_fd_sc_hd__fill_1
XPHY_EDGE_ROW_0_Left_69 VGND VGND VPWR VPWR sky130_fd_sc_hd__decap_3
XFILLER_0_13_293 VGND VGND VPWR VPWR sky130_fd_sc_hd__fill_1
XTAP_TAPCELL_ROW_56_542 VGND VPWR sky130_fd_sc_hd__tapvpwrvgnd_1
XTAP_TAPCELL_ROW_5_186 VGND VPWR sky130_fd_sc_hd__tapvpwrvgnd_1
XFILLER_0_50_29 VPWR VGND VPWR VGND sky130_ef_sc_hd__decap_12
XFILLER_0_36_385 VGND VGND VPWR VPWR sky130_fd_sc_hd__decap_3
XFILLER_0_36_363 VGND VGND VPWR VPWR sky130_fd_sc_hd__fill_1
XFILLER_0_36_341 VGND VGND VPWR VPWR sky130_fd_sc_hd__fill_1
XFILLER_0_59_27 VPWR VGND VPWR VGND sky130_ef_sc_hd__decap_12
XscaleAdd._493_ operator.io_outExp\[1\] scaleAdd._164_ VGND VGND VPWR VPWR scaleAdd._165_
+ sky130_fd_sc_hd__nand2_1
XFILLER_0_46_149 VGND VGND VPWR VPWR sky130_fd_sc_hd__decap_3
Xaccumulator._1290_ accumulator._0374_ accumulator._0387_ VGND VGND VPWR VPWR accumulator._0388_
+ sky130_fd_sc_hd__xor2_2
XFILLER_0_24_96 VGND VGND VPWR VPWR sky130_fd_sc_hd__fill_1
XFILLER_0_24_85 VGND VGND VPWR VPWR sky130_fd_sc_hd__decap_4
XFILLER_0_24_74 VGND VGND VPWR VPWR sky130_fd_sc_hd__decap_8
XFILLER_0_24_41 VPWR VGND VPWR VGND sky130_ef_sc_hd__decap_12
XFILLER_0_6_268 VGND VGND VPWR VPWR sky130_fd_sc_hd__fill_2
Xaccumulator._1626_ accumulator._0536_ accumulator._0538_ VGND VGND VPWR VPWR accumulator._0724_
+ sky130_fd_sc_hd__xnor2_4
XFILLER_0_57_3 VPWR VGND VPWR VGND sky130_ef_sc_hd__decap_12
XFILLER_0_65_81 VGND VGND VPWR VPWR sky130_fd_sc_hd__fill_2
Xaccumulator._1557_ accumulator._0395_ accumulator._0411_ accumulator._0654_ VGND
+ VGND VPWR VPWR accumulator._0655_ sky130_fd_sc_hd__or3_1
Xaccumulator._1488_ accumulator._0482_ accumulator._0491_ accumulator._0473_ VGND
+ VGND VPWR VPWR accumulator._0586_ sky130_fd_sc_hd__a21o_1
Xaccumulator._2109_ accumulator._1048_ accumulator._1098_ accumulator._1124_ VGND
+ VGND VPWR VPWR accumulator._0095_ sky130_fd_sc_hd__mux2_2
XPHY_EDGE_ROW_36_Left_105 VGND VGND VPWR VPWR sky130_fd_sc_hd__decap_3
XFILLER_0_18_363 VGND VGND VPWR VPWR sky130_fd_sc_hd__fill_1
XFILLER_0_60_141 VPWR VGND VPWR VGND sky130_ef_sc_hd__decap_12
XPHY_EDGE_ROW_45_Left_114 VGND VGND VPWR VPWR sky130_fd_sc_hd__decap_3
XFILLER_0_61_39 VPWR VGND VPWR VGND sky130_ef_sc_hd__decap_12
XFILLER_0_28_127 VGND VGND VPWR VPWR sky130_fd_sc_hd__fill_1
XTAP_TAPCELL_ROW_16_258 VGND VPWR sky130_fd_sc_hd__tapvpwrvgnd_1
XPHY_EDGE_ROW_54_Left_123 VGND VGND VPWR VPWR sky130_fd_sc_hd__decap_3
XFILLER_0_24_377 VGND VGND VPWR VPWR sky130_fd_sc_hd__decap_4
XFILLER_0_3_249 VPWR VGND VPWR VGND sky130_ef_sc_hd__decap_12
XPHY_EDGE_ROW_63_Left_132 VGND VGND VPWR VPWR sky130_fd_sc_hd__decap_3
XFILLER_0_51_185 VPWR VGND VPWR VGND sky130_ef_sc_hd__decap_12
XscaleAdd._545_ scaleAdd._197_ scaleAdd._203_ VGND VGND VPWR VPWR scaleAdd._213_ sky130_fd_sc_hd__or2_1
XscaleAdd._476_ scaleAdd._150_ scaleAdd._143_ scaleAdd._149_ VGND VGND VPWR VPWR scaleAdd._152_
+ sky130_fd_sc_hd__and3_1
XTAP_TAPCELL_ROW_67_615 VGND VPWR sky130_fd_sc_hd__tapvpwrvgnd_1
Xaccumulator._1342_ accumulator._0439_ VGND VGND VPWR VPWR accumulator._0440_ sky130_fd_sc_hd__buf_2
Xaccumulator._1411_ accumulator._0454_ accumulator._0508_ accumulator._0470_ VGND
+ VGND VPWR VPWR accumulator._0509_ sky130_fd_sc_hd__a21o_1
Xaccumulator._1273_ accumulator._0322_ accumulator._0370_ accumulator._0349_ VGND
+ VGND VPWR VPWR accumulator._0371_ sky130_fd_sc_hd__mux2_1
XFILLER_0_19_85 VGND VGND VPWR VPWR sky130_fd_sc_hd__fill_1
XFILLER_0_62_406 VGND VGND VPWR VPWR sky130_fd_sc_hd__decap_3
XFILLER_0_59_296 VPWR VGND VPWR VGND sky130_ef_sc_hd__decap_12
XFILLER_0_47_403 VGND VGND VPWR VPWR sky130_fd_sc_hd__fill_2
XFILLER_0_35_95 VGND VGND VPWR VPWR sky130_fd_sc_hd__fill_1
XFILLER_0_34_108 VGND VGND VPWR VPWR sky130_fd_sc_hd__decap_4
XFILLER_0_42_185 VGND VGND VPWR VPWR sky130_fd_sc_hd__decap_6
XFILLER_0_42_141 VGND VGND VPWR VPWR sky130_fd_sc_hd__fill_1
Xaccumulator._1609_ accumulator._0638_ accumulator._0660_ accumulator._0704_ accumulator._0705_
+ accumulator._0706_ VGND VGND VPWR VPWR accumulator._0707_ sky130_fd_sc_hd__a311o_1
XTAP_TAPCELL_ROW_13_239 VGND VPWR sky130_fd_sc_hd__tapvpwrvgnd_1
XTAP_TAPCELL_ROW_21_294 VGND VPWR sky130_fd_sc_hd__tapvpwrvgnd_1
XFILLER_0_33_185 VGND VGND VPWR VPWR sky130_fd_sc_hd__fill_1
XscaleAdd._330_ scaleAdd._260_ scaleAdd._011_ VGND VGND VPWR VPWR scaleAdd._013_ sky130_fd_sc_hd__nand2_1
XFILLER_0_21_325 VGND VGND VPWR VPWR sky130_fd_sc_hd__decap_8
XTAP_TAPCELL_ROW_29_350 VGND VPWR sky130_fd_sc_hd__tapvpwrvgnd_1
XPHY_EDGE_ROW_3_Left_72 VGND VGND VPWR VPWR sky130_fd_sc_hd__decap_3
XFILLER_0_56_277 VPWR VGND VPWR VGND sky130_ef_sc_hd__decap_12
Xaccumulator._1891_ accumulator._0918_ accumulator._0988_ accumulator._0921_ VGND
+ VGND VPWR VPWR accumulator._0989_ sky130_fd_sc_hd__and3b_1
Xaccumulator._1960_ accumulator._0957_ accumulator._1057_ VGND VGND VPWR VPWR accumulator._1058_
+ sky130_fd_sc_hd__xnor2_2
XscaleAdd._528_ net20 net25 VGND VGND VPWR VPWR scaleAdd._197_ sky130_fd_sc_hd__nand2_1
XscaleAdd._459_ scaleAdd._135_ VGND VGND VPWR VPWR scaleAdd._136_ sky130_fd_sc_hd__inv_2
XFILLER_0_62_71 VPWR VGND VPWR VGND sky130_ef_sc_hd__decap_12
XFILLER_0_46_72 VPWR VGND VPWR VGND sky130_ef_sc_hd__decap_12
Xaccumulator._1256_ accumulator._0355_ VGND VGND VPWR VPWR accumulator._0356_ sky130_fd_sc_hd__clkbuf_4
Xaccumulator._1325_ accumulator._0422_ VGND VGND VPWR VPWR accumulator._0423_ sky130_fd_sc_hd__inv_2
XFILLER_0_62_269 VGND VGND VPWR VPWR sky130_fd_sc_hd__decap_8
XFILLER_0_47_277 VGND VGND VPWR VPWR sky130_fd_sc_hd__decap_3
Xaccumulator._1187_ accumulator.io_inExp\[4\] accumulator.io_inExp\[3\] accumulator._0286_
+ VGND VGND VPWR VPWR accumulator._0287_ sky130_fd_sc_hd__o21ai_1
XFILLER_0_7_385 VGND VGND VPWR VPWR sky130_fd_sc_hd__decap_6
XFILLER_0_15_152 VPWR VGND VPWR VGND sky130_ef_sc_hd__decap_12
XFILLER_0_11_391 VGND VGND VPWR VPWR sky130_fd_sc_hd__fill_1
XTAP_TAPCELL_ROW_26_331 VGND VPWR sky130_fd_sc_hd__tapvpwrvgnd_1
XFILLER_0_53_225 VGND VGND VPWR VPWR sky130_fd_sc_hd__decap_4
XFILLER_0_21_122 VGND VGND VPWR VPWR sky130_fd_sc_hd__fill_1
XFILLER_0_21_144 VGND VGND VPWR VPWR sky130_fd_sc_hd__fill_2
XFILLER_0_67_27 VPWR VGND VPWR VGND sky130_ef_sc_hd__decap_12
XscaleAdd._313_ operator.io_outMant\[6\] VGND VGND VPWR VPWR scaleAdd._262_ sky130_fd_sc_hd__buf_6
XFILLER_0_21_177 VGND VGND VPWR VPWR sky130_fd_sc_hd__decap_3
XFILLER_0_21_199 VGND VGND VPWR VPWR sky130_fd_sc_hd__decap_4
XTAP_TAPCELL_ROW_49_489 VGND VPWR sky130_fd_sc_hd__tapvpwrvgnd_1
Xaccumulator._2090_ accumulator._0363_ accumulator._0076_ VGND VGND VPWR VPWR accumulator._0007_
+ sky130_fd_sc_hd__nor2_1
XFILLER_0_29_222 VGND VGND VPWR VPWR sky130_fd_sc_hd__fill_2
Xrebuffer19 accumulator._0034_ VGND VGND VPWR VPWR net82 sky130_fd_sc_hd__buf_6
XFILLER_0_32_85 VGND VGND VPWR VPWR sky130_fd_sc_hd__fill_2
XFILLER_0_32_41 VGND VGND VPWR VPWR sky130_fd_sc_hd__decap_4
XFILLER_0_29_277 VGND VGND VPWR VPWR sky130_fd_sc_hd__decap_3
XFILLER_0_4_333 VPWR VGND VPWR VGND sky130_ef_sc_hd__decap_12
XFILLER_0_8_116 VGND VGND VPWR VPWR sky130_fd_sc_hd__decap_3
XFILLER_0_8_138 VGND VGND VPWR VPWR sky130_fd_sc_hd__fill_2
Xoperator._061_ net10 net9 VGND VGND VPWR VPWR operator._005_ sky130_fd_sc_hd__nand2_1
Xaccumulator._1874_ accumulator._0970_ accumulator._0971_ VGND VGND VPWR VPWR accumulator._0972_
+ sky130_fd_sc_hd__nor2_2
Xaccumulator._1943_ accumulator._0966_ accumulator._0972_ accumulator._0977_ accumulator._0903_
+ VGND VGND VPWR VPWR accumulator._1041_ sky130_fd_sc_hd__o31a_1
XFILLER_0_52_291 VGND VGND VPWR VPWR sky130_fd_sc_hd__fill_1
XFILLER_0_4_377 VPWR VGND VPWR VGND sky130_ef_sc_hd__decap_12
Xaccumulator._1308_ accumulator._0322_ accumulator._0370_ accumulator._0397_ VGND
+ VGND VPWR VPWR accumulator._0406_ sky130_fd_sc_hd__mux2_4
XTAP_TAPCELL_ROW_23_312 VGND VPWR sky130_fd_sc_hd__tapvpwrvgnd_1
Xaccumulator._2288_ accumulator._0266_ accumulator._0268_ VGND VGND VPWR VPWR accumulator._0270_
+ sky130_fd_sc_hd__xnor2_1
Xaccumulator._1239_ accumulator.io_accOut\[28\] accumulator._0338_ VGND VGND VPWR
+ VPWR accumulator._0339_ sky130_fd_sc_hd__or2_1
XFILLER_0_35_225 VGND VGND VPWR VPWR sky130_fd_sc_hd__decap_4
XFILLER_0_7_160 VGND VGND VPWR VPWR sky130_fd_sc_hd__decap_8
Xoutput33 net33 VGND VGND VPWR VPWR io_accOut[13] sky130_fd_sc_hd__buf_2
Xoutput44 net44 VGND VGND VPWR VPWR io_accOut[23] sky130_fd_sc_hd__buf_2
Xoutput55 net55 VGND VGND VPWR VPWR io_accOut[4] sky130_fd_sc_hd__buf_2
XFILLER_0_26_258 VGND VGND VPWR VPWR sky130_fd_sc_hd__decap_3
Xaccumulator._2211_ accumulator._0035_ accumulator._0165_ VGND VGND VPWR VPWR accumulator._0194_
+ sky130_fd_sc_hd__nor2_1
XTAP_TAPCELL_ROW_37_404 VGND VPWR sky130_fd_sc_hd__tapvpwrvgnd_1
Xaccumulator._1590_ accumulator._0593_ accumulator._0594_ accumulator._0615_ accumulator._0616_
+ VGND VGND VPWR VPWR accumulator._0688_ sky130_fd_sc_hd__and4_1
XFILLER_0_27_30 VGND VGND VPWR VPWR sky130_fd_sc_hd__fill_2
XFILLER_0_64_309 VGND VGND VPWR VPWR sky130_fd_sc_hd__decap_6
Xaccumulator._2073_ accumulator._1130_ accumulator._1131_ VGND VGND VPWR VPWR accumulator._0059_
+ sky130_fd_sc_hd__and2_1
Xaccumulator._2142_ accumulator._0126_ accumulator._0106_ accumulator._0047_ VGND
+ VGND VPWR VPWR accumulator._0127_ sky130_fd_sc_hd__mux2_4
XFILLER_0_32_228 VPWR VGND VPWR VGND sky130_ef_sc_hd__decap_12
Xoperator._113_ operator._027_ operator._037_ operator._038_ VGND VGND VPWR VPWR operator._049_
+ sky130_fd_sc_hd__o21ai_4
XFILLER_0_17_225 VPWR VGND VPWR VGND sky130_ef_sc_hd__decap_12
XFILLER_0_68_81 VGND VGND VPWR VPWR sky130_fd_sc_hd__decap_3
Xaccumulator._1857_ accumulator._0365_ accumulator._0701_ VGND VGND VPWR VPWR accumulator._0955_
+ sky130_fd_sc_hd__nand2_1
Xaccumulator._1926_ accumulator._1011_ accumulator._1021_ accumulator._1023_ VGND
+ VGND VPWR VPWR accumulator._1024_ sky130_fd_sc_hd__or3_1
Xaccumulator._1788_ accumulator._0391_ accumulator._0605_ accumulator._0798_ VGND
+ VGND VPWR VPWR accumulator._0886_ sky130_fd_sc_hd__o21ai_1
XFILLER_0_67_169 VGND VGND VPWR VPWR sky130_fd_sc_hd__fill_1
XFILLER_0_67_158 VGND VGND VPWR VPWR sky130_fd_sc_hd__decap_8
XFILLER_0_63_331 VGND VGND VPWR VPWR sky130_fd_sc_hd__fill_2
XFILLER_0_55_309 VGND VGND VPWR VPWR sky130_fd_sc_hd__fill_1
XFILLER_0_48_372 VGND VGND VPWR VPWR sky130_fd_sc_hd__fill_2
XFILLER_0_48_29 VGND VGND VPWR VPWR sky130_fd_sc_hd__decap_8
XTAP_TAPCELL_ROW_59_562 VGND VPWR sky130_fd_sc_hd__tapvpwrvgnd_1
XFILLER_0_46_309 VGND VGND VPWR VPWR sky130_fd_sc_hd__decap_8
XTAP_TAPCELL_ROW_42_440 VGND VPWR sky130_fd_sc_hd__tapvpwrvgnd_1
XFILLER_0_13_65 VGND VGND VPWR VPWR sky130_fd_sc_hd__fill_2
Xaccumulator._1642_ accumulator._0446_ accumulator._0588_ accumulator._0591_ accumulator._0739_
+ VGND VGND VPWR VPWR accumulator._0740_ sky130_fd_sc_hd__a31o_2
Xaccumulator._1711_ accumulator._0799_ accumulator._0808_ accumulator._0803_ accumulator._0800_
+ VGND VGND VPWR VPWR accumulator._0809_ sky130_fd_sc_hd__a31o_1
XFILLER_0_1_111 VGND VGND VPWR VPWR sky130_fd_sc_hd__fill_1
XFILLER_0_1_188 VGND VGND VPWR VPWR sky130_fd_sc_hd__fill_2
XFILLER_0_10_401 VGND VGND VPWR VPWR sky130_fd_sc_hd__decap_8
Xaccumulator._1573_ accumulator.io_accOut\[2\] accumulator._0348_ VGND VGND VPWR VPWR
+ accumulator._0671_ sky130_fd_sc_hd__nand2_1
XFILLER_0_38_73 VGND VGND VPWR VPWR sky130_fd_sc_hd__decap_3
XFILLER_0_64_139 VGND VGND VPWR VPWR sky130_fd_sc_hd__fill_1
XFILLER_0_57_191 VGND VGND VPWR VPWR sky130_fd_sc_hd__decap_6
XFILLER_0_49_169 VGND VGND VPWR VPWR sky130_fd_sc_hd__fill_2
Xaccumulator._2056_ accumulator._0041_ accumulator._1122_ accumulator._1127_ VGND
+ VGND VPWR VPWR accumulator._0042_ sky130_fd_sc_hd__mux2_4
XFILLER_0_45_320 VPWR VGND VPWR VGND sky130_ef_sc_hd__decap_12
Xaccumulator._2125_ accumulator.io_accOut\[10\] accumulator._0350_ VGND VGND VPWR
+ VPWR accumulator._0110_ sky130_fd_sc_hd__nand2_1
Xaccumulator._1909_ accumulator._0906_ accumulator._1006_ VGND VGND VPWR VPWR accumulator._1007_
+ sky130_fd_sc_hd__nand2_1
XTAP_TAPCELL_ROW_56_543 VGND VPWR sky130_fd_sc_hd__tapvpwrvgnd_1
XFILLER_0_55_106 VGND VGND VPWR VPWR sky130_fd_sc_hd__decap_6
XFILLER_0_28_309 VGND VGND VPWR VPWR sky130_fd_sc_hd__fill_1
XFILLER_0_63_194 VGND VGND VPWR VPWR sky130_fd_sc_hd__decap_3
XFILLER_0_51_356 VGND VGND VPWR VPWR sky130_fd_sc_hd__decap_6
XFILLER_0_59_39 VPWR VGND VPWR VGND sky130_ef_sc_hd__decap_12
XscaleAdd._492_ scaleAdd._162_ scaleAdd._163_ VGND VGND VPWR VPWR scaleAdd._164_ sky130_fd_sc_hd__nor2_1
XTAP_TAPCELL_ROW_62_579 VGND VPWR sky130_fd_sc_hd__tapvpwrvgnd_1
XFILLER_0_39_180 VGND VGND VPWR VPWR sky130_fd_sc_hd__fill_1
XFILLER_0_24_53 VGND VGND VPWR VPWR sky130_fd_sc_hd__decap_8
XTAP_TAPCELL_ROW_19_278 VGND VPWR sky130_fd_sc_hd__tapvpwrvgnd_1
XFILLER_0_40_85 VGND VGND VPWR VPWR sky130_fd_sc_hd__decap_3
XFILLER_0_40_41 VGND VGND VPWR VPWR sky130_fd_sc_hd__decap_3
Xaccumulator._1625_ accumulator._0720_ accumulator._0721_ accumulator._0722_ VGND
+ VGND VPWR VPWR accumulator._0723_ sky130_fd_sc_hd__a21boi_1
Xaccumulator._1556_ accumulator._0434_ accumulator._0653_ accumulator._0473_ VGND
+ VGND VPWR VPWR accumulator._0654_ sky130_fd_sc_hd__mux2_4
XFILLER_0_4_41 VGND VGND VPWR VPWR sky130_fd_sc_hd__decap_8
XFILLER_0_10_253 VGND VGND VPWR VPWR sky130_fd_sc_hd__fill_2
Xaccumulator._1487_ accumulator._0583_ accumulator._0584_ VGND VGND VPWR VPWR accumulator._0585_
+ sky130_fd_sc_hd__nor2_1
XFILLER_0_52_109 VPWR VGND VPWR VGND sky130_ef_sc_hd__decap_12
Xaccumulator._2039_ accumulator._1137_ VGND VGND VPWR VPWR accumulator._1138_ sky130_fd_sc_hd__buf_2
Xaccumulator._2108_ net107 accumulator._0351_ VGND VGND VPWR VPWR accumulator._0094_
+ sky130_fd_sc_hd__nand2_1
XFILLER_0_60_153 VPWR VGND VPWR VGND sky130_ef_sc_hd__decap_12
XFILLER_0_68_253 VPWR VGND VPWR VGND sky130_ef_sc_hd__decap_12
XFILLER_0_56_404 VGND VGND VPWR VPWR sky130_fd_sc_hd__fill_1
XTAP_TAPCELL_ROW_16_259 VGND VPWR sky130_fd_sc_hd__tapvpwrvgnd_1
XFILLER_0_51_197 VPWR VGND VPWR VGND sky130_ef_sc_hd__decap_12
XscaleAdd._544_ scaleAdd._197_ scaleAdd._203_ VGND VGND VPWR VPWR scaleAdd._212_ sky130_fd_sc_hd__nand2_1
XFILLER_0_24_345 VGND VGND VPWR VPWR sky130_fd_sc_hd__decap_8
XFILLER_0_24_301 VGND VGND VPWR VPWR sky130_fd_sc_hd__decap_6
XTAP_TAPCELL_ROW_67_616 VGND VPWR sky130_fd_sc_hd__tapvpwrvgnd_1
Xaccumulator._1410_ accumulator.io_accOut\[11\] accumulator._0507_ net64 VGND VGND
+ VPWR VPWR accumulator._0508_ sky130_fd_sc_hd__mux2_1
XscaleAdd._475_ scaleAdd._137_ scaleAdd._148_ scaleAdd._150_ scaleAdd._143_ VGND VGND
+ VPWR VPWR scaleAdd._151_ sky130_fd_sc_hd__o211a_1
XFILLER_0_19_75 VGND VGND VPWR VPWR sky130_fd_sc_hd__fill_1
XFILLER_0_59_231 VPWR VGND VPWR VGND sky130_ef_sc_hd__decap_12
Xaccumulator._1341_ accumulator._0438_ VGND VGND VPWR VPWR accumulator._0439_ sky130_fd_sc_hd__buf_2
Xaccumulator._1272_ accumulator._0368_ accumulator._0369_ VGND VGND VPWR VPWR accumulator._0370_
+ sky130_fd_sc_hd__nor2_1
XFILLER_0_59_275 VGND VGND VPWR VPWR sky130_fd_sc_hd__decap_4
XFILLER_0_51_51 VGND VGND VPWR VPWR sky130_fd_sc_hd__decap_4
XFILLER_0_27_172 VPWR VGND VPWR VGND sky130_ef_sc_hd__decap_12
Xaccumulator._1608_ accumulator._0606_ accumulator._0607_ VGND VGND VPWR VPWR accumulator._0706_
+ sky130_fd_sc_hd__nor2_1
Xaccumulator._1539_ accumulator.io_accOut\[3\] accumulator._0348_ VGND VGND VPWR VPWR
+ accumulator._0637_ sky130_fd_sc_hd__nand2_1
XFILLER_0_65_234 VGND VGND VPWR VPWR sky130_fd_sc_hd__fill_1
XFILLER_0_65_223 VGND VGND VPWR VPWR sky130_fd_sc_hd__fill_1
XFILLER_0_33_131 VGND VGND VPWR VPWR sky130_fd_sc_hd__fill_1
XFILLER_0_0_209 VPWR VGND VPWR VGND sky130_ef_sc_hd__decap_12
XTAP_TAPCELL_ROW_21_295 VGND VPWR sky130_fd_sc_hd__tapvpwrvgnd_1
XFILLER_0_21_337 VPWR VGND VPWR VGND sky130_ef_sc_hd__decap_12
XFILLER_0_56_29 VPWR VGND VPWR VGND sky130_ef_sc_hd__decap_12
XFILLER_0_29_404 VGND VGND VPWR VPWR sky130_fd_sc_hd__fill_1
XTAP_TAPCELL_ROW_29_351 VGND VPWR sky130_fd_sc_hd__tapvpwrvgnd_1
XFILLER_0_56_289 VGND VGND VPWR VPWR sky130_fd_sc_hd__fill_1
XFILLER_0_8_309 VPWR VGND VPWR VGND sky130_ef_sc_hd__decap_12
Xaccumulator._1890_ accumulator._0984_ accumulator._0987_ VGND VGND VPWR VPWR accumulator._0988_
+ sky130_fd_sc_hd__nor2_2
XscaleAdd._527_ scaleAdd._196_ VGND VGND VPWR VPWR accumulator.io_inExp\[3\] sky130_fd_sc_hd__buf_1
XscaleAdd._458_ scaleAdd._133_ scaleAdd._134_ VGND VGND VPWR VPWR scaleAdd._135_ sky130_fd_sc_hd__or2_1
XscaleAdd._389_ scaleAdd._042_ scaleAdd._041_ VGND VGND VPWR VPWR scaleAdd._069_ sky130_fd_sc_hd__and2b_1
XFILLER_0_20_381 VGND VGND VPWR VPWR sky130_fd_sc_hd__fill_1
XFILLER_0_62_83 VGND VGND VPWR VPWR sky130_fd_sc_hd__fill_1
Xaccumulator._1255_ accumulator._0354_ VGND VGND VPWR VPWR accumulator._0355_ sky130_fd_sc_hd__clkbuf_4
Xaccumulator._1186_ accumulator.io_inExp\[5\] accumulator._0285_ VGND VGND VPWR VPWR
+ accumulator._0286_ sky130_fd_sc_hd__nor2_1
X_29_ accumulator.io_accOut\[29\] VGND VGND VPWR VPWR net50 sky130_fd_sc_hd__clkbuf_1
Xaccumulator._1324_ accumulator._0420_ accumulator._0421_ net91 VGND VGND VPWR VPWR
+ accumulator._0422_ sky130_fd_sc_hd__mux2_1
XFILLER_0_62_259 VGND VGND VPWR VPWR sky130_fd_sc_hd__decap_3
XFILLER_0_15_164 VGND VGND VPWR VPWR sky130_fd_sc_hd__decap_4
XFILLER_0_30_134 VGND VGND VPWR VPWR sky130_fd_sc_hd__decap_6
Xhold44 accumulator.io_accOut\[8\] VGND VGND VPWR VPWR net107 sky130_fd_sc_hd__dlygate4sd3_1
XFILLER_0_38_289 VGND VGND VPWR VPWR sky130_fd_sc_hd__fill_1
XTAP_TAPCELL_ROW_26_332 VGND VPWR sky130_fd_sc_hd__tapvpwrvgnd_1
XFILLER_0_67_39 VPWR VGND VPWR VGND sky130_ef_sc_hd__decap_12
XFILLER_0_21_167 VGND VGND VPWR VPWR sky130_fd_sc_hd__fill_1
XscaleAdd._312_ scaleAdd._232_ scaleAdd._256_ VGND VGND VPWR VPWR scaleAdd._261_ sky130_fd_sc_hd__nand2_1
Xaccumulator._1942_ accumulator._0977_ accumulator._1039_ VGND VGND VPWR VPWR accumulator._1040_
+ sky130_fd_sc_hd__xnor2_2
XFILLER_0_32_64 VGND VGND VPWR VPWR sky130_fd_sc_hd__decap_4
XFILLER_0_4_345 VPWR VGND VPWR VGND sky130_ef_sc_hd__decap_12
Xoperator._060_ net9 net4 operator._001_ operator._003_ VGND VGND VPWR VPWR operator._004_
+ sky130_fd_sc_hd__or4_2
Xaccumulator._1873_ accumulator._0967_ accumulator._0969_ accumulator._0728_ VGND
+ VGND VPWR VPWR accumulator._0971_ sky130_fd_sc_hd__a21oi_1
XFILLER_0_4_389 VPWR VGND VPWR VGND sky130_ef_sc_hd__decap_12
XFILLER_0_12_156 VPWR VGND VPWR VGND sky130_ef_sc_hd__decap_12
XFILLER_0_32_3 VPWR VGND VPWR VGND sky130_ef_sc_hd__decap_12
Xaccumulator._1307_ accumulator._0402_ accumulator._0404_ accumulator._0353_ VGND
+ VGND VPWR VPWR accumulator._0405_ sky130_fd_sc_hd__mux2_4
Xaccumulator._1169_ accumulator._0103_ accumulator._0229_ accumulator.io_inMant\[12\]
+ accumulator.io_inMant\[14\] VGND VGND VPWR VPWR accumulator._0239_ sky130_fd_sc_hd__a211o_1
Xaccumulator._2287_ accumulator._0265_ accumulator._0267_ VGND VGND VPWR VPWR accumulator._0268_
+ sky130_fd_sc_hd__xnor2_1
Xaccumulator._1238_ accumulator._0297_ accumulator._0309_ VGND VGND VPWR VPWR accumulator._0338_
+ sky130_fd_sc_hd__or2_1
XFILLER_0_43_281 VGND VGND VPWR VPWR sky130_fd_sc_hd__decap_6
Xoutput34 net34 VGND VGND VPWR VPWR io_accOut[14] sky130_fd_sc_hd__buf_2
Xoutput56 net56 VGND VGND VPWR VPWR io_accOut[5] sky130_fd_sc_hd__buf_2
Xoutput45 net45 VGND VGND VPWR VPWR io_accOut[24] sky130_fd_sc_hd__buf_2
XFILLER_0_58_307 VGND VGND VPWR VPWR sky130_fd_sc_hd__fill_1
XFILLER_0_1_337 VPWR VGND VPWR VGND sky130_ef_sc_hd__decap_12
Xaccumulator._2210_ accumulator._1011_ accumulator._1095_ accumulator._0047_ accumulator._0176_
+ VGND VGND VPWR VPWR accumulator._0193_ sky130_fd_sc_hd__a22o_1
XTAP_TAPCELL_ROW_37_405 VGND VPWR sky130_fd_sc_hd__tapvpwrvgnd_1
Xaccumulator._2141_ accumulator._1042_ accumulator._1088_ accumulator._1119_ VGND
+ VGND VPWR VPWR accumulator._0126_ sky130_fd_sc_hd__mux2_4
XTAP_TAPCELL_ROW_45_460 VGND VPWR sky130_fd_sc_hd__tapvpwrvgnd_1
XFILLER_0_43_74 VPWR VGND VPWR VGND sky130_ef_sc_hd__decap_12
Xaccumulator._2072_ accumulator._0350_ accumulator._0057_ VGND VGND VPWR VPWR accumulator._0058_
+ sky130_fd_sc_hd__or2_1
Xoperator._112_ operator._046_ operator._047_ VGND VGND VPWR VPWR operator._048_ sky130_fd_sc_hd__or2b_2
XFILLER_0_17_237 VGND VGND VPWR VPWR sky130_fd_sc_hd__decap_8
Xaccumulator._1925_ accumulator._1007_ accumulator._1022_ VGND VGND VPWR VPWR accumulator._1023_
+ sky130_fd_sc_hd__nor2_1
XFILLER_0_25_281 VGND VGND VPWR VPWR sky130_fd_sc_hd__decap_8
XFILLER_0_4_197 VGND VGND VPWR VPWR sky130_fd_sc_hd__fill_2
XFILLER_0_4_164 VGND VGND VPWR VPWR sky130_fd_sc_hd__decap_8
XFILLER_0_7_30 VGND VGND VPWR VPWR sky130_fd_sc_hd__decap_8
Xaccumulator._1856_ accumulator._0834_ accumulator._0851_ accumulator._0852_ VGND
+ VGND VPWR VPWR accumulator._0954_ sky130_fd_sc_hd__a21oi_1
Xaccumulator._1787_ accumulator._0442_ accumulator._0443_ VGND VGND VPWR VPWR accumulator._0885_
+ sky130_fd_sc_hd__nor2_1
XFILLER_0_63_365 VPWR VGND VPWR VGND sky130_ef_sc_hd__decap_12
XFILLER_0_23_229 VGND VGND VPWR VPWR sky130_fd_sc_hd__fill_1
XFILLER_0_64_29 VPWR VGND VPWR VGND sky130_ef_sc_hd__decap_12
XTAP_TAPCELL_ROW_59_563 VGND VPWR sky130_fd_sc_hd__tapvpwrvgnd_1
XTAP_TAPCELL_ROW_42_441 VGND VPWR sky130_fd_sc_hd__tapvpwrvgnd_1
XFILLER_0_39_373 VGND VGND VPWR VPWR sky130_fd_sc_hd__decap_8
XFILLER_0_13_55 VGND VGND VPWR VPWR sky130_fd_sc_hd__fill_1
XFILLER_0_22_251 VGND VGND VPWR VPWR sky130_fd_sc_hd__fill_1
Xaccumulator._1572_ accumulator._0533_ accumulator._0661_ accumulator._0666_ accumulator._0668_
+ accumulator._0669_ VGND VGND VPWR VPWR accumulator._0670_ sky130_fd_sc_hd__a32o_2
Xaccumulator._1641_ accumulator._0393_ accumulator._0449_ accumulator._0604_ VGND
+ VGND VPWR VPWR accumulator._0739_ sky130_fd_sc_hd__and3_1
Xaccumulator._1710_ accumulator._0802_ VGND VGND VPWR VPWR accumulator._0808_ sky130_fd_sc_hd__inv_2
XFILLER_0_38_96 VPWR VGND VPWR VGND sky130_ef_sc_hd__decap_12
XFILLER_0_38_85 VGND VGND VPWR VPWR sky130_fd_sc_hd__decap_6
XFILLER_0_38_63 VGND VGND VPWR VPWR sky130_fd_sc_hd__decap_4
XFILLER_0_1_167 VGND VGND VPWR VPWR sky130_fd_sc_hd__fill_1
Xaccumulator._2124_ accumulator._0079_ accumulator._0108_ accumulator._0035_ VGND
+ VGND VPWR VPWR accumulator._0109_ sky130_fd_sc_hd__mux2_1
Xclkbuf_0_clock clock VGND VGND VPWR VPWR clknet_0_clock sky130_fd_sc_hd__clkbuf_16
XFILLER_0_64_107 VPWR VGND VPWR VGND sky130_ef_sc_hd__decap_12
Xaccumulator._2055_ accumulator._1058_ accumulator._1074_ accumulator._1119_ VGND
+ VGND VPWR VPWR accumulator._0041_ sky130_fd_sc_hd__mux2_4
XFILLER_0_45_332 VGND VGND VPWR VPWR sky130_fd_sc_hd__decap_4
Xaccumulator._1839_ accumulator._0819_ accumulator._0936_ VGND VGND VPWR VPWR accumulator._0937_
+ sky130_fd_sc_hd__xnor2_1
XFILLER_0_60_357 VGND VGND VPWR VPWR sky130_fd_sc_hd__decap_3
Xaccumulator._1908_ accumulator._1005_ accumulator._0911_ VGND VGND VPWR VPWR accumulator._1006_
+ sky130_fd_sc_hd__nor2_4
XFILLER_0_55_129 VGND VGND VPWR VPWR sky130_fd_sc_hd__fill_1
XFILLER_0_36_321 VGND VGND VPWR VPWR sky130_fd_sc_hd__decap_8
XFILLER_0_51_335 VGND VGND VPWR VPWR sky130_fd_sc_hd__fill_1
XFILLER_0_36_398 VGND VGND VPWR VPWR sky130_fd_sc_hd__fill_1
XFILLER_0_36_365 VPWR VGND VPWR VGND sky130_ef_sc_hd__decap_12
XscaleAdd._491_ scaleAdd._154_ scaleAdd._159_ scaleAdd._160_ VGND VGND VPWR VPWR scaleAdd._163_
+ sky130_fd_sc_hd__and3_1
XTAP_TAPCELL_ROW_19_279 VGND VPWR sky130_fd_sc_hd__tapvpwrvgnd_1
XFILLER_0_27_376 VGND VGND VPWR VPWR sky130_fd_sc_hd__decap_8
XFILLER_0_27_365 VGND VGND VPWR VPWR sky130_fd_sc_hd__decap_6
XFILLER_0_6_215 VGND VGND VPWR VPWR sky130_fd_sc_hd__fill_1
XFILLER_0_6_248 VGND VGND VPWR VPWR sky130_fd_sc_hd__decap_4
XFILLER_0_6_237 VGND VGND VPWR VPWR sky130_fd_sc_hd__decap_3
XFILLER_0_49_51 VGND VGND VPWR VPWR sky130_fd_sc_hd__decap_4
XFILLER_0_10_232 VGND VGND VPWR VPWR sky130_fd_sc_hd__fill_1
Xaccumulator._1624_ accumulator.io_accOut\[8\] accumulator._0349_ accumulator._0712_
+ VGND VGND VPWR VPWR accumulator._0722_ sky130_fd_sc_hd__nand3_1
Xaccumulator._1555_ accumulator._0541_ accumulator._0542_ VGND VGND VPWR VPWR accumulator._0653_
+ sky130_fd_sc_hd__nand2_1
XFILLER_0_4_97 VPWR VGND VPWR VGND sky130_ef_sc_hd__decap_12
XFILLER_0_65_405 VGND VGND VPWR VPWR sky130_fd_sc_hd__decap_4
Xaccumulator._1486_ accumulator.io_accOut\[7\] accumulator._0349_ VGND VGND VPWR VPWR
+ accumulator._0584_ sky130_fd_sc_hd__nand2_1
Xaccumulator._2107_ accumulator._0087_ accumulator._0091_ accumulator._0092_ VGND
+ VGND VPWR VPWR accumulator._0009_ sky130_fd_sc_hd__o21a_1
XFILLER_0_60_165 VGND VGND VPWR VPWR sky130_fd_sc_hd__decap_8
Xaccumulator._2038_ accumulator._1136_ VGND VGND VPWR VPWR accumulator._1137_ sky130_fd_sc_hd__buf_8
XFILLER_0_45_151 VGND VGND VPWR VPWR sky130_fd_sc_hd__fill_1
XFILLER_0_33_368 VGND VGND VPWR VPWR sky130_fd_sc_hd__decap_3
XFILLER_0_5_281 VPWR VGND VPWR VGND sky130_ef_sc_hd__decap_12
XFILLER_0_5_270 VGND VGND VPWR VPWR sky130_fd_sc_hd__decap_8
XFILLER_0_68_221 VGND VGND VPWR VPWR sky130_fd_sc_hd__decap_3
XFILLER_0_68_265 VPWR VGND VPWR VGND sky130_ef_sc_hd__decap_12
XFILLER_0_32_390 VGND VGND VPWR VPWR sky130_fd_sc_hd__fill_2
XscaleAdd._543_ scaleAdd._211_ VGND VGND VPWR VPWR accumulator.io_inExp\[4\] sky130_fd_sc_hd__buf_1
XscaleAdd._474_ scaleAdd._129_ scaleAdd._141_ VGND VGND VPWR VPWR scaleAdd._150_ sky130_fd_sc_hd__nand2_1
XFILLER_0_10_23 VGND VGND VPWR VPWR sky130_fd_sc_hd__decap_4
XTAP_TAPCELL_ROW_67_617 VGND VPWR sky130_fd_sc_hd__tapvpwrvgnd_1
Xaccumulator._1340_ accumulator._0436_ accumulator._0437_ VGND VGND VPWR VPWR accumulator._0438_
+ sky130_fd_sc_hd__or2_4
XFILLER_0_59_243 VPWR VGND VPWR VGND sky130_ef_sc_hd__decap_12
Xaccumulator._1271_ accumulator.io_accOut\[30\] accumulator.io_accOut\[29\] accumulator.io_accOut\[28\]
+ accumulator.io_accOut\[27\] VGND VGND VPWR VPWR accumulator._0369_ sky130_fd_sc_hd__or4_1
XFILLER_0_42_110 VPWR VGND VPWR VGND sky130_ef_sc_hd__decap_12
XFILLER_0_27_184 VGND VGND VPWR VPWR sky130_fd_sc_hd__decap_4
XFILLER_0_62_3 VPWR VGND VPWR VGND sky130_ef_sc_hd__decap_12
XFILLER_0_30_349 VPWR VGND VPWR VGND sky130_ef_sc_hd__decap_12
XFILLER_0_23_390 VGND VGND VPWR VPWR sky130_fd_sc_hd__fill_2
XFILLER_0_2_251 VGND VGND VPWR VPWR sky130_fd_sc_hd__fill_1
Xaccumulator._1607_ accumulator._0656_ accumulator._0657_ VGND VGND VPWR VPWR accumulator._0705_
+ sky130_fd_sc_hd__and2b_1
Xaccumulator._1538_ accumulator._0389_ accumulator._0627_ accumulator._0634_ accumulator._0581_
+ accumulator._0635_ VGND VGND VPWR VPWR accumulator._0636_ sky130_fd_sc_hd__o32a_1
Xaccumulator._1469_ accumulator._0474_ accumulator._0492_ accumulator._0449_ VGND
+ VGND VPWR VPWR accumulator._0567_ sky130_fd_sc_hd__a21o_1
XFILLER_0_65_279 VGND VGND VPWR VPWR sky130_fd_sc_hd__fill_1
XFILLER_0_65_268 VGND VGND VPWR VPWR sky130_fd_sc_hd__fill_1
XFILLER_0_33_165 VGND VGND VPWR VPWR sky130_fd_sc_hd__decap_3
XFILLER_0_33_110 VGND VGND VPWR VPWR sky130_fd_sc_hd__fill_2
Xclkload0 clknet_2_0__leaf_clock VGND VGND VPWR VPWR clkload0/Y sky130_fd_sc_hd__clkinvlp_4
XFILLER_0_18_173 VGND VGND VPWR VPWR sky130_fd_sc_hd__decap_4
XFILLER_0_18_195 VGND VGND VPWR VPWR sky130_fd_sc_hd__fill_1
XTAP_TAPCELL_ROW_21_296 VGND VPWR sky130_fd_sc_hd__tapvpwrvgnd_1
XFILLER_0_21_349 VGND VGND VPWR VPWR sky130_fd_sc_hd__decap_8
XFILLER_0_56_213 VGND VGND VPWR VPWR sky130_fd_sc_hd__fill_2
XTAP_TAPCELL_ROW_29_352 VGND VPWR sky130_fd_sc_hd__tapvpwrvgnd_1
XTAP_TAPCELL_ROW_12_230 VGND VPWR sky130_fd_sc_hd__tapvpwrvgnd_1
XFILLER_0_21_55 VGND VGND VPWR VPWR sky130_fd_sc_hd__fill_1
XscaleAdd._526_ scaleAdd._194_ scaleAdd._195_ VGND VGND VPWR VPWR scaleAdd._196_ sky130_fd_sc_hd__and2_1
XscaleAdd._457_ scaleAdd._132_ scaleAdd._131_ VGND VGND VPWR VPWR scaleAdd._134_ sky130_fd_sc_hd__and2b_1
XFILLER_0_46_41 VPWR VGND VPWR VGND sky130_ef_sc_hd__decap_12
XFILLER_0_27_6 VPWR VGND VPWR VGND sky130_ef_sc_hd__decap_12
XscaleAdd._388_ scaleAdd._065_ scaleAdd._067_ VGND VGND VPWR VPWR scaleAdd._068_ sky130_fd_sc_hd__nand2_1
X_28_ accumulator.io_accOut\[28\] VGND VGND VPWR VPWR net49 sky130_fd_sc_hd__clkbuf_1
Xaccumulator._1323_ accumulator.io_inMant\[5\] accumulator.io_inMant\[4\] accumulator._0313_
+ VGND VGND VPWR VPWR accumulator._0421_ sky130_fd_sc_hd__mux2_1
XFILLER_0_62_205 VPWR VGND VPWR VGND sky130_ef_sc_hd__decap_12
XFILLER_0_47_257 VPWR VGND VPWR VGND sky130_ef_sc_hd__decap_12
Xaccumulator._1254_ accumulator._0353_ VGND VGND VPWR VPWR accumulator._0354_ sky130_fd_sc_hd__clkbuf_4
Xaccumulator._1185_ net77 VGND VGND VPWR VPWR accumulator._0285_ sky130_fd_sc_hd__buf_2
XFILLER_0_30_113 VGND VGND VPWR VPWR sky130_fd_sc_hd__fill_1
Xhold45 accumulator.io_accOut\[14\] VGND VGND VPWR VPWR net108 sky130_fd_sc_hd__dlygate4sd3_1
XFILLER_0_11_393 VPWR VGND VPWR VGND sky130_ef_sc_hd__decap_12
XTAP_TAPCELL_ROW_26_333 VGND VPWR sky130_fd_sc_hd__tapvpwrvgnd_1
XFILLER_0_53_249 VGND VGND VPWR VPWR sky130_fd_sc_hd__fill_1
XFILLER_0_38_268 VPWR VGND VPWR VGND sky130_ef_sc_hd__decap_12
XFILLER_0_38_224 VGND VGND VPWR VPWR sky130_fd_sc_hd__fill_1
XFILLER_0_61_271 VGND VGND VPWR VPWR sky130_fd_sc_hd__fill_1
XscaleAdd._311_ scaleAdd._249_ scaleAdd._257_ VGND VGND VPWR VPWR scaleAdd._260_ sky130_fd_sc_hd__nor2_1
Xaccumulator._1941_ accumulator._0966_ accumulator._0972_ accumulator._0903_ VGND
+ VGND VPWR VPWR accumulator._1039_ sky130_fd_sc_hd__o21ai_1
Xaccumulator._1872_ accumulator._0728_ accumulator._0967_ accumulator._0969_ VGND
+ VGND VPWR VPWR accumulator._0970_ sky130_fd_sc_hd__and3_1
XFILLER_0_44_249 VGND VGND VPWR VPWR sky130_fd_sc_hd__decap_3
XFILLER_0_44_238 VGND VGND VPWR VPWR sky130_fd_sc_hd__decap_4
XTAP_TAPCELL_ROW_32_369 VGND VPWR sky130_fd_sc_hd__tapvpwrvgnd_1
XFILLER_0_4_357 VGND VGND VPWR VPWR sky130_fd_sc_hd__decap_6
XFILLER_0_57_51 VGND VGND VPWR VPWR sky130_fd_sc_hd__decap_4
XFILLER_0_12_168 VGND VGND VPWR VPWR sky130_fd_sc_hd__fill_2
XscaleAdd._509_ scaleAdd._165_ scaleAdd._168_ scaleAdd._179_ VGND VGND VPWR VPWR scaleAdd._180_
+ sky130_fd_sc_hd__a21o_1
XFILLER_0_67_308 VGND VGND VPWR VPWR sky130_fd_sc_hd__decap_6
Xaccumulator._1306_ accumulator._0402_ accumulator._0403_ VGND VGND VPWR VPWR accumulator._0404_
+ sky130_fd_sc_hd__nand2_1
Xaccumulator._2286_ accumulator.io_accOut\[30\] accumulator._0344_ accumulator._0343_
+ VGND VGND VPWR VPWR accumulator._0267_ sky130_fd_sc_hd__mux2_1
XFILLER_0_28_290 VPWR VGND VPWR VGND sky130_ef_sc_hd__decap_12
Xaccumulator._1168_ accumulator.io_inMant\[9\] accumulator._0219_ accumulator.io_inMant\[10\]
+ VGND VGND VPWR VPWR accumulator._0229_ sky130_fd_sc_hd__o21bai_1
Xaccumulator._1237_ accumulator._0335_ accumulator._0324_ accumulator._0336_ VGND
+ VGND VPWR VPWR accumulator._0337_ sky130_fd_sc_hd__a21o_1
Xoutput57 net57 VGND VGND VPWR VPWR io_accOut[6] sky130_fd_sc_hd__buf_2
Xoutput35 net35 VGND VGND VPWR VPWR io_accOut[15] sky130_fd_sc_hd__buf_2
Xoutput46 net46 VGND VGND VPWR VPWR io_accOut[25] sky130_fd_sc_hd__buf_2
XFILLER_0_66_363 VGND VGND VPWR VPWR sky130_fd_sc_hd__fill_1
XPHY_EDGE_ROW_19_Right_19 VGND VGND VPWR VPWR sky130_fd_sc_hd__decap_3
XFILLER_0_1_305 VPWR VGND VPWR VGND sky130_ef_sc_hd__decap_12
XPHY_EDGE_ROW_28_Right_28 VGND VGND VPWR VPWR sky130_fd_sc_hd__decap_3
XFILLER_0_1_349 VPWR VGND VPWR VGND sky130_ef_sc_hd__decap_12
Xaccumulator._2140_ accumulator._0096_ VGND VGND VPWR VPWR accumulator._0125_ sky130_fd_sc_hd__inv_2
XPHY_EDGE_ROW_37_Right_37 VGND VGND VPWR VPWR sky130_fd_sc_hd__decap_3
XTAP_TAPCELL_ROW_37_406 VGND VPWR sky130_fd_sc_hd__tapvpwrvgnd_1
XFILLER_0_57_385 VGND VGND VPWR VPWR sky130_fd_sc_hd__decap_6
XTAP_TAPCELL_ROW_45_461 VGND VPWR sky130_fd_sc_hd__tapvpwrvgnd_1
XFILLER_0_43_86 VPWR VGND VPWR VGND sky130_ef_sc_hd__decap_12
XFILLER_0_43_53 VGND VGND VPWR VPWR sky130_fd_sc_hd__decap_3
Xaccumulator._2071_ accumulator._1030_ accumulator._0056_ VGND VGND VPWR VPWR accumulator._0057_
+ sky130_fd_sc_hd__nor2_2
Xoperator._111_ operator._045_ operator._043_ VGND VGND VPWR VPWR operator._047_ sky130_fd_sc_hd__or2b_1
XFILLER_0_9_405 VGND VGND VPWR VPWR sky130_fd_sc_hd__decap_4
Xaccumulator._1855_ accumulator._0851_ accumulator._0952_ VGND VGND VPWR VPWR accumulator._0953_
+ sky130_fd_sc_hd__or2b_1
Xaccumulator._1924_ accumulator._0892_ accumulator._0900_ VGND VGND VPWR VPWR accumulator._1022_
+ sky130_fd_sc_hd__or2b_1
XPHY_EDGE_ROW_46_Right_46 VGND VGND VPWR VPWR sky130_fd_sc_hd__decap_3
XFILLER_0_40_230 VGND VGND VPWR VPWR sky130_fd_sc_hd__decap_3
XFILLER_0_4_121 VGND VGND VPWR VPWR sky130_fd_sc_hd__fill_2
XPHY_EDGE_ROW_55_Right_55 VGND VGND VPWR VPWR sky130_fd_sc_hd__decap_3
Xaccumulator._1786_ accumulator._0876_ accumulator._0878_ accumulator._0880_ accumulator._0881_
+ accumulator._0883_ VGND VGND VPWR VPWR accumulator._0884_ sky130_fd_sc_hd__a311o_1
XFILLER_0_0_393 VPWR VGND VPWR VGND sky130_ef_sc_hd__decap_12
XFILLER_0_67_138 VGND VGND VPWR VPWR sky130_fd_sc_hd__decap_4
Xaccumulator._2269_ accumulator.io_accOut\[28\] accumulator._0250_ accumulator._0356_
+ VGND VGND VPWR VPWR accumulator._0251_ sky130_fd_sc_hd__mux2_1
XPHY_EDGE_ROW_64_Right_64 VGND VGND VPWR VPWR sky130_fd_sc_hd__decap_3
XFILLER_0_63_377 VPWR VGND VPWR VGND sky130_ef_sc_hd__decap_12
XFILLER_0_23_208 VPWR VGND VPWR VGND sky130_ef_sc_hd__decap_12
XFILLER_0_16_282 VGND VGND VPWR VPWR sky130_fd_sc_hd__fill_1
XTAP_TAPCELL_ROW_59_564 VGND VPWR sky130_fd_sc_hd__tapvpwrvgnd_1
XFILLER_0_58_105 VGND VGND VPWR VPWR sky130_fd_sc_hd__fill_1
XTAP_TAPCELL_ROW_42_442 VGND VPWR sky130_fd_sc_hd__tapvpwrvgnd_1
XFILLER_0_39_330 VGND VGND VPWR VPWR sky130_fd_sc_hd__fill_1
XFILLER_0_13_12 VGND VGND VPWR VPWR sky130_fd_sc_hd__fill_1
XFILLER_0_13_34 VGND VGND VPWR VPWR sky130_fd_sc_hd__decap_8
XFILLER_0_54_377 VGND VGND VPWR VPWR sky130_fd_sc_hd__decap_8
XFILLER_0_22_230 VGND VGND VPWR VPWR sky130_fd_sc_hd__fill_1
Xaccumulator._1640_ accumulator._0736_ accumulator._0737_ VGND VGND VPWR VPWR accumulator._0738_
+ sky130_fd_sc_hd__or2_1
Xaccumulator._1571_ accumulator._0388_ accumulator._0386_ VGND VGND VPWR VPWR accumulator._0669_
+ sky130_fd_sc_hd__nor2_2
Xaccumulator._2123_ accumulator._0107_ accumulator._0095_ accumulator._1097_ VGND
+ VGND VPWR VPWR accumulator._0108_ sky130_fd_sc_hd__mux2_2
XFILLER_0_54_85 VPWR VGND VPWR VGND sky130_ef_sc_hd__decap_12
XFILLER_0_54_41 VPWR VGND VPWR VGND sky130_ef_sc_hd__decap_12
XPHY_EDGE_ROW_19_Left_88 VGND VGND VPWR VPWR sky130_fd_sc_hd__decap_3
XFILLER_0_64_119 VPWR VGND VPWR VGND sky130_ef_sc_hd__decap_12
XFILLER_0_60_336 VGND VGND VPWR VPWR sky130_fd_sc_hd__fill_2
Xaccumulator._2054_ accumulator._0039_ VGND VGND VPWR VPWR accumulator._0040_ sky130_fd_sc_hd__inv_2
Xaccumulator._1838_ accumulator._0366_ accumulator._0717_ accumulator._0722_ accumulator._0935_
+ VGND VGND VPWR VPWR accumulator._0936_ sky130_fd_sc_hd__a31o_1
Xaccumulator._1907_ accumulator._1001_ accumulator._0997_ accumulator._1004_ VGND
+ VGND VPWR VPWR accumulator._1005_ sky130_fd_sc_hd__or3b_4
Xaccumulator._1769_ accumulator._0861_ accumulator._0859_ accumulator._0856_ accumulator._0866_
+ accumulator._0826_ VGND VGND VPWR VPWR accumulator._0867_ sky130_fd_sc_hd__o311a_4
XFILLER_0_48_171 VGND VGND VPWR VPWR sky130_fd_sc_hd__fill_1
XFILLER_0_63_174 VPWR VGND VPWR VGND sky130_ef_sc_hd__decap_12
XFILLER_0_36_377 VGND VGND VPWR VPWR sky130_fd_sc_hd__decap_8
XscaleAdd._490_ net16 net21 scaleAdd._161_ VGND VGND VPWR VPWR scaleAdd._162_ sky130_fd_sc_hd__and3_1
XFILLER_0_49_96 VGND VGND VPWR VPWR sky130_fd_sc_hd__decap_3
Xaccumulator._1623_ accumulator.io_accOut\[9\] accumulator._0570_ accumulator._0354_
+ VGND VGND VPWR VPWR accumulator._0721_ sky130_fd_sc_hd__mux2_2
XFILLER_0_65_51 VGND VGND VPWR VPWR sky130_fd_sc_hd__decap_4
Xaccumulator._1554_ accumulator._0396_ accumulator._0651_ accumulator._0534_ VGND
+ VGND VPWR VPWR accumulator._0652_ sky130_fd_sc_hd__o21a_1
Xaccumulator._1485_ accumulator._0390_ accumulator._0569_ accumulator._0580_ accumulator._0582_
+ VGND VGND VPWR VPWR accumulator._0583_ sky130_fd_sc_hd__o31a_2
XTAP_TAPCELL_ROW_2_159 VGND VPWR sky130_fd_sc_hd__tapvpwrvgnd_1
Xaccumulator._2037_ accumulator._1095_ accumulator._1011_ accumulator._1026_ accumulator._1135_
+ VGND VGND VPWR VPWR accumulator._1136_ sky130_fd_sc_hd__or4b_4
Xaccumulator._2106_ accumulator._0352_ VGND VGND VPWR VPWR accumulator._0092_ sky130_fd_sc_hd__clkbuf_4
XFILLER_0_60_188 VGND VGND VPWR VPWR sky130_fd_sc_hd__fill_1
XFILLER_0_5_293 VPWR VGND VPWR VGND sky130_ef_sc_hd__decap_12
XFILLER_0_41_391 VGND VGND VPWR VPWR sky130_fd_sc_hd__fill_1
XFILLER_0_68_277 VGND VGND VPWR VPWR sky130_fd_sc_hd__decap_3
XFILLER_0_36_141 VGND VGND VPWR VPWR sky130_fd_sc_hd__decap_8
XFILLER_0_51_166 VGND VGND VPWR VPWR sky130_fd_sc_hd__fill_2
XscaleAdd._542_ scaleAdd._209_ scaleAdd._210_ VGND VGND VPWR VPWR scaleAdd._211_ sky130_fd_sc_hd__and2_1
XFILLER_0_24_358 VGND VGND VPWR VPWR sky130_fd_sc_hd__decap_6
XscaleAdd._473_ scaleAdd._140_ scaleAdd._135_ scaleAdd._137_ scaleAdd._148_ VGND VGND
+ VPWR VPWR scaleAdd._149_ sky130_fd_sc_hd__o211a_1
XFILLER_0_10_13 VGND VGND VPWR VPWR sky130_fd_sc_hd__fill_1
XTAP_TAPCELL_ROW_67_618 VGND VPWR sky130_fd_sc_hd__tapvpwrvgnd_1
XPHY_EDGE_ROW_32_Left_101 VGND VGND VPWR VPWR sky130_fd_sc_hd__decap_3
XFILLER_0_19_55 VGND VGND VPWR VPWR sky130_fd_sc_hd__fill_1
XFILLER_0_59_255 VGND VGND VPWR VPWR sky130_fd_sc_hd__decap_3
Xaccumulator._1270_ accumulator.io_accOut\[26\] accumulator.io_accOut\[25\] accumulator.io_accOut\[24\]
+ accumulator.io_accOut\[23\] VGND VGND VPWR VPWR accumulator._0368_ sky130_fd_sc_hd__or4_1
XTAP_TAPCELL_ROW_15_250 VGND VPWR sky130_fd_sc_hd__tapvpwrvgnd_1
XFILLER_0_51_64 VPWR VGND VPWR VGND sky130_ef_sc_hd__decap_12
XFILLER_0_42_122 VGND VGND VPWR VPWR sky130_fd_sc_hd__decap_6
XPHY_EDGE_ROW_41_Left_110 VGND VGND VPWR VPWR sky130_fd_sc_hd__decap_3
XFILLER_0_30_317 VPWR VGND VPWR VGND sky130_ef_sc_hd__decap_12
XFILLER_0_30_306 VGND VGND VPWR VPWR sky130_fd_sc_hd__fill_2
XFILLER_0_27_196 VPWR VGND VPWR VGND sky130_ef_sc_hd__decap_12
XFILLER_0_15_314 VGND VGND VPWR VPWR sky130_fd_sc_hd__decap_4
XFILLER_0_15_325 VGND VGND VPWR VPWR sky130_fd_sc_hd__fill_1
Xaccumulator._1606_ accumulator._0672_ accumulator._0701_ accumulator._0702_ accumulator._0703_
+ VGND VGND VPWR VPWR accumulator._0704_ sky130_fd_sc_hd__a211o_1
XFILLER_0_55_3 VPWR VGND VPWR VGND sky130_ef_sc_hd__decap_12
Xaccumulator._1468_ accumulator._0536_ accumulator._0538_ accumulator._0565_ VGND
+ VGND VPWR VPWR accumulator._0566_ sky130_fd_sc_hd__a21o_1
Xaccumulator._1537_ accumulator._0446_ accumulator._0495_ VGND VGND VPWR VPWR accumulator._0635_
+ sky130_fd_sc_hd__nand2_1
Xaccumulator._1399_ accumulator.io_accOut\[14\] accumulator._0496_ net64 VGND VGND
+ VPWR VPWR accumulator._0497_ sky130_fd_sc_hd__mux2_1
XFILLER_0_65_258 VGND VGND VPWR VPWR sky130_fd_sc_hd__decap_6
XFILLER_0_65_225 VGND VGND VPWR VPWR sky130_fd_sc_hd__decap_6
Xclkload1 clknet_2_1__leaf_clock VGND VGND VPWR VPWR clkload1/Y sky130_fd_sc_hd__clkinvlp_4
XFILLER_0_18_141 VPWR VGND VPWR VGND sky130_ef_sc_hd__decap_12
XTAP_TAPCELL_ROW_21_297 VGND VPWR sky130_fd_sc_hd__tapvpwrvgnd_1
XTAP_TAPCELL_ROW_29_353 VGND VPWR sky130_fd_sc_hd__tapvpwrvgnd_1
XTAP_TAPCELL_ROW_12_231 VGND VPWR sky130_fd_sc_hd__tapvpwrvgnd_1
XFILLER_0_12_306 VGND VGND VPWR VPWR sky130_fd_sc_hd__fill_2
XFILLER_0_21_89 VGND VGND VPWR VPWR sky130_fd_sc_hd__fill_1
XscaleAdd._525_ scaleAdd._177_ scaleAdd._180_ scaleAdd._193_ VGND VGND VPWR VPWR scaleAdd._195_
+ sky130_fd_sc_hd__nand3_1
XscaleAdd._456_ scaleAdd._131_ scaleAdd._132_ VGND VGND VPWR VPWR scaleAdd._133_ sky130_fd_sc_hd__nor2b_1
XscaleAdd._387_ scaleAdd._046_ scaleAdd._066_ VGND VGND VPWR VPWR scaleAdd._067_ sky130_fd_sc_hd__or2_2
XFILLER_0_46_53 VGND VGND VPWR VPWR sky130_fd_sc_hd__decap_4
Xaccumulator._1253_ accumulator._0343_ accumulator._0345_ VGND VGND VPWR VPWR accumulator._0353_
+ sky130_fd_sc_hd__xor2_4
XFILLER_0_1_55 VGND VGND VPWR VPWR sky130_fd_sc_hd__fill_1
X_27_ accumulator.io_accOut\[27\] VGND VGND VPWR VPWR net48 sky130_fd_sc_hd__clkbuf_1
Xaccumulator._1322_ accumulator.io_inMant\[3\] accumulator.io_inMant\[2\] accumulator._0313_
+ VGND VGND VPWR VPWR accumulator._0420_ sky130_fd_sc_hd__mux2_1
XFILLER_0_62_217 VGND VGND VPWR VPWR sky130_fd_sc_hd__decap_4
XFILLER_0_62_85 VGND VGND VPWR VPWR sky130_fd_sc_hd__decap_6
XFILLER_0_62_41 VGND VGND VPWR VPWR sky130_fd_sc_hd__decap_8
XFILLER_0_47_269 VGND VGND VPWR VPWR sky130_fd_sc_hd__decap_8
Xaccumulator._1184_ accumulator.io_inExp\[5\] accumulator._0283_ VGND VGND VPWR VPWR
+ accumulator._0284_ sky130_fd_sc_hd__xnor2_1
XFILLER_0_1_99 VGND VGND VPWR VPWR sky130_fd_sc_hd__fill_2
XFILLER_0_11_361 VPWR VGND VPWR VGND sky130_ef_sc_hd__decap_12
Xhold46 accumulator.io_accOut\[28\] VGND VGND VPWR VPWR net109 sky130_fd_sc_hd__dlygate4sd3_1
XFILLER_0_61_250 VGND VGND VPWR VPWR sky130_fd_sc_hd__decap_3
XPHY_EDGE_ROW_7_Left_76 VGND VGND VPWR VPWR sky130_fd_sc_hd__decap_3
XFILLER_0_61_294 VGND VGND VPWR VPWR sky130_fd_sc_hd__fill_1
XscaleAdd._310_ scaleAdd._240_ scaleAdd._243_ scaleAdd._258_ scaleAdd._259_ VGND VGND
+ VPWR VPWR accumulator.io_inMant\[5\] sky130_fd_sc_hd__a31oi_2
XFILLER_0_21_169 VGND VGND VPWR VPWR sky130_fd_sc_hd__decap_8
XFILLER_0_16_45 VPWR VGND VPWR VGND sky130_ef_sc_hd__decap_12
XFILLER_0_44_217 VPWR VGND VPWR VGND sky130_ef_sc_hd__decap_12
XFILLER_0_29_269 VGND VGND VPWR VPWR sky130_fd_sc_hd__decap_8
XFILLER_0_29_225 VGND VGND VPWR VPWR sky130_fd_sc_hd__decap_8
Xaccumulator._1871_ accumulator._0819_ accumulator._0934_ accumulator._0968_ VGND
+ VGND VPWR VPWR accumulator._0969_ sky130_fd_sc_hd__o21ai_1
Xaccumulator._1940_ accumulator._0921_ accumulator._1037_ VGND VGND VPWR VPWR accumulator._1038_
+ sky130_fd_sc_hd__xnor2_2
XscaleAdd._439_ scaleAdd._115_ scaleAdd._116_ VGND VGND VPWR VPWR scaleAdd._117_ sky130_fd_sc_hd__xnor2_1
XscaleAdd._508_ scaleAdd._177_ scaleAdd._178_ VGND VGND VPWR VPWR scaleAdd._179_ sky130_fd_sc_hd__nand2_1
XTAP_TAPCELL_ROW_48_481 VGND VPWR sky130_fd_sc_hd__tapvpwrvgnd_1
Xaccumulator._1305_ accumulator._0373_ accumulator._0384_ VGND VGND VPWR VPWR accumulator._0403_
+ sky130_fd_sc_hd__nand2_1
Xaccumulator._2285_ accumulator._0251_ accumulator._0265_ accumulator._0261_ accumulator._0257_
+ VGND VGND VPWR VPWR accumulator._0266_ sky130_fd_sc_hd__a22o_1
XFILLER_0_18_3 VPWR VGND VPWR VGND sky130_ef_sc_hd__decap_12
Xaccumulator._1236_ accumulator._0303_ accumulator._0322_ accumulator.io_accOut\[27\]
+ VGND VGND VPWR VPWR accumulator._0336_ sky130_fd_sc_hd__o21a_1
Xaccumulator._1167_ accumulator.io_inMant\[7\] accumulator._0209_ accumulator.io_inMant\[8\]
+ VGND VGND VPWR VPWR accumulator._0219_ sky130_fd_sc_hd__o21ba_1
Xoutput36 net36 VGND VGND VPWR VPWR io_accOut[16] sky130_fd_sc_hd__buf_2
Xoutput58 net58 VGND VGND VPWR VPWR io_accOut[7] sky130_fd_sc_hd__buf_2
Xoutput47 net47 VGND VGND VPWR VPWR io_accOut[26] sky130_fd_sc_hd__buf_2
XFILLER_0_3_391 VGND VGND VPWR VPWR sky130_fd_sc_hd__fill_1
XFILLER_0_66_331 VPWR VGND VPWR VGND sky130_ef_sc_hd__decap_12
XFILLER_0_58_309 VGND VGND VPWR VPWR sky130_fd_sc_hd__decap_6
XFILLER_0_1_317 VPWR VGND VPWR VGND sky130_ef_sc_hd__decap_12
Xaccumulator._2070_ accumulator._1133_ accumulator._1085_ accumulator._1043_ VGND
+ VGND VPWR VPWR accumulator._0056_ sky130_fd_sc_hd__nand3_2
XTAP_TAPCELL_ROW_45_462 VGND VPWR sky130_fd_sc_hd__tapvpwrvgnd_1
XTAP_TAPCELL_ROW_37_407 VGND VPWR sky130_fd_sc_hd__tapvpwrvgnd_1
XFILLER_0_43_98 VPWR VGND VPWR VGND sky130_ef_sc_hd__decap_12
Xoperator._110_ operator._043_ operator._045_ VGND VGND VPWR VPWR operator._046_ sky130_fd_sc_hd__and2b_1
XFILLER_0_17_206 VPWR VGND VPWR VGND sky130_ef_sc_hd__decap_12
Xaccumulator._1854_ accumulator._0852_ accumulator._0951_ VGND VGND VPWR VPWR accumulator._0952_
+ sky130_fd_sc_hd__xnor2_2
Xaccumulator._1923_ accumulator._1013_ accumulator._1020_ VGND VGND VPWR VPWR accumulator._1021_
+ sky130_fd_sc_hd__or2_1
Xaccumulator._1785_ accumulator._0882_ VGND VGND VPWR VPWR accumulator._0883_ sky130_fd_sc_hd__inv_2
XFILLER_0_40_253 VGND VGND VPWR VPWR sky130_fd_sc_hd__decap_4
XFILLER_0_25_294 VPWR VGND VPWR VGND sky130_ef_sc_hd__decap_12
XFILLER_0_0_361 VGND VGND VPWR VPWR sky130_fd_sc_hd__decap_3
Xaccumulator._2199_ net115 accumulator._0358_ accumulator._0352_ VGND VGND VPWR VPWR
+ accumulator._0183_ sky130_fd_sc_hd__o21ai_1
Xaccumulator._2268_ accumulator._0338_ VGND VGND VPWR VPWR accumulator._0250_ sky130_fd_sc_hd__inv_2
Xaccumulator._1219_ net86 accumulator._0279_ VGND VGND VPWR VPWR accumulator._0319_
+ sky130_fd_sc_hd__xnor2_2
XFILLER_0_63_389 VGND VGND VPWR VPWR sky130_fd_sc_hd__decap_3
XFILLER_0_31_220 VGND VGND VPWR VPWR sky130_fd_sc_hd__decap_4
XFILLER_0_31_286 VGND VGND VPWR VPWR sky130_fd_sc_hd__fill_2
XTAP_TAPCELL_ROW_42_443 VGND VPWR sky130_fd_sc_hd__tapvpwrvgnd_1
XFILLER_0_13_57 VGND VGND VPWR VPWR sky130_fd_sc_hd__decap_8
Xaccumulator._1570_ accumulator._0450_ accumulator._0544_ accumulator._0667_ accumulator._0395_
+ VGND VGND VPWR VPWR accumulator._0668_ sky130_fd_sc_hd__a211oi_2
Xaccumulator._2122_ accumulator._0106_ VGND VGND VPWR VPWR accumulator._0107_ sky130_fd_sc_hd__inv_2
XFILLER_0_54_97 VGND VGND VPWR VPWR sky130_fd_sc_hd__decap_4
XFILLER_0_54_53 VGND VGND VPWR VPWR sky130_fd_sc_hd__decap_6
Xaccumulator._2053_ accumulator._0844_ accumulator._1097_ net102 accumulator._0038_
+ VGND VGND VPWR VPWR accumulator._0039_ sky130_fd_sc_hd__a31o_1
XFILLER_0_9_247 VPWR VGND VPWR VGND sky130_ef_sc_hd__decap_12
XFILLER_0_60_315 VGND VGND VPWR VPWR sky130_fd_sc_hd__fill_1
XFILLER_0_13_220 VGND VGND VPWR VPWR sky130_fd_sc_hd__decap_4
Xaccumulator._1837_ accumulator._0366_ accumulator._0934_ VGND VGND VPWR VPWR accumulator._0935_
+ sky130_fd_sc_hd__nor2_1
Xaccumulator._1768_ accumulator._0712_ accumulator._0713_ accumulator._0861_ accumulator._0863_
+ accumulator._0865_ VGND VGND VPWR VPWR accumulator._0866_ sky130_fd_sc_hd__o221a_1
Xaccumulator._1906_ accumulator._0806_ accumulator._1003_ VGND VGND VPWR VPWR accumulator._1004_
+ sky130_fd_sc_hd__xnor2_2
XFILLER_0_13_297 VGND VGND VPWR VPWR sky130_fd_sc_hd__fill_1
Xaccumulator._1699_ accumulator._0391_ accumulator._0605_ VGND VGND VPWR VPWR accumulator._0797_
+ sky130_fd_sc_hd__nor2_1
XFILLER_0_63_153 VPWR VGND VPWR VGND sky130_ef_sc_hd__decap_12
XFILLER_0_48_194 VGND VGND VPWR VPWR sky130_fd_sc_hd__fill_2
XFILLER_0_63_186 VGND VGND VPWR VPWR sky130_fd_sc_hd__decap_8
XPHY_EDGE_ROW_20_Left_89 VGND VGND VPWR VPWR sky130_fd_sc_hd__decap_3
XFILLER_0_54_131 VGND VGND VPWR VPWR sky130_fd_sc_hd__fill_1
XFILLER_0_2_401 VGND VGND VPWR VPWR sky130_fd_sc_hd__decap_8
Xaccumulator._1622_ accumulator._0447_ accumulator._0718_ accumulator._0719_ VGND
+ VGND VPWR VPWR accumulator._0720_ sky130_fd_sc_hd__o21ba_1
XFILLER_0_65_96 VGND VGND VPWR VPWR sky130_fd_sc_hd__decap_4
Xaccumulator._1484_ accumulator._0395_ accumulator._0581_ accumulator._0408_ VGND
+ VGND VPWR VPWR accumulator._0582_ sky130_fd_sc_hd__or3_1
Xaccumulator._1553_ accumulator._0411_ accumulator._0646_ accumulator._0647_ accumulator._0650_
+ VGND VGND VPWR VPWR accumulator._0651_ sky130_fd_sc_hd__a31o_1
XTAP_TAPCELL_ROW_53_516 VGND VPWR sky130_fd_sc_hd__tapvpwrvgnd_1
Xaccumulator._2036_ accumulator._1028_ accumulator._1021_ accumulator._1134_ VGND
+ VGND VPWR VPWR accumulator._1135_ sky130_fd_sc_hd__or3_1
Xaccumulator._2105_ accumulator._0046_ accumulator._0049_ accumulator._0090_ accumulator._0351_
+ accumulator.io_accOut\[7\] VGND VGND VPWR VPWR accumulator._0091_ sky130_fd_sc_hd__a32o_1
XFILLER_0_33_304 VPWR VGND VPWR VGND sky130_ef_sc_hd__decap_12
XFILLER_0_18_389 VPWR VGND VPWR VGND sky130_ef_sc_hd__decap_12
XscaleAdd._541_ scaleAdd._191_ scaleAdd._194_ scaleAdd._208_ VGND VGND VPWR VPWR scaleAdd._210_
+ sky130_fd_sc_hd__nand3_1
XscaleAdd._472_ scaleAdd._133_ scaleAdd._147_ VGND VGND VPWR VPWR scaleAdd._148_ sky130_fd_sc_hd__xnor2_1
XTAP_TAPCELL_ROW_67_619 VGND VPWR sky130_fd_sc_hd__tapvpwrvgnd_1
XFILLER_0_35_55 VGND VGND VPWR VPWR sky130_fd_sc_hd__fill_1
XFILLER_0_51_87 VPWR VGND VPWR VGND sky130_ef_sc_hd__decap_12
XFILLER_0_51_76 VGND VGND VPWR VPWR sky130_fd_sc_hd__decap_6
XFILLER_0_35_88 VGND VGND VPWR VPWR sky130_fd_sc_hd__fill_1
XFILLER_0_27_131 VGND VGND VPWR VPWR sky130_fd_sc_hd__decap_6
XTAP_TAPCELL_ROW_15_251 VGND VPWR sky130_fd_sc_hd__tapvpwrvgnd_1
XFILLER_0_30_329 VGND VGND VPWR VPWR sky130_fd_sc_hd__decap_4
XFILLER_0_15_337 VPWR VGND VPWR VGND sky130_ef_sc_hd__decap_12
Xaccumulator._1605_ accumulator._0636_ accumulator._0637_ VGND VGND VPWR VPWR accumulator._0703_
+ sky130_fd_sc_hd__nor2_1
XFILLER_0_48_3 VPWR VGND VPWR VGND sky130_ef_sc_hd__decap_12
Xaccumulator._1536_ accumulator._0450_ accumulator._0632_ accumulator._0633_ accumulator._0395_
+ VGND VGND VPWR VPWR accumulator._0634_ sky130_fd_sc_hd__a211oi_1
Xaccumulator._1467_ accumulator._0536_ accumulator._0538_ accumulator._0564_ VGND
+ VGND VPWR VPWR accumulator._0565_ sky130_fd_sc_hd__o21a_1
Xaccumulator._1398_ accumulator._0285_ accumulator._0424_ VGND VGND VPWR VPWR accumulator._0496_
+ sky130_fd_sc_hd__nor2_1
Xaccumulator._2019_ accumulator._1116_ accumulator._1011_ accumulator._1009_ VGND
+ VGND VPWR VPWR accumulator._1117_ sky130_fd_sc_hd__a21oi_1
Xclkload2 clknet_2_3__leaf_clock VGND VGND VPWR VPWR clkload2/Y sky130_fd_sc_hd__bufinv_16
XFILLER_0_18_153 VPWR VGND VPWR VGND sky130_ef_sc_hd__decap_12
XFILLER_0_18_197 VGND VGND VPWR VPWR sky130_fd_sc_hd__decap_4
XFILLER_0_33_156 VGND VGND VPWR VPWR sky130_fd_sc_hd__decap_4
XTAP_TAPCELL_ROW_21_298 VGND VPWR sky130_fd_sc_hd__tapvpwrvgnd_1
XTAP_TAPCELL_ROW_29_354 VGND VPWR sky130_fd_sc_hd__tapvpwrvgnd_1
XFILLER_0_56_237 VPWR VGND VPWR VGND sky130_ef_sc_hd__decap_12
XscaleAdd._524_ scaleAdd._177_ scaleAdd._180_ scaleAdd._193_ VGND VGND VPWR VPWR scaleAdd._194_
+ sky130_fd_sc_hd__a21o_1
XTAP_TAPCELL_ROW_12_232 VGND VPWR sky130_fd_sc_hd__tapvpwrvgnd_1
XFILLER_0_21_57 VPWR VGND VPWR VGND sky130_ef_sc_hd__decap_12
XFILLER_0_21_79 VGND VGND VPWR VPWR sky130_fd_sc_hd__decap_6
XscaleAdd._455_ operator.io_outMant\[4\] scaleAdd._014_ scaleAdd._113_ scaleAdd._112_
+ VGND VGND VPWR VPWR scaleAdd._132_ sky130_fd_sc_hd__a31o_1
XscaleAdd._386_ operator.io_outMant\[3\] scaleAdd._236_ VGND VGND VPWR VPWR scaleAdd._066_
+ sky130_fd_sc_hd__nand2_1
XFILLER_0_62_64 VGND VGND VPWR VPWR sky130_fd_sc_hd__decap_4
Xaccumulator._1252_ net26 net28 VGND VGND VPWR VPWR accumulator._0352_ sky130_fd_sc_hd__nor2_4
Xaccumulator._1183_ accumulator.io_inExp\[4\] accumulator._0276_ VGND VGND VPWR VPWR
+ accumulator._0283_ sky130_fd_sc_hd__nor2_1
X_26_ accumulator.io_accOut\[26\] VGND VGND VPWR VPWR net47 sky130_fd_sc_hd__clkbuf_1
Xaccumulator._1321_ net91 accumulator._0418_ VGND VGND VPWR VPWR accumulator._0419_
+ sky130_fd_sc_hd__nand2_1
XFILLER_0_55_281 VGND VGND VPWR VPWR sky130_fd_sc_hd__decap_6
XPHY_EDGE_ROW_23_Left_92 VGND VGND VPWR VPWR sky130_fd_sc_hd__decap_3
XFILLER_0_30_148 VPWR VGND VPWR VGND sky130_ef_sc_hd__decap_12
XFILLER_0_11_373 VPWR VGND VPWR VGND sky130_ef_sc_hd__decap_12
Xaccumulator._1519_ accumulator._0593_ accumulator._0594_ accumulator._0615_ accumulator._0616_
+ VGND VGND VPWR VPWR accumulator._0617_ sky130_fd_sc_hd__a22o_1
Xhold47 accumulator.io_accOut\[29\] VGND VGND VPWR VPWR net110 sky130_fd_sc_hd__dlygate4sd3_1
XFILLER_0_53_229 VGND VGND VPWR VPWR sky130_fd_sc_hd__fill_1
XFILLER_0_21_137 VGND VGND VPWR VPWR sky130_fd_sc_hd__decap_4
XPHY_EDGE_ROW_60_Left_129 VGND VGND VPWR VPWR sky130_fd_sc_hd__decap_3
XFILLER_0_16_13 VPWR VGND VPWR VGND sky130_ef_sc_hd__decap_12
XFILLER_0_16_35 VGND VGND VPWR VPWR sky130_fd_sc_hd__decap_4
XFILLER_0_16_57 VPWR VGND VPWR VGND sky130_ef_sc_hd__decap_12
XFILLER_0_44_229 VGND VGND VPWR VPWR sky130_fd_sc_hd__decap_4
XFILLER_0_37_281 VPWR VGND VPWR VGND sky130_ef_sc_hd__decap_12
XFILLER_0_32_45 VGND VGND VPWR VPWR sky130_fd_sc_hd__fill_1
XFILLER_0_4_304 VGND VGND VPWR VPWR sky130_fd_sc_hd__decap_4
XFILLER_0_8_109 VGND VGND VPWR VPWR sky130_fd_sc_hd__fill_1
Xaccumulator._1870_ accumulator._0720_ accumulator._0822_ accumulator._0815_ VGND
+ VGND VPWR VPWR accumulator._0968_ sky130_fd_sc_hd__o21a_1
XFILLER_0_52_251 VGND VGND VPWR VPWR sky130_fd_sc_hd__fill_1
XscaleAdd._507_ operator.io_outExp\[2\] scaleAdd._176_ VGND VGND VPWR VPWR scaleAdd._178_
+ sky130_fd_sc_hd__or2_1
XscaleAdd._369_ scaleAdd._048_ scaleAdd._049_ VGND VGND VPWR VPWR scaleAdd._050_ sky130_fd_sc_hd__xnor2_1
XscaleAdd._438_ scaleAdd._089_ scaleAdd._091_ scaleAdd._090_ VGND VGND VPWR VPWR scaleAdd._116_
+ sky130_fd_sc_hd__o21ba_1
XTAP_TAPCELL_ROW_48_482 VGND VPWR sky130_fd_sc_hd__tapvpwrvgnd_1
X_09_ accumulator.io_accOut\[9\] VGND VGND VPWR VPWR net60 sky130_fd_sc_hd__clkbuf_2
Xaccumulator._1235_ accumulator._0333_ accumulator._0332_ accumulator._0334_ VGND
+ VGND VPWR VPWR accumulator._0335_ sky130_fd_sc_hd__a21o_1
Xaccumulator._1166_ accumulator.io_inMant\[5\] accumulator._0200_ accumulator.io_inMant\[6\]
+ VGND VGND VPWR VPWR accumulator._0209_ sky130_fd_sc_hd__o21ba_1
Xaccumulator._1304_ accumulator._0401_ net74 VGND VGND VPWR VPWR accumulator._0402_
+ sky130_fd_sc_hd__xnor2_2
Xaccumulator._2284_ accumulator._0057_ accumulator._0260_ VGND VGND VPWR VPWR accumulator._0265_
+ sky130_fd_sc_hd__nor2_1
XFILLER_0_35_218 VGND VGND VPWR VPWR sky130_fd_sc_hd__decap_6
XFILLER_0_7_197 VGND VGND VPWR VPWR sky130_fd_sc_hd__decap_4
Xoutput59 net59 VGND VGND VPWR VPWR io_accOut[8] sky130_fd_sc_hd__buf_2
Xaccumulator._1999_ accumulator._1096_ VGND VGND VPWR VPWR accumulator._1097_ sky130_fd_sc_hd__buf_2
Xoutput37 net37 VGND VGND VPWR VPWR io_accOut[17] sky130_fd_sc_hd__buf_2
XPHY_EDGE_ROW_1_Right_1 VGND VGND VPWR VPWR sky130_fd_sc_hd__decap_3
XFILLER_0_9_7 VGND VGND VPWR VPWR sky130_fd_sc_hd__fill_1
Xoutput48 net48 VGND VGND VPWR VPWR io_accOut[27] sky130_fd_sc_hd__buf_2
XFILLER_0_66_365 VPWR VGND VPWR VGND sky130_ef_sc_hd__decap_12
XFILLER_0_66_343 VPWR VGND VPWR VGND sky130_ef_sc_hd__decap_12
XFILLER_0_19_281 VPWR VGND VPWR VGND sky130_ef_sc_hd__decap_12
XFILLER_0_1_329 VGND VGND VPWR VPWR sky130_fd_sc_hd__decap_6
XTAP_TAPCELL_ROW_45_463 VGND VPWR sky130_fd_sc_hd__tapvpwrvgnd_1
XTAP_TAPCELL_ROW_37_408 VGND VPWR sky130_fd_sc_hd__tapvpwrvgnd_1
XFILLER_0_57_365 VGND VGND VPWR VPWR sky130_fd_sc_hd__fill_2
Xaccumulator._1922_ accumulator._1017_ accumulator._1019_ VGND VGND VPWR VPWR accumulator._1020_
+ sky130_fd_sc_hd__nand2_1
XFILLER_0_17_218 VGND VGND VPWR VPWR sky130_fd_sc_hd__decap_6
XFILLER_0_68_85 VPWR VGND VPWR VGND sky130_ef_sc_hd__decap_12
XFILLER_0_68_41 VPWR VGND VPWR VGND sky130_ef_sc_hd__decap_12
Xaccumulator._1853_ accumulator._0815_ accumulator._0834_ accumulator._0851_ accumulator._0950_
+ VGND VGND VPWR VPWR accumulator._0951_ sky130_fd_sc_hd__a31o_1
Xaccumulator._1784_ accumulator._0799_ accumulator._0801_ VGND VGND VPWR VPWR accumulator._0882_
+ sky130_fd_sc_hd__nand2_1
XFILLER_0_4_189 VGND VGND VPWR VPWR sky130_fd_sc_hd__decap_6
XFILLER_0_7_55 VGND VGND VPWR VPWR sky130_fd_sc_hd__fill_1
Xaccumulator._2198_ accumulator._0053_ accumulator._0130_ accumulator._0358_ VGND
+ VGND VPWR VPWR accumulator._0182_ sky130_fd_sc_hd__o21a_1
Xaccumulator._1218_ accumulator._0311_ accumulator._0316_ accumulator._0317_ VGND
+ VGND VPWR VPWR accumulator._0318_ sky130_fd_sc_hd__and3_1
Xaccumulator._1149_ accumulator.io_inMant\[6\] accumulator.io_inMant\[4\] accumulator.io_inMant\[3\]
+ accumulator.io_inMant\[5\] VGND VGND VPWR VPWR accumulator._0044_ sky130_fd_sc_hd__or4_1
Xaccumulator._2267_ accumulator._0245_ accumulator._0243_ accumulator._0242_ VGND
+ VGND VPWR VPWR accumulator._0248_ sky130_fd_sc_hd__a21o_1
XFILLER_0_16_251 VGND VGND VPWR VPWR sky130_fd_sc_hd__fill_1
XTAP_TAPCELL_ROW_42_444 VGND VPWR sky130_fd_sc_hd__tapvpwrvgnd_1
Xaccumulator._2121_ accumulator._1084_ accumulator._1040_ net92 VGND VGND VPWR VPWR
+ accumulator._0106_ sky130_fd_sc_hd__mux2_2
XFILLER_0_57_162 VGND VGND VPWR VPWR sky130_fd_sc_hd__decap_6
XFILLER_0_49_118 VPWR VGND VPWR VGND sky130_ef_sc_hd__decap_12
Xaccumulator._2052_ accumulator._1127_ accumulator._1125_ VGND VGND VPWR VPWR accumulator._0038_
+ sky130_fd_sc_hd__nor2_1
XFILLER_0_9_259 VGND VGND VPWR VPWR sky130_fd_sc_hd__fill_1
Xaccumulator._1905_ accumulator._0367_ accumulator._0796_ accumulator._1002_ VGND
+ VGND VPWR VPWR accumulator._1003_ sky130_fd_sc_hd__a21o_1
Xaccumulator._1836_ accumulator._0856_ accumulator._0859_ accumulator._0861_ accumulator._0866_
+ VGND VGND VPWR VPWR accumulator._0934_ sky130_fd_sc_hd__o31a_1
Xaccumulator._1767_ accumulator._0712_ accumulator._0713_ accumulator._0864_ VGND
+ VGND VPWR VPWR accumulator._0865_ sky130_fd_sc_hd__a21o_1
Xaccumulator._1698_ accumulator._0782_ accumulator._0793_ accumulator._0795_ VGND
+ VGND VPWR VPWR accumulator._0796_ sky130_fd_sc_hd__a21o_1
XFILLER_0_0_181 VPWR VGND VPWR VGND sky130_ef_sc_hd__decap_12
XFILLER_0_68_405 VGND VGND VPWR VPWR sky130_fd_sc_hd__decap_4
Xaccumulator._2319_ clknet_2_0__leaf_clock accumulator._0026_ VGND VGND VPWR VPWR
+ accumulator.io_accOut\[24\] sky130_fd_sc_hd__dfxtp_1
XFILLER_0_63_165 VGND VGND VPWR VPWR sky130_fd_sc_hd__decap_3
XFILLER_0_51_305 VPWR VGND VPWR VGND sky130_ef_sc_hd__decap_12
XFILLER_0_36_335 VGND VGND VPWR VPWR sky130_fd_sc_hd__decap_6
XFILLER_0_36_302 VGND VGND VPWR VPWR sky130_fd_sc_hd__decap_6
XFILLER_0_44_390 VGND VGND VPWR VPWR sky130_fd_sc_hd__decap_3
XFILLER_0_59_405 VGND VGND VPWR VPWR sky130_fd_sc_hd__decap_4
XFILLER_0_39_140 VPWR VGND VPWR VGND sky130_ef_sc_hd__decap_12
XFILLER_0_27_335 VGND VGND VPWR VPWR sky130_fd_sc_hd__fill_1
XFILLER_0_42_305 VGND VGND VPWR VPWR sky130_fd_sc_hd__decap_3
XFILLER_0_40_56 VGND VGND VPWR VPWR sky130_fd_sc_hd__decap_6
XFILLER_0_6_229 VGND VGND VPWR VPWR sky130_fd_sc_hd__decap_8
Xaccumulator._1621_ accumulator._0447_ accumulator._0676_ accumulator._0677_ accumulator._0390_
+ VGND VGND VPWR VPWR accumulator._0719_ sky130_fd_sc_hd__a31o_1
Xaccumulator._1552_ accumulator._0440_ accumulator._0648_ accumulator._0649_ accumulator._0493_
+ VGND VGND VPWR VPWR accumulator._0650_ sky130_fd_sc_hd__o211a_1
XFILLER_0_10_246 VGND VGND VPWR VPWR sky130_fd_sc_hd__decap_6
XTAP_TAPCELL_ROW_53_517 VGND VPWR sky130_fd_sc_hd__tapvpwrvgnd_1
Xaccumulator._1483_ accumulator._0388_ accumulator._0386_ VGND VGND VPWR VPWR accumulator._0581_
+ sky130_fd_sc_hd__or2_2
Xaccumulator._2104_ accumulator._0089_ VGND VGND VPWR VPWR accumulator._0090_ sky130_fd_sc_hd__inv_2
XTAP_TAPCELL_ROW_61_572 VGND VPWR sky130_fd_sc_hd__tapvpwrvgnd_1
Xaccumulator._2035_ accumulator._1129_ accumulator._1132_ accumulator._1133_ VGND
+ VGND VPWR VPWR accumulator._1134_ sky130_fd_sc_hd__o21a_1
XFILLER_0_45_143 VGND VGND VPWR VPWR sky130_fd_sc_hd__decap_4
XFILLER_0_33_316 VPWR VGND VPWR VGND sky130_ef_sc_hd__decap_12
XTAP_TAPCELL_ROW_18_271 VGND VPWR sky130_fd_sc_hd__tapvpwrvgnd_1
Xaccumulator._1819_ accumulator._0367_ accumulator._0760_ accumulator._0913_ accumulator._0916_
+ VGND VGND VPWR VPWR accumulator._0917_ sky130_fd_sc_hd__a31o_1
XFILLER_0_51_113 VGND VGND VPWR VPWR sky130_fd_sc_hd__decap_6
XscaleAdd._540_ scaleAdd._191_ scaleAdd._194_ scaleAdd._208_ VGND VGND VPWR VPWR scaleAdd._209_
+ sky130_fd_sc_hd__a21o_1
XFILLER_0_10_37 VGND VGND VPWR VPWR sky130_fd_sc_hd__fill_2
XFILLER_0_32_382 VGND VGND VPWR VPWR sky130_fd_sc_hd__decap_8
XscaleAdd._471_ scaleAdd._111_ scaleAdd._014_ scaleAdd._262_ VGND VGND VPWR VPWR scaleAdd._147_
+ sky130_fd_sc_hd__and3b_1
XFILLER_0_59_279 VGND VGND VPWR VPWR sky130_fd_sc_hd__fill_1
XFILLER_0_51_99 VGND VGND VPWR VPWR sky130_fd_sc_hd__decap_4
XFILLER_0_51_55 VGND VGND VPWR VPWR sky130_fd_sc_hd__fill_1
XFILLER_0_27_165 VGND VGND VPWR VPWR sky130_fd_sc_hd__decap_3
XFILLER_0_27_143 VGND VGND VPWR VPWR sky130_fd_sc_hd__fill_2
XTAP_TAPCELL_ROW_15_252 VGND VPWR sky130_fd_sc_hd__tapvpwrvgnd_1
XFILLER_0_23_393 VPWR VGND VPWR VGND sky130_ef_sc_hd__decap_12
XFILLER_0_15_349 VGND VGND VPWR VPWR sky130_fd_sc_hd__decap_4
Xaccumulator._1604_ accumulator.io_accOut\[2\] accumulator._0349_ accumulator._0670_
+ VGND VGND VPWR VPWR accumulator._0702_ sky130_fd_sc_hd__and3_1
Xaccumulator._1535_ accumulator._0502_ accumulator._0572_ accumulator._0573_ accumulator._0578_
+ accumulator._0512_ VGND VGND VPWR VPWR accumulator._0633_ sky130_fd_sc_hd__o311a_1
XFILLER_0_65_238 VPWR VGND VPWR VGND sky130_ef_sc_hd__decap_12
Xaccumulator._1466_ accumulator._0391_ accumulator._0546_ accumulator._0562_ accumulator._0563_
+ VGND VGND VPWR VPWR accumulator._0564_ sky130_fd_sc_hd__or4b_1
Xaccumulator._1397_ accumulator._0450_ accumulator._0474_ accumulator._0492_ accumulator._0494_
+ VGND VGND VPWR VPWR accumulator._0495_ sky130_fd_sc_hd__a31o_1
Xaccumulator._2018_ accumulator._1026_ VGND VGND VPWR VPWR accumulator._1116_ sky130_fd_sc_hd__inv_2
XFILLER_0_33_113 VPWR VGND VPWR VGND sky130_ef_sc_hd__decap_12
XFILLER_0_33_102 VGND VGND VPWR VPWR sky130_fd_sc_hd__fill_2
XFILLER_0_18_121 VPWR VGND VPWR VGND sky130_ef_sc_hd__decap_12
XFILLER_0_18_165 VGND VGND VPWR VPWR sky130_fd_sc_hd__decap_4
XFILLER_0_14_360 VGND VGND VPWR VPWR sky130_fd_sc_hd__decap_4
XFILLER_0_56_249 VGND VGND VPWR VPWR sky130_fd_sc_hd__decap_3
XFILLER_0_56_205 VGND VGND VPWR VPWR sky130_fd_sc_hd__decap_8
XFILLER_0_52_400 VGND VGND VPWR VPWR sky130_fd_sc_hd__fill_1
XTAP_TAPCELL_ROW_12_233 VGND VPWR sky130_fd_sc_hd__tapvpwrvgnd_1
XFILLER_0_64_293 VGND VGND VPWR VPWR sky130_fd_sc_hd__fill_1
XFILLER_0_24_157 VGND VGND VPWR VPWR sky130_fd_sc_hd__fill_1
XscaleAdd._523_ scaleAdd._191_ scaleAdd._192_ VGND VGND VPWR VPWR scaleAdd._193_ sky130_fd_sc_hd__nand2_1
XscaleAdd._454_ scaleAdd._262_ scaleAdd._014_ scaleAdd._111_ scaleAdd._130_ VGND VGND
+ VPWR VPWR scaleAdd._131_ sky130_fd_sc_hd__a31o_1
XFILLER_0_21_69 VGND VGND VPWR VPWR sky130_fd_sc_hd__decap_4
XscaleAdd._385_ operator.io_outMant\[2\] scaleAdd._236_ scaleAdd._044_ VGND VGND VPWR
+ VPWR scaleAdd._065_ sky130_fd_sc_hd__a21o_1
Xaccumulator._1320_ accumulator.io_inMant\[1\] accumulator.io_inMant\[0\] accumulator._0313_
+ VGND VGND VPWR VPWR accumulator._0418_ sky130_fd_sc_hd__mux2_1
XFILLER_0_47_238 VGND VGND VPWR VPWR sky130_fd_sc_hd__decap_4
Xaccumulator._1251_ accumulator._0350_ VGND VGND VPWR VPWR accumulator._0351_ sky130_fd_sc_hd__clkbuf_4
X_25_ accumulator.io_accOut\[25\] VGND VGND VPWR VPWR net46 sky130_fd_sc_hd__clkbuf_1
XFILLER_0_1_57 VPWR VGND VPWR VGND sky130_ef_sc_hd__decap_12
Xaccumulator._1182_ accumulator._0281_ VGND VGND VPWR VPWR accumulator._0282_ sky130_fd_sc_hd__inv_2
XFILLER_0_7_335 VGND VGND VPWR VPWR sky130_fd_sc_hd__fill_1
XFILLER_0_15_113 VGND VGND VPWR VPWR sky130_fd_sc_hd__decap_8
XFILLER_0_60_3 VPWR VGND VPWR VGND sky130_ef_sc_hd__decap_12
XFILLER_0_11_80 VGND VGND VPWR VPWR sky130_fd_sc_hd__decap_8
XFILLER_0_11_385 VGND VGND VPWR VPWR sky130_fd_sc_hd__decap_6
Xaccumulator._1449_ accumulator._0454_ accumulator._0522_ accumulator._0455_ VGND
+ VGND VPWR VPWR accumulator._0547_ sky130_fd_sc_hd__a21o_1
Xaccumulator._1518_ accumulator.io_accOut\[6\] accumulator._0354_ accumulator._0575_
+ accumulator._0381_ VGND VGND VPWR VPWR accumulator._0616_ sky130_fd_sc_hd__a31o_1
Xhold48 accumulator.state\[0\] VGND VGND VPWR VPWR net111 sky130_fd_sc_hd__dlygate4sd3_1
XFILLER_0_38_216 VGND VGND VPWR VPWR sky130_fd_sc_hd__decap_8
XFILLER_0_21_149 VPWR VGND VPWR VGND sky130_ef_sc_hd__decap_12
XFILLER_0_16_25 VGND VGND VPWR VPWR sky130_fd_sc_hd__decap_3
XFILLER_0_16_69 VPWR VGND VPWR VGND sky130_ef_sc_hd__decap_12
XFILLER_0_37_293 VPWR VGND VPWR VGND sky130_ef_sc_hd__decap_12
XscaleAdd._437_ scaleAdd._110_ scaleAdd._114_ VGND VGND VPWR VPWR scaleAdd._115_ sky130_fd_sc_hd__xnor2_1
XscaleAdd._506_ operator.io_outExp\[2\] scaleAdd._176_ VGND VGND VPWR VPWR scaleAdd._177_
+ sky130_fd_sc_hd__nand2_1
XFILLER_0_20_193 VGND VGND VPWR VPWR sky130_fd_sc_hd__decap_3
X_08_ accumulator.io_accOut\[8\] VGND VGND VPWR VPWR net59 sky130_fd_sc_hd__buf_1
XFILLER_0_25_6 VPWR VGND VPWR VGND sky130_ef_sc_hd__decap_12
XscaleAdd._368_ operator.io_outMant\[1\] scaleAdd._236_ VGND VGND VPWR VPWR scaleAdd._049_
+ sky130_fd_sc_hd__nand2_1
XscaleAdd._299_ net63 scaleAdd._248_ VGND VGND VPWR VPWR scaleAdd._249_ sky130_fd_sc_hd__nand2_1
Xaccumulator._1303_ accumulator._0342_ accumulator._0300_ VGND VGND VPWR VPWR accumulator._0401_
+ sky130_fd_sc_hd__or2b_1
Xaccumulator._2283_ net110 accumulator._0120_ accumulator._0352_ accumulator._0264_
+ VGND VGND VPWR VPWR accumulator._0031_ sky130_fd_sc_hd__o211a_1
XTAP_TAPCELL_ROW_48_483 VGND VPWR sky130_fd_sc_hd__tapvpwrvgnd_1
XTAP_TAPCELL_ROW_23_306 VGND VPWR sky130_fd_sc_hd__tapvpwrvgnd_1
Xaccumulator._1234_ accumulator._0319_ accumulator._0322_ accumulator.io_accOut\[26\]
+ VGND VGND VPWR VPWR accumulator._0334_ sky130_fd_sc_hd__o21a_1
XFILLER_0_7_110 VGND VGND VPWR VPWR sky130_fd_sc_hd__fill_2
XFILLER_0_7_121 VGND VGND VPWR VPWR sky130_fd_sc_hd__fill_1
Xaccumulator._1165_ accumulator.io_inMant\[3\] accumulator._0191_ accumulator.io_inMant\[4\]
+ VGND VGND VPWR VPWR accumulator._0200_ sky130_fd_sc_hd__o21ba_1
Xaccumulator._1998_ accumulator._1034_ accumulator._1094_ accumulator._1095_ VGND
+ VGND VPWR VPWR accumulator._1096_ sky130_fd_sc_hd__a21oi_2
Xoutput38 net38 VGND VGND VPWR VPWR io_accOut[18] sky130_fd_sc_hd__buf_2
XFILLER_0_3_393 VPWR VGND VPWR VGND sky130_ef_sc_hd__decap_12
XFILLER_0_11_160 VGND VGND VPWR VPWR sky130_fd_sc_hd__decap_8
Xoutput49 net49 VGND VGND VPWR VPWR io_accOut[28] sky130_fd_sc_hd__buf_2
XFILLER_0_66_377 VPWR VGND VPWR VGND sky130_ef_sc_hd__decap_12
XFILLER_0_66_355 VGND VGND VPWR VPWR sky130_fd_sc_hd__decap_8
XFILLER_0_19_293 VGND VGND VPWR VPWR sky130_fd_sc_hd__decap_6
XTAP_TAPCELL_ROW_37_409 VGND VPWR sky130_fd_sc_hd__tapvpwrvgnd_1
XTAP_TAPCELL_ROW_45_464 VGND VPWR sky130_fd_sc_hd__tapvpwrvgnd_1
Xaccumulator._1921_ accumulator._0992_ accumulator._1018_ VGND VGND VPWR VPWR accumulator._1019_
+ sky130_fd_sc_hd__xnor2_2
Xaccumulator._1852_ accumulator._0814_ accumulator._0699_ VGND VGND VPWR VPWR accumulator._0950_
+ sky130_fd_sc_hd__nor2_1
XFILLER_0_25_230 VPWR VGND VPWR VGND sky130_ef_sc_hd__decap_12
XFILLER_0_68_97 VPWR VGND VPWR VGND sky130_ef_sc_hd__decap_12
XFILLER_0_68_53 VGND VGND VPWR VPWR sky130_fd_sc_hd__decap_3
Xaccumulator._1783_ accumulator._0792_ accumulator._0806_ accumulator._0878_ VGND
+ VGND VPWR VPWR accumulator._0881_ sky130_fd_sc_hd__o21a_1
XFILLER_0_7_78 VPWR VGND VPWR VGND sky130_ef_sc_hd__decap_12
XPHY_EDGE_ROW_15_Right_15 VGND VGND VPWR VPWR sky130_fd_sc_hd__decap_3
XPHY_EDGE_ROW_24_Right_24 VGND VGND VPWR VPWR sky130_fd_sc_hd__decap_3
XFILLER_0_23_3 VPWR VGND VPWR VGND sky130_ef_sc_hd__decap_12
Xaccumulator._2266_ accumulator._0120_ accumulator._0246_ accumulator._0247_ VGND
+ VGND VPWR VPWR accumulator._0029_ sky130_fd_sc_hd__a21oi_1
Xaccumulator._2197_ accumulator._0117_ accumulator._0179_ accumulator._0061_ VGND
+ VGND VPWR VPWR accumulator._0180_ sky130_fd_sc_hd__mux2_2
Xaccumulator._1217_ net80 accumulator._0314_ VGND VGND VPWR VPWR accumulator._0317_
+ sky130_fd_sc_hd__xnor2_1
Xaccumulator._1148_ accumulator.io_inMant\[14\] accumulator.io_inMant\[11\] accumulator.io_inMant\[13\]
+ accumulator.io_inMant\[12\] VGND VGND VPWR VPWR accumulator._0034_ sky130_fd_sc_hd__or4_4
XPHY_EDGE_ROW_33_Right_33 VGND VGND VPWR VPWR sky130_fd_sc_hd__decap_3
XFILLER_0_31_299 VGND VGND VPWR VPWR sky130_fd_sc_hd__fill_1
Xoperator._099_ operator._018_ operator._023_ operator._035_ operator._022_ VGND VGND
+ VPWR VPWR operator._036_ sky130_fd_sc_hd__o22a_1
XPHY_EDGE_ROW_42_Right_42 VGND VGND VPWR VPWR sky130_fd_sc_hd__decap_3
XTAP_TAPCELL_ROW_42_445 VGND VPWR sky130_fd_sc_hd__tapvpwrvgnd_1
XPHY_EDGE_ROW_51_Right_51 VGND VGND VPWR VPWR sky130_fd_sc_hd__decap_3
XFILLER_0_39_399 VGND VGND VPWR VPWR sky130_fd_sc_hd__decap_6
XFILLER_0_38_56 VGND VGND VPWR VPWR sky130_fd_sc_hd__fill_1
XPHY_EDGE_ROW_60_Right_60 VGND VGND VPWR VPWR sky130_fd_sc_hd__decap_3
Xaccumulator._2120_ accumulator._0363_ accumulator._0105_ VGND VGND VPWR VPWR accumulator._0011_
+ sky130_fd_sc_hd__nor2_1
XFILLER_0_45_358 VPWR VGND VPWR VGND sky130_ef_sc_hd__decap_12
Xaccumulator._2051_ accumulator._0363_ accumulator._0037_ VGND VGND VPWR VPWR accumulator._0003_
+ sky130_fd_sc_hd__nor2_1
Xaccumulator._1835_ accumulator._0715_ accumulator._0932_ VGND VGND VPWR VPWR accumulator._0933_
+ sky130_fd_sc_hd__xnor2_2
Xaccumulator._1904_ accumulator._0792_ accumulator._0998_ accumulator._0816_ accumulator._0877_
+ VGND VGND VPWR VPWR accumulator._1002_ sky130_fd_sc_hd__o211a_1
Xaccumulator._1766_ accumulator.io_accOut\[7\] accumulator._0349_ accumulator._0583_
+ VGND VGND VPWR VPWR accumulator._0864_ sky130_fd_sc_hd__nand3_1
Xaccumulator._1697_ accumulator._0790_ accumulator._0794_ accumulator._0791_ VGND
+ VGND VPWR VPWR accumulator._0795_ sky130_fd_sc_hd__o21a_1
XFILLER_0_0_193 VGND VGND VPWR VPWR sky130_fd_sc_hd__decap_3
XTAP_TAPCELL_ROW_56_537 VGND VPWR sky130_fd_sc_hd__tapvpwrvgnd_1
XFILLER_0_48_141 VPWR VGND VPWR VGND sky130_ef_sc_hd__decap_12
Xaccumulator._2318_ clknet_2_0__leaf_clock accumulator._0025_ VGND VGND VPWR VPWR
+ accumulator.io_accOut\[23\] sky130_fd_sc_hd__dfxtp_1
Xaccumulator._2249_ accumulator._0225_ accumulator._0228_ VGND VGND VPWR VPWR accumulator._0231_
+ sky130_fd_sc_hd__and2_1
XFILLER_0_51_317 VPWR VGND VPWR VGND sky130_ef_sc_hd__decap_12
XFILLER_0_39_174 VGND VGND VPWR VPWR sky130_fd_sc_hd__decap_6
XFILLER_0_39_152 VGND VGND VPWR VPWR sky130_fd_sc_hd__fill_1
XFILLER_0_49_55 VGND VGND VPWR VPWR sky130_fd_sc_hd__fill_1
XFILLER_0_10_214 VPWR VGND VPWR VGND sky130_ef_sc_hd__decap_12
Xaccumulator._1620_ accumulator._0450_ accumulator._0673_ accumulator._0674_ VGND
+ VGND VPWR VPWR accumulator._0718_ sky130_fd_sc_hd__a21oi_1
Xaccumulator._1482_ accumulator._0411_ accumulator._0503_ accumulator._0510_ accumulator._0579_
+ accumulator._0396_ VGND VGND VPWR VPWR accumulator._0580_ sky130_fd_sc_hd__a311oi_1
Xaccumulator._1551_ accumulator._0436_ accumulator._0437_ accumulator._0615_ accumulator._0616_
+ VGND VGND VPWR VPWR accumulator._0649_ sky130_fd_sc_hd__a2bb2o_1
XFILLER_0_4_57 VPWR VGND VPWR VGND sky130_ef_sc_hd__decap_12
XFILLER_0_4_24 VGND VGND VPWR VPWR sky130_fd_sc_hd__decap_4
XTAP_TAPCELL_ROW_53_518 VGND VPWR sky130_fd_sc_hd__tapvpwrvgnd_1
Xaccumulator._2103_ accumulator._0088_ VGND VGND VPWR VPWR accumulator._0089_ sky130_fd_sc_hd__buf_2
XTAP_TAPCELL_ROW_18_272 VGND VPWR sky130_fd_sc_hd__tapvpwrvgnd_1
Xaccumulator._2034_ accumulator._1036_ accumulator._1038_ accumulator._1091_ VGND
+ VGND VPWR VPWR accumulator._1133_ sky130_fd_sc_hd__and3_1
XTAP_TAPCELL_ROW_61_573 VGND VPWR sky130_fd_sc_hd__tapvpwrvgnd_1
XFILLER_0_45_177 VPWR VGND VPWR VGND sky130_ef_sc_hd__decap_12
XFILLER_0_33_328 VGND VGND VPWR VPWR sky130_fd_sc_hd__fill_2
XFILLER_0_5_252 VGND VGND VPWR VPWR sky130_fd_sc_hd__fill_2
Xaccumulator._1818_ accumulator._0366_ accumulator._0915_ VGND VGND VPWR VPWR accumulator._0916_
+ sky130_fd_sc_hd__nor2_1
XFILLER_0_41_361 VGND VGND VPWR VPWR sky130_fd_sc_hd__decap_8
Xaccumulator._1749_ accumulator._0449_ accumulator._0440_ accumulator._0679_ accumulator._0393_
+ VGND VGND VPWR VPWR accumulator._0847_ sky130_fd_sc_hd__a31o_1
XFILLER_0_68_225 VPWR VGND VPWR VGND sky130_ef_sc_hd__decap_12
XFILLER_0_51_147 VPWR VGND VPWR VGND sky130_ef_sc_hd__decap_12
XFILLER_0_51_103 VGND VGND VPWR VPWR sky130_fd_sc_hd__fill_1
XFILLER_0_32_361 VGND VGND VPWR VPWR sky130_fd_sc_hd__decap_3
XFILLER_0_10_27 VGND VGND VPWR VPWR sky130_fd_sc_hd__fill_1
XFILLER_0_10_49 VGND VGND VPWR VPWR sky130_fd_sc_hd__fill_1
XscaleAdd._470_ scaleAdd._146_ VGND VGND VPWR VPWR accumulator.io_inMant\[12\] sky130_fd_sc_hd__buf_6
XFILLER_0_59_203 VPWR VGND VPWR VGND sky130_ef_sc_hd__decap_12
XFILLER_0_35_57 VPWR VGND VPWR VGND sky130_ef_sc_hd__decap_12
XTAP_TAPCELL_ROW_15_253 VGND VPWR sky130_fd_sc_hd__tapvpwrvgnd_1
XFILLER_0_2_266 VPWR VGND VPWR VGND sky130_ef_sc_hd__decap_12
XTAP_TAPCELL_ROW_66_610 VGND VPWR sky130_fd_sc_hd__tapvpwrvgnd_1
Xaccumulator._1603_ accumulator._0685_ accumulator._0699_ accumulator._0700_ VGND
+ VGND VPWR VPWR accumulator._0701_ sky130_fd_sc_hd__o21ai_1
Xaccumulator._1534_ accumulator._0630_ accumulator._0631_ accumulator._0440_ VGND
+ VGND VPWR VPWR accumulator._0632_ sky130_fd_sc_hd__mux2_1
Xaccumulator._1465_ accumulator.io_accOut\[10\] accumulator._0557_ accumulator._0354_
+ VGND VGND VPWR VPWR accumulator._0563_ sky130_fd_sc_hd__mux2_1
Xaccumulator._2017_ accumulator._1114_ accumulator._1013_ accumulator._1029_ VGND
+ VGND VPWR VPWR accumulator._1115_ sky130_fd_sc_hd__o21ai_1
Xaccumulator._1396_ accumulator._0493_ accumulator._0407_ VGND VGND VPWR VPWR accumulator._0494_
+ sky130_fd_sc_hd__nor2_1
XFILLER_0_18_133 VGND VGND VPWR VPWR sky130_fd_sc_hd__decap_6
XFILLER_0_33_169 VPWR VGND VPWR VGND sky130_ef_sc_hd__decap_12
XFILLER_0_33_125 VGND VGND VPWR VPWR sky130_fd_sc_hd__decap_6
XTAP_TAPCELL_ROW_12_234 VGND VPWR sky130_fd_sc_hd__tapvpwrvgnd_1
XFILLER_0_21_37 VPWR VGND VPWR VGND sky130_ef_sc_hd__decap_12
XscaleAdd._522_ operator.io_outExp\[3\] scaleAdd._190_ VGND VGND VPWR VPWR scaleAdd._192_
+ sky130_fd_sc_hd__or2_1
XscaleAdd._453_ operator.io_outMant\[5\] scaleAdd._014_ scaleAdd._009_ scaleAdd._262_
+ VGND VGND VPWR VPWR scaleAdd._130_ sky130_fd_sc_hd__a22oi_1
XscaleAdd._384_ scaleAdd._063_ VGND VGND VPWR VPWR scaleAdd._064_ sky130_fd_sc_hd__inv_2
XFILLER_0_12_309 VPWR VGND VPWR VGND sky130_ef_sc_hd__decap_12
XFILLER_0_20_342 VGND VGND VPWR VPWR sky130_fd_sc_hd__decap_3
X_24_ accumulator.io_accOut\[24\] VGND VGND VPWR VPWR net45 sky130_fd_sc_hd__buf_1
Xaccumulator._1250_ accumulator.state\[1\] accumulator.state\[0\] VGND VGND VPWR VPWR
+ accumulator._0350_ sky130_fd_sc_hd__nand2b_2
Xaccumulator._1181_ accumulator.io_inExp\[4\] net93 VGND VGND VPWR VPWR accumulator._0281_
+ sky130_fd_sc_hd__xnor2_2
XFILLER_0_15_169 VPWR VGND VPWR VGND sky130_ef_sc_hd__decap_12
XFILLER_0_53_3 VPWR VGND VPWR VGND sky130_ef_sc_hd__decap_12
Xaccumulator._1448_ accumulator._0411_ accumulator._0544_ accumulator._0545_ accumulator._0396_
+ VGND VGND VPWR VPWR accumulator._0546_ sky130_fd_sc_hd__o211a_1
Xaccumulator._1517_ accumulator.io_accOut\[7\] accumulator._0397_ accumulator._0575_
+ accumulator._0412_ VGND VGND VPWR VPWR accumulator._0615_ sky130_fd_sc_hd__a31o_1
Xaccumulator._1379_ accumulator._0416_ accumulator._0426_ accumulator._0414_ VGND
+ VGND VPWR VPWR accumulator._0477_ sky130_fd_sc_hd__mux2_1
Xhold49 accumulator.io_accOut\[27\] VGND VGND VPWR VPWR net112 sky130_fd_sc_hd__dlygate4sd3_1
XFILLER_0_38_228 VGND VGND VPWR VPWR sky130_fd_sc_hd__fill_2
XFILLER_0_34_401 VGND VGND VPWR VPWR sky130_fd_sc_hd__fill_1
XFILLER_0_61_275 VGND VGND VPWR VPWR sky130_fd_sc_hd__decap_4
XFILLER_0_61_264 VGND VGND VPWR VPWR sky130_fd_sc_hd__fill_1
Xclkbuf_2_2__f_clock clknet_0_clock VGND VGND VPWR VPWR clknet_2_2__leaf_clock sky130_fd_sc_hd__clkbuf_16
XFILLER_0_21_106 VGND VGND VPWR VPWR sky130_fd_sc_hd__decap_3
XFILLER_0_52_286 VGND VGND VPWR VPWR sky130_fd_sc_hd__fill_1
XFILLER_0_52_253 VPWR VGND VPWR VGND sky130_ef_sc_hd__decap_12
XFILLER_0_12_106 VGND VGND VPWR VPWR sky130_fd_sc_hd__fill_1
XFILLER_0_57_55 VGND VGND VPWR VPWR sky130_fd_sc_hd__fill_1
XscaleAdd._367_ scaleAdd._045_ scaleAdd._047_ VGND VGND VPWR VPWR scaleAdd._048_ sky130_fd_sc_hd__and2b_1
XscaleAdd._436_ scaleAdd._112_ scaleAdd._113_ VGND VGND VPWR VPWR scaleAdd._114_ sky130_fd_sc_hd__or2b_1
XFILLER_0_12_139 VGND VGND VPWR VPWR sky130_fd_sc_hd__fill_1
XscaleAdd._505_ scaleAdd._162_ scaleAdd._175_ VGND VGND VPWR VPWR scaleAdd._176_ sky130_fd_sc_hd__xnor2_1
XTAP_TAPCELL_ROW_48_484 VGND VPWR sky130_fd_sc_hd__tapvpwrvgnd_1
X_07_ accumulator.io_accOut\[7\] VGND VGND VPWR VPWR net58 sky130_fd_sc_hd__clkbuf_1
Xaccumulator._1302_ accumulator._0399_ VGND VGND VPWR VPWR accumulator._0400_ sky130_fd_sc_hd__buf_2
XscaleAdd._298_ scaleAdd._247_ VGND VGND VPWR VPWR scaleAdd._248_ sky130_fd_sc_hd__buf_2
Xaccumulator._2282_ accumulator._0262_ accumulator._0263_ accumulator._0351_ VGND
+ VGND VPWR VPWR accumulator._0264_ sky130_fd_sc_hd__a21o_1
Xaccumulator._1233_ accumulator.io_accOut\[26\] accumulator._0319_ accumulator._0322_
+ VGND VGND VPWR VPWR accumulator._0333_ sky130_fd_sc_hd__or3_1
XFILLER_0_28_250 VGND VGND VPWR VPWR sky130_fd_sc_hd__fill_2
XTAP_TAPCELL_ROW_23_307 VGND VPWR sky130_fd_sc_hd__tapvpwrvgnd_1
XFILLER_0_7_155 VGND VGND VPWR VPWR sky130_fd_sc_hd__fill_1
Xaccumulator._1164_ accumulator.io_inMant\[2\] accumulator.io_inMant\[1\] VGND VGND
+ VPWR VPWR accumulator._0191_ sky130_fd_sc_hd__and2b_1
Xaccumulator._1997_ accumulator._0892_ accumulator._1008_ accumulator._1022_ VGND
+ VGND VPWR VPWR accumulator._1095_ sky130_fd_sc_hd__a21bo_1
XFILLER_0_43_231 VGND VGND VPWR VPWR sky130_fd_sc_hd__fill_2
XTAP_TAPCELL_ROW_31_362 VGND VPWR sky130_fd_sc_hd__tapvpwrvgnd_1
Xoutput39 net39 VGND VGND VPWR VPWR io_accOut[19] sky130_fd_sc_hd__buf_2
XFILLER_0_3_361 VPWR VGND VPWR VGND sky130_ef_sc_hd__decap_12
XFILLER_0_66_389 VPWR VGND VPWR VGND sky130_ef_sc_hd__decap_12
XFILLER_0_34_253 VPWR VGND VPWR VGND sky130_ef_sc_hd__decap_12
XFILLER_0_34_220 VGND VGND VPWR VPWR sky130_fd_sc_hd__fill_2
XFILLER_0_26_209 VGND VGND VPWR VPWR sky130_fd_sc_hd__fill_2
XTAP_TAPCELL_ROW_45_465 VGND VPWR sky130_fd_sc_hd__tapvpwrvgnd_1
XFILLER_0_43_57 VPWR VGND VPWR VGND sky130_ef_sc_hd__decap_12
Xaccumulator._1851_ accumulator._0948_ accumulator._0858_ VGND VGND VPWR VPWR accumulator._0949_
+ sky130_fd_sc_hd__xor2_2
Xaccumulator._1920_ accumulator._1014_ accumulator._0989_ VGND VGND VPWR VPWR accumulator._1018_
+ sky130_fd_sc_hd__or2_1
XFILLER_0_25_242 VPWR VGND VPWR VGND sky130_ef_sc_hd__decap_12
XFILLER_0_4_136 VGND VGND VPWR VPWR sky130_fd_sc_hd__decap_4
XFILLER_0_7_57 VGND VGND VPWR VPWR sky130_fd_sc_hd__fill_1
Xaccumulator._1782_ accumulator._0785_ accumulator._0879_ accumulator._0786_ VGND
+ VGND VPWR VPWR accumulator._0880_ sky130_fd_sc_hd__o21ai_1
XscaleAdd._419_ scaleAdd._088_ scaleAdd._087_ scaleAdd._096_ VGND VGND VPWR VPWR scaleAdd._098_
+ sky130_fd_sc_hd__and3_1
Xaccumulator._2196_ accumulator._0175_ accumulator._0178_ accumulator._0035_ VGND
+ VGND VPWR VPWR accumulator._0179_ sky130_fd_sc_hd__mux2_2
Xaccumulator._1216_ accumulator._0314_ accumulator._0315_ VGND VGND VPWR VPWR accumulator._0316_
+ sky130_fd_sc_hd__or2_1
Xaccumulator._2265_ net112 accumulator._0358_ accumulator._0352_ VGND VGND VPWR VPWR
+ accumulator._0247_ sky130_fd_sc_hd__o21ai_1
XFILLER_0_63_348 VGND VGND VPWR VPWR sky130_fd_sc_hd__decap_8
XFILLER_0_63_337 VGND VGND VPWR VPWR sky130_fd_sc_hd__fill_2
XFILLER_0_48_389 VGND VGND VPWR VPWR sky130_fd_sc_hd__fill_2
XPHY_EDGE_ROW_39_Left_108 VGND VGND VPWR VPWR sky130_fd_sc_hd__decap_3
Xaccumulator._1147_ accumulator._1126_ VGND VGND VPWR VPWR net61 sky130_fd_sc_hd__clkbuf_1
XFILLER_0_16_253 VGND VGND VPWR VPWR sky130_fd_sc_hd__decap_6
XFILLER_0_7_6 VPWR VGND VPWR VGND sky130_ef_sc_hd__decap_12
Xoperator._098_ operator._020_ operator._024_ VGND VGND VPWR VPWR operator._035_ sky130_fd_sc_hd__nor2_1
XPHY_EDGE_ROW_48_Left_117 VGND VGND VPWR VPWR sky130_fd_sc_hd__decap_3
XFILLER_0_66_186 VGND VGND VPWR VPWR sky130_fd_sc_hd__decap_4
XPHY_EDGE_ROW_57_Left_126 VGND VGND VPWR VPWR sky130_fd_sc_hd__decap_3
XFILLER_0_54_348 VPWR VGND VPWR VGND sky130_ef_sc_hd__decap_12
XFILLER_0_22_256 VGND VGND VPWR VPWR sky130_fd_sc_hd__fill_1
XPHY_EDGE_ROW_66_Left_135 VGND VGND VPWR VPWR sky130_fd_sc_hd__decap_3
Xaccumulator._2050_ accumulator.io_accOut\[1\] accumulator._0364_ accumulator._1032_
+ accumulator._0036_ VGND VGND VPWR VPWR accumulator._0037_ sky130_fd_sc_hd__o2bb2a_1
XFILLER_0_60_307 VGND VGND VPWR VPWR sky130_fd_sc_hd__fill_1
XFILLER_0_57_197 VGND VGND VPWR VPWR sky130_fd_sc_hd__fill_1
Xaccumulator._1834_ accumulator._0366_ accumulator._0927_ accumulator._0930_ accumulator._0860_
+ accumulator._0931_ VGND VGND VPWR VPWR accumulator._0932_ sky130_fd_sc_hd__a221o_1
Xaccumulator._1765_ accumulator._0625_ accumulator._0862_ accumulator._0623_ VGND
+ VGND VPWR VPWR accumulator._0863_ sky130_fd_sc_hd__o21ba_1
Xaccumulator._1903_ accumulator._0792_ accumulator._1000_ VGND VGND VPWR VPWR accumulator._1001_
+ sky130_fd_sc_hd__xor2_2
XFILLER_0_13_267 VPWR VGND VPWR VGND sky130_ef_sc_hd__decap_12
XTAP_TAPCELL_ROW_56_538 VGND VPWR sky130_fd_sc_hd__tapvpwrvgnd_1
Xaccumulator._1696_ accumulator._0534_ accumulator._0668_ accumulator._0784_ VGND
+ VGND VPWR VPWR accumulator._0794_ sky130_fd_sc_hd__and3_1
XTAP_TAPCELL_ROW_64_593 VGND VPWR sky130_fd_sc_hd__tapvpwrvgnd_1
XFILLER_0_63_101 VGND VGND VPWR VPWR sky130_fd_sc_hd__fill_1
XFILLER_0_48_153 VPWR VGND VPWR VGND sky130_ef_sc_hd__decap_12
Xaccumulator._2179_ accumulator._0135_ VGND VGND VPWR VPWR accumulator._0163_ sky130_fd_sc_hd__inv_2
Xaccumulator._2317_ clknet_2_0__leaf_clock accumulator._0024_ VGND VGND VPWR VPWR
+ accumulator.io_accOut\[22\] sky130_fd_sc_hd__dfxtp_1
Xaccumulator._2248_ accumulator._0225_ accumulator._0228_ VGND VGND VPWR VPWR accumulator._0230_
+ sky130_fd_sc_hd__nor2_1
XFILLER_0_48_197 VGND VGND VPWR VPWR sky130_fd_sc_hd__decap_8
XFILLER_0_24_15 VPWR VGND VPWR VGND sky130_ef_sc_hd__decap_12
XFILLER_0_54_178 VPWR VGND VPWR VGND sky130_ef_sc_hd__decap_12
XFILLER_0_40_69 VGND VGND VPWR VPWR sky130_fd_sc_hd__decap_6
XFILLER_0_6_209 VGND VGND VPWR VPWR sky130_fd_sc_hd__decap_6
XFILLER_0_10_226 VGND VGND VPWR VPWR sky130_fd_sc_hd__decap_6
XFILLER_0_65_55 VGND VGND VPWR VPWR sky130_fd_sc_hd__fill_1
Xaccumulator._1481_ accumulator._0502_ accumulator._0572_ accumulator._0573_ accumulator._0578_
+ accumulator._0449_ VGND VGND VPWR VPWR accumulator._0579_ sky130_fd_sc_hd__o311a_1
Xaccumulator._1550_ accumulator._0628_ accumulator._0595_ accumulator._0470_ VGND
+ VGND VPWR VPWR accumulator._0648_ sky130_fd_sc_hd__mux2_1
XFILLER_0_4_69 VPWR VGND VPWR VGND sky130_ef_sc_hd__decap_12
Xaccumulator._2033_ accumulator._1130_ accumulator._1131_ VGND VGND VPWR VPWR accumulator._1132_
+ sky130_fd_sc_hd__and2b_1
XTAP_TAPCELL_ROW_53_519 VGND VPWR sky130_fd_sc_hd__tapvpwrvgnd_1
Xaccumulator._2102_ accumulator._0058_ accumulator._0061_ VGND VGND VPWR VPWR accumulator._0088_
+ sky130_fd_sc_hd__or2_1
XTAP_TAPCELL_ROW_18_273 VGND VPWR sky130_fd_sc_hd__tapvpwrvgnd_1
XTAP_TAPCELL_ROW_61_574 VGND VPWR sky130_fd_sc_hd__tapvpwrvgnd_1
XFILLER_0_60_137 VGND VGND VPWR VPWR sky130_fd_sc_hd__decap_3
XFILLER_0_45_189 VGND VGND VPWR VPWR sky130_fd_sc_hd__decap_3
XFILLER_0_18_359 VGND VGND VPWR VPWR sky130_fd_sc_hd__decap_4
Xaccumulator._1817_ accumulator._0914_ accumulator._0868_ accumulator._0871_ VGND
+ VGND VPWR VPWR accumulator._0915_ sky130_fd_sc_hd__o21a_1
Xaccumulator._1748_ accumulator._0411_ accumulator._0632_ VGND VGND VPWR VPWR accumulator._0846_
+ sky130_fd_sc_hd__nand2_1
XFILLER_0_41_373 VPWR VGND VPWR VGND sky130_ef_sc_hd__decap_12
XFILLER_0_68_237 VPWR VGND VPWR VGND sky130_ef_sc_hd__decap_12
Xaccumulator._1679_ accumulator._0774_ accumulator._0775_ VGND VGND VPWR VPWR accumulator._0777_
+ sky130_fd_sc_hd__nand2_1
XTAP_TAPCELL_ROW_1_152 VGND VPWR sky130_fd_sc_hd__tapvpwrvgnd_1
XFILLER_0_24_307 VGND VGND VPWR VPWR sky130_fd_sc_hd__fill_1
Xfanout63 operator.io_outMant\[0\] VGND VGND VPWR VPWR net63 sky130_fd_sc_hd__buf_2
XFILLER_0_51_159 VGND VGND VPWR VPWR sky130_fd_sc_hd__fill_1
XFILLER_0_10_17 VGND VGND VPWR VPWR sky130_fd_sc_hd__decap_3
XFILLER_0_59_215 VGND VGND VPWR VPWR sky130_fd_sc_hd__decap_3
XFILLER_0_35_69 VGND VGND VPWR VPWR sky130_fd_sc_hd__decap_3
XFILLER_0_67_281 VGND VGND VPWR VPWR sky130_fd_sc_hd__decap_6
XTAP_TAPCELL_ROW_15_254 VGND VPWR sky130_fd_sc_hd__tapvpwrvgnd_1
XFILLER_0_15_318 VGND VGND VPWR VPWR sky130_fd_sc_hd__fill_1
Xaccumulator._1602_ accumulator._0675_ accumulator._0683_ accumulator._0684_ VGND
+ VGND VPWR VPWR accumulator._0700_ sky130_fd_sc_hd__a21o_1
XFILLER_0_2_278 VPWR VGND VPWR VGND sky130_ef_sc_hd__decap_12
XTAP_TAPCELL_ROW_66_611 VGND VPWR sky130_fd_sc_hd__tapvpwrvgnd_1
Xaccumulator._1464_ accumulator._0553_ accumulator._0561_ accumulator._0396_ VGND
+ VGND VPWR VPWR accumulator._0562_ sky130_fd_sc_hd__a21oi_1
Xaccumulator._1395_ accumulator._0448_ VGND VGND VPWR VPWR accumulator._0493_ sky130_fd_sc_hd__buf_2
Xaccumulator._1533_ accumulator._0413_ accumulator._0595_ accumulator._0596_ VGND
+ VGND VPWR VPWR accumulator._0631_ sky130_fd_sc_hd__a21o_1
XFILLER_0_65_207 VPWR VGND VPWR VGND sky130_ef_sc_hd__decap_12
Xaccumulator._2016_ accumulator._1019_ accumulator._1113_ accumulator._1016_ VGND
+ VGND VPWR VPWR accumulator._1114_ sky130_fd_sc_hd__a21oi_1
XFILLER_0_33_148 VGND VGND VPWR VPWR sky130_fd_sc_hd__decap_4
XFILLER_0_64_251 VGND VGND VPWR VPWR sky130_fd_sc_hd__fill_1
XscaleAdd._521_ operator.io_outExp\[3\] scaleAdd._190_ VGND VGND VPWR VPWR scaleAdd._191_
+ sky130_fd_sc_hd__nand2_1
XTAP_TAPCELL_ROW_12_235 VGND VPWR sky130_fd_sc_hd__tapvpwrvgnd_1
XFILLER_0_21_49 VGND VGND VPWR VPWR sky130_fd_sc_hd__decap_6
XFILLER_0_32_181 VGND VGND VPWR VPWR sky130_fd_sc_hd__decap_6
XscaleAdd._383_ scaleAdd._043_ scaleAdd._050_ VGND VGND VPWR VPWR scaleAdd._063_ sky130_fd_sc_hd__and2_1
XscaleAdd._452_ scaleAdd._120_ scaleAdd._107_ VGND VGND VPWR VPWR scaleAdd._129_ sky130_fd_sc_hd__and2b_1
XTAP_TAPCELL_ROW_20_290 VGND VPWR sky130_fd_sc_hd__tapvpwrvgnd_1
XFILLER_0_20_365 VPWR VGND VPWR VGND sky130_ef_sc_hd__decap_12
XFILLER_0_46_57 VGND VGND VPWR VPWR sky130_fd_sc_hd__fill_1
X_23_ accumulator.io_accOut\[23\] VGND VGND VPWR VPWR net44 sky130_fd_sc_hd__clkbuf_1
XFILLER_0_1_15 VPWR VGND VPWR VGND sky130_ef_sc_hd__decap_12
Xaccumulator._1180_ accumulator._0279_ VGND VGND VPWR VPWR accumulator._0280_ sky130_fd_sc_hd__inv_2
XFILLER_0_7_337 VPWR VGND VPWR VGND sky130_ef_sc_hd__decap_12
XFILLER_0_46_3 VPWR VGND VPWR VGND sky130_ef_sc_hd__decap_12
Xaccumulator._1516_ accumulator._0470_ net70 accumulator._0571_ VGND VGND VPWR VPWR
+ accumulator._0614_ sky130_fd_sc_hd__and3_1
Xaccumulator._1447_ accumulator._0434_ accumulator._0450_ accumulator._0440_ VGND
+ VGND VPWR VPWR accumulator._0545_ sky130_fd_sc_hd__or3_1
XTAP_TAPCELL_ROW_26_327 VGND VPWR sky130_fd_sc_hd__tapvpwrvgnd_1
Xaccumulator._1378_ accumulator._0418_ accumulator._0420_ accumulator._0427_ VGND
+ VGND VPWR VPWR accumulator._0476_ sky130_fd_sc_hd__mux2_1
XFILLER_0_14_192 VGND VGND VPWR VPWR sky130_fd_sc_hd__decap_4
XFILLER_0_32_15 VPWR VGND VPWR VGND sky130_ef_sc_hd__decap_12
XFILLER_0_52_265 VGND VGND VPWR VPWR sky130_fd_sc_hd__decap_6
XscaleAdd._504_ scaleAdd._173_ scaleAdd._174_ VGND VGND VPWR VPWR scaleAdd._175_ sky130_fd_sc_hd__or2_1
XPHY_EDGE_ROW_27_Left_96 VGND VGND VPWR VPWR sky130_fd_sc_hd__decap_3
XscaleAdd._366_ operator.io_outMant\[3\] scaleAdd._248_ scaleAdd._046_ VGND VGND VPWR
+ VPWR scaleAdd._047_ sky130_fd_sc_hd__a21bo_1
XscaleAdd._435_ scaleAdd._262_ scaleAdd._248_ scaleAdd._111_ VGND VGND VPWR VPWR scaleAdd._113_
+ sky130_fd_sc_hd__a21o_1
XscaleAdd._297_ scaleAdd._246_ net13 scaleAdd._236_ VGND VGND VPWR VPWR scaleAdd._247_
+ sky130_fd_sc_hd__mux2_1
XTAP_TAPCELL_ROW_48_485 VGND VPWR sky130_fd_sc_hd__tapvpwrvgnd_1
X_06_ accumulator.io_accOut\[6\] VGND VGND VPWR VPWR net57 sky130_fd_sc_hd__buf_1
Xaccumulator._1301_ accumulator._0377_ accumulator._0398_ VGND VGND VPWR VPWR accumulator._0399_
+ sky130_fd_sc_hd__xnor2_2
Xaccumulator._1232_ accumulator._0330_ accumulator._0326_ accumulator._0331_ VGND
+ VGND VPWR VPWR accumulator._0332_ sky130_fd_sc_hd__a21o_4
Xaccumulator._2281_ accumulator._0261_ accumulator._0257_ VGND VGND VPWR VPWR accumulator._0263_
+ sky130_fd_sc_hd__or2_1
XTAP_TAPCELL_ROW_31_363 VGND VPWR sky130_fd_sc_hd__tapvpwrvgnd_1
Xaccumulator._1163_ accumulator._0171_ accumulator.io_inExp\[1\] VGND VGND VPWR VPWR
+ accumulator._0181_ sky130_fd_sc_hd__xor2_2
XTAP_TAPCELL_ROW_23_308 VGND VPWR sky130_fd_sc_hd__tapvpwrvgnd_1
XFILLER_0_22_70 VPWR VGND VPWR VGND sky130_ef_sc_hd__decap_12
Xoutput29 net29 VGND VGND VPWR VPWR io_accOut[0] sky130_fd_sc_hd__buf_2
Xaccumulator._1996_ accumulator._1028_ accumulator._1013_ accumulator._1093_ VGND
+ VGND VPWR VPWR accumulator._1094_ sky130_fd_sc_hd__or3_1
XFILLER_0_43_287 VGND VGND VPWR VPWR sky130_fd_sc_hd__fill_1
XFILLER_0_43_254 VGND VGND VPWR VPWR sky130_fd_sc_hd__decap_3
XFILLER_0_3_373 VPWR VGND VPWR VGND sky130_ef_sc_hd__decap_12
XFILLER_0_34_298 VGND VGND VPWR VPWR sky130_fd_sc_hd__decap_8
XFILLER_0_34_265 VPWR VGND VPWR VGND sky130_ef_sc_hd__decap_12
XFILLER_0_57_357 VGND VGND VPWR VPWR sky130_fd_sc_hd__decap_8
XTAP_TAPCELL_ROW_45_466 VGND VPWR sky130_fd_sc_hd__tapvpwrvgnd_1
XFILLER_0_43_69 VGND VGND VPWR VPWR sky130_fd_sc_hd__fill_1
Xaccumulator._1850_ accumulator._0856_ accumulator._0947_ accumulator._0365_ VGND
+ VGND VPWR VPWR accumulator._0948_ sky130_fd_sc_hd__mux2_4
Xaccumulator._1781_ accumulator._0391_ accumulator._0773_ accumulator._0775_ VGND
+ VGND VPWR VPWR accumulator._0879_ sky130_fd_sc_hd__o21a_1
XFILLER_0_25_276 VGND VGND VPWR VPWR sky130_fd_sc_hd__decap_4
XFILLER_0_4_148 VGND VGND VPWR VPWR sky130_fd_sc_hd__decap_3
XFILLER_0_0_321 VPWR VGND VPWR VGND sky130_ef_sc_hd__decap_12
XFILLER_0_7_47 VGND VGND VPWR VPWR sky130_fd_sc_hd__decap_8
XFILLER_0_13_405 VGND VGND VPWR VPWR sky130_fd_sc_hd__decap_4
XFILLER_0_30_6 VPWR VGND VPWR VGND sky130_ef_sc_hd__decap_12
XFILLER_0_0_365 VPWR VGND VPWR VGND sky130_ef_sc_hd__decap_12
XscaleAdd._418_ scaleAdd._087_ scaleAdd._088_ scaleAdd._096_ VGND VGND VPWR VPWR scaleAdd._097_
+ sky130_fd_sc_hd__a21oi_1
XscaleAdd._349_ net63 scaleAdd._014_ scaleAdd._029_ scaleAdd._030_ VGND VGND VPWR
+ VPWR scaleAdd._031_ sky130_fd_sc_hd__a22o_1
Xaccumulator._2195_ accumulator._0177_ accumulator._0164_ accumulator._0047_ VGND
+ VGND VPWR VPWR accumulator._0178_ sky130_fd_sc_hd__mux2_1
XFILLER_0_48_346 VGND VGND VPWR VPWR sky130_fd_sc_hd__fill_1
XTAP_TAPCELL_ROW_36_400 VGND VPWR sky130_fd_sc_hd__tapvpwrvgnd_1
Xaccumulator._1146_ accumulator.state\[0\] accumulator.state\[1\] VGND VGND VPWR VPWR
+ accumulator._1126_ sky130_fd_sc_hd__and2b_1
XPHY_EDGE_ROW_5_Right_5 VGND VGND VPWR VPWR sky130_fd_sc_hd__decap_3
Xaccumulator._2264_ accumulator._0244_ accumulator._0245_ VGND VGND VPWR VPWR accumulator._0246_
+ sky130_fd_sc_hd__xnor2_1
Xaccumulator._1215_ accumulator._0312_ accumulator._0313_ VGND VGND VPWR VPWR accumulator._0315_
+ sky130_fd_sc_hd__and2_1
XFILLER_0_31_235 VGND VGND VPWR VPWR sky130_fd_sc_hd__decap_3
Xoperator._097_ operator._033_ operator._031_ VGND VGND VPWR VPWR operator._034_ sky130_fd_sc_hd__xor2_1
Xaccumulator._1979_ accumulator._1074_ accumulator._1076_ VGND VGND VPWR VPWR accumulator._1077_
+ sky130_fd_sc_hd__nand2_1
XFILLER_0_3_192 VGND VGND VPWR VPWR sky130_fd_sc_hd__decap_3
XTAP_TAPCELL_ROW_59_558 VGND VPWR sky130_fd_sc_hd__tapvpwrvgnd_1
XFILLER_0_66_154 VGND VGND VPWR VPWR sky130_fd_sc_hd__fill_1
XFILLER_0_54_327 VPWR VGND VPWR VGND sky130_ef_sc_hd__decap_12
XFILLER_0_39_335 VGND VGND VPWR VPWR sky130_fd_sc_hd__fill_1
XFILLER_0_22_224 VGND VGND VPWR VPWR sky130_fd_sc_hd__decap_6
XFILLER_0_22_213 VGND VGND VPWR VPWR sky130_fd_sc_hd__decap_6
XFILLER_0_38_47 VGND VGND VPWR VPWR sky130_fd_sc_hd__decap_3
XFILLER_0_53_393 VPWR VGND VPWR VGND sky130_ef_sc_hd__decap_12
Xaccumulator._1902_ accumulator._0367_ accumulator._0998_ accumulator._0999_ VGND
+ VGND VPWR VPWR accumulator._1000_ sky130_fd_sc_hd__o21a_1
Xaccumulator._1833_ accumulator._0365_ accumulator._0864_ VGND VGND VPWR VPWR accumulator._0931_
+ sky130_fd_sc_hd__nor2_1
Xaccumulator._1764_ accumulator.io_accOut\[5\] accumulator._0349_ accumulator._0606_
+ VGND VGND VPWR VPWR accumulator._0862_ sky130_fd_sc_hd__nand3_1
Xaccumulator._1695_ accumulator._0787_ accumulator._0792_ VGND VGND VPWR VPWR accumulator._0793_
+ sky130_fd_sc_hd__and2_1
XFILLER_0_13_279 VGND VGND VPWR VPWR sky130_fd_sc_hd__fill_1
XTAP_TAPCELL_ROW_56_539 VGND VPWR sky130_fd_sc_hd__tapvpwrvgnd_1
Xaccumulator._2316_ clknet_2_3__leaf_clock accumulator._0023_ VGND VGND VPWR VPWR
+ accumulator.io_accOut\[21\] sky130_fd_sc_hd__dfxtp_1
XFILLER_0_28_91 VGND VGND VPWR VPWR sky130_fd_sc_hd__fill_1
XTAP_TAPCELL_ROW_64_594 VGND VPWR sky130_fd_sc_hd__tapvpwrvgnd_1
XFILLER_0_63_113 VGND VGND VPWR VPWR sky130_fd_sc_hd__fill_2
XFILLER_0_48_165 VGND VGND VPWR VPWR sky130_fd_sc_hd__decap_6
Xaccumulator._2178_ accumulator._0089_ accumulator._0102_ accumulator._0154_ accumulator._0036_
+ VGND VGND VPWR VPWR accumulator._0162_ sky130_fd_sc_hd__o22a_1
Xaccumulator._2247_ accumulator._0060_ accumulator._0227_ VGND VGND VPWR VPWR accumulator._0228_
+ sky130_fd_sc_hd__xnor2_2
XPHY_EDGE_ROW_14_Left_83 VGND VGND VPWR VPWR sky130_fd_sc_hd__decap_3
XFILLER_0_44_360 VGND VGND VPWR VPWR sky130_fd_sc_hd__decap_4
XFILLER_0_24_27 VGND VGND VPWR VPWR sky130_fd_sc_hd__fill_1
XFILLER_0_40_15 VPWR VGND VPWR VGND sky130_ef_sc_hd__decap_12
XFILLER_0_35_382 VGND VGND VPWR VPWR sky130_fd_sc_hd__fill_2
XFILLER_0_62_190 VGND VGND VPWR VPWR sky130_fd_sc_hd__decap_3
XFILLER_0_49_57 VGND VGND VPWR VPWR sky130_fd_sc_hd__decap_4
Xaccumulator._1480_ accumulator._0439_ accumulator._0577_ VGND VGND VPWR VPWR accumulator._0578_
+ sky130_fd_sc_hd__or2_1
XTAP_TAPCELL_ROW_61_575 VGND VPWR sky130_fd_sc_hd__tapvpwrvgnd_1
Xaccumulator._2032_ accumulator._1056_ accumulator._1049_ VGND VGND VPWR VPWR accumulator._1131_
+ sky130_fd_sc_hd__nor2_1
XFILLER_0_45_124 VGND VGND VPWR VPWR sky130_fd_sc_hd__decap_3
Xaccumulator._2101_ accumulator._1032_ accumulator._0086_ VGND VGND VPWR VPWR accumulator._0087_
+ sky130_fd_sc_hd__nor2_1
XTAP_TAPCELL_ROW_18_274 VGND VPWR sky130_fd_sc_hd__tapvpwrvgnd_1
XFILLER_0_18_349 VGND VGND VPWR VPWR sky130_fd_sc_hd__decap_4
XFILLER_0_60_105 VPWR VGND VPWR VGND sky130_ef_sc_hd__decap_12
XFILLER_0_41_385 VGND VGND VPWR VPWR sky130_fd_sc_hd__decap_6
XFILLER_0_26_393 VGND VGND VPWR VPWR sky130_fd_sc_hd__fill_2
Xaccumulator._1816_ accumulator._0827_ accumulator._0867_ VGND VGND VPWR VPWR accumulator._0914_
+ sky130_fd_sc_hd__or2_1
Xaccumulator._1678_ accumulator._0774_ accumulator._0775_ VGND VGND VPWR VPWR accumulator._0776_
+ sky130_fd_sc_hd__or2_1
Xaccumulator._1747_ accumulator._0512_ accumulator._0503_ accumulator._0510_ accumulator._0579_
+ accumulator._0446_ VGND VGND VPWR VPWR accumulator._0845_ sky130_fd_sc_hd__a311o_1
XFILLER_0_39_90 VGND VGND VPWR VPWR sky130_fd_sc_hd__decap_8
XFILLER_0_68_249 VGND VGND VPWR VPWR sky130_fd_sc_hd__decap_3
XTAP_TAPCELL_ROW_1_153 VGND VPWR sky130_fd_sc_hd__tapvpwrvgnd_1
XFILLER_0_10_29 VGND VGND VPWR VPWR sky130_fd_sc_hd__decap_8
XFILLER_0_17_393 VPWR VGND VPWR VGND sky130_ef_sc_hd__decap_12
XFILLER_0_35_15 VPWR VGND VPWR VGND sky130_ef_sc_hd__decap_12
XFILLER_0_67_260 VPWR VGND VPWR VGND sky130_ef_sc_hd__decap_12
XTAP_TAPCELL_ROW_15_255 VGND VPWR sky130_fd_sc_hd__tapvpwrvgnd_1
XFILLER_0_42_149 VPWR VGND VPWR VGND sky130_ef_sc_hd__decap_12
XFILLER_0_42_105 VGND VGND VPWR VPWR sky130_fd_sc_hd__fill_1
Xaccumulator._1601_ accumulator._0695_ accumulator._0697_ accumulator._0698_ VGND
+ VGND VPWR VPWR accumulator._0699_ sky130_fd_sc_hd__a21o_1
XFILLER_0_50_171 VPWR VGND VPWR VGND sky130_ef_sc_hd__decap_12
Xaccumulator._1532_ accumulator._0628_ accumulator._0629_ accumulator._0455_ VGND
+ VGND VPWR VPWR accumulator._0630_ sky130_fd_sc_hd__mux2_1
XTAP_TAPCELL_ROW_66_612 VGND VPWR sky130_fd_sc_hd__tapvpwrvgnd_1
Xaccumulator._1463_ accumulator._0440_ accumulator._0554_ accumulator._0555_ accumulator._0560_
+ accumulator._0400_ VGND VGND VPWR VPWR accumulator._0561_ sky130_fd_sc_hd__a311o_1
Xaccumulator._1394_ accumulator._0482_ accumulator._0491_ accumulator._0439_ VGND
+ VGND VPWR VPWR accumulator._0492_ sky130_fd_sc_hd__a21o_1
XFILLER_0_25_81 VGND VGND VPWR VPWR sky130_fd_sc_hd__fill_1
XFILLER_0_65_219 VGND VGND VPWR VPWR sky130_fd_sc_hd__fill_1
Xaccumulator._2015_ accumulator._1112_ accumulator._1036_ accumulator._1038_ VGND
+ VGND VPWR VPWR accumulator._1113_ sky130_fd_sc_hd__a21bo_1
XFILLER_0_14_330 VGND VGND VPWR VPWR sky130_fd_sc_hd__fill_1
XFILLER_0_5_91 VGND VGND VPWR VPWR sky130_fd_sc_hd__decap_3
XscaleAdd._520_ scaleAdd._188_ scaleAdd._189_ VGND VGND VPWR VPWR scaleAdd._190_ sky130_fd_sc_hd__nor2_1
XTAP_TAPCELL_ROW_20_291 VGND VPWR sky130_fd_sc_hd__tapvpwrvgnd_1
XscaleAdd._451_ scaleAdd._084_ scaleAdd._101_ scaleAdd._124_ VGND VGND VPWR VPWR scaleAdd._128_
+ sky130_fd_sc_hd__or3_4
XscaleAdd._382_ operator.io_outMant\[1\] scaleAdd._014_ scaleAdd._047_ scaleAdd._045_
+ VGND VGND VPWR VPWR scaleAdd._062_ sky130_fd_sc_hd__a31oi_4
XFILLER_0_20_322 VPWR VGND VPWR VGND sky130_ef_sc_hd__decap_12
XFILLER_0_20_377 VGND VGND VPWR VPWR sky130_fd_sc_hd__decap_4
XFILLER_0_20_388 VPWR VGND VPWR VGND sky130_ef_sc_hd__decap_12
X_22_ accumulator.io_accOut\[22\] VGND VGND VPWR VPWR net43 sky130_fd_sc_hd__buf_1
XFILLER_0_1_27 VPWR VGND VPWR VGND sky130_ef_sc_hd__decap_12
XFILLER_0_47_208 VPWR VGND VPWR VGND sky130_ef_sc_hd__decap_12
XFILLER_0_7_305 VPWR VGND VPWR VGND sky130_ef_sc_hd__decap_12
XFILLER_0_7_349 VPWR VGND VPWR VGND sky130_ef_sc_hd__decap_12
XFILLER_0_30_119 VGND VGND VPWR VPWR sky130_fd_sc_hd__decap_6
XFILLER_0_39_3 VPWR VGND VPWR VGND sky130_ef_sc_hd__decap_12
Xaccumulator._1515_ accumulator.io_accOut\[8\] accumulator._0455_ accumulator._0574_
+ VGND VGND VPWR VPWR accumulator._0613_ sky130_fd_sc_hd__and3_1
Xaccumulator._1446_ accumulator._0502_ accumulator._0539_ accumulator._0540_ accumulator._0543_
+ VGND VGND VPWR VPWR accumulator._0544_ sky130_fd_sc_hd__a31oi_2
Xaccumulator._1377_ accumulator._0453_ VGND VGND VPWR VPWR accumulator._0475_ sky130_fd_sc_hd__buf_2
XTAP_TAPCELL_ROW_26_328 VGND VPWR sky130_fd_sc_hd__tapvpwrvgnd_1
XFILLER_0_46_230 VGND VGND VPWR VPWR sky130_fd_sc_hd__decap_8
XTAP_TAPCELL_ROW_34_383 VGND VPWR sky130_fd_sc_hd__tapvpwrvgnd_1
XFILLER_0_16_39 VGND VGND VPWR VPWR sky130_fd_sc_hd__fill_1
XFILLER_0_37_241 VGND VGND VPWR VPWR sky130_fd_sc_hd__fill_1
XFILLER_0_32_27 VGND VGND VPWR VPWR sky130_fd_sc_hd__fill_1
XscaleAdd._503_ scaleAdd._171_ scaleAdd._172_ scaleAdd._159_ VGND VGND VPWR VPWR scaleAdd._174_
+ sky130_fd_sc_hd__a21oi_1
XscaleAdd._434_ scaleAdd._262_ scaleAdd._248_ scaleAdd._111_ VGND VGND VPWR VPWR scaleAdd._112_
+ sky130_fd_sc_hd__and3_1
XPHY_EDGE_ROW_2_Left_71 VGND VGND VPWR VPWR sky130_fd_sc_hd__decap_3
Xaccumulator._1300_ accumulator._0397_ accumulator._0382_ VGND VGND VPWR VPWR accumulator._0398_
+ sky130_fd_sc_hd__nand2_2
XscaleAdd._365_ operator.io_outMant\[2\] scaleAdd._009_ VGND VGND VPWR VPWR scaleAdd._046_
+ sky130_fd_sc_hd__nand2_1
XscaleAdd._296_ net15 scaleAdd._234_ scaleAdd._235_ net14 VGND VGND VPWR VPWR scaleAdd._246_
+ sky130_fd_sc_hd__o31a_1
XTAP_TAPCELL_ROW_48_486 VGND VPWR sky130_fd_sc_hd__tapvpwrvgnd_1
X_05_ accumulator.io_accOut\[5\] VGND VGND VPWR VPWR net56 sky130_fd_sc_hd__buf_1
XTAP_TAPCELL_ROW_23_309 VGND VPWR sky130_fd_sc_hd__tapvpwrvgnd_1
Xaccumulator._1162_ accumulator._0161_ accumulator._0112_ accumulator._0103_ accumulator.io_inMant\[13\]
+ accumulator.io_inMant\[14\] VGND VGND VPWR VPWR accumulator._0171_ sky130_fd_sc_hd__a311o_4
Xaccumulator._2280_ accumulator._0257_ accumulator._0261_ VGND VGND VPWR VPWR accumulator._0262_
+ sky130_fd_sc_hd__nand2_1
Xaccumulator._1231_ net96 accumulator._0322_ accumulator.io_accOut\[25\] VGND VGND
+ VPWR VPWR accumulator._0331_ sky130_fd_sc_hd__o21a_1
XTAP_TAPCELL_ROW_31_364 VGND VPWR sky130_fd_sc_hd__tapvpwrvgnd_1
XFILLER_0_22_82 VGND VGND VPWR VPWR sky130_fd_sc_hd__fill_2
XFILLER_0_7_102 VGND VGND VPWR VPWR sky130_fd_sc_hd__decap_8
XFILLER_0_7_113 VGND VGND VPWR VPWR sky130_fd_sc_hd__decap_8
XFILLER_0_7_146 VGND VGND VPWR VPWR sky130_fd_sc_hd__fill_1
XFILLER_0_22_60 VGND VGND VPWR VPWR sky130_fd_sc_hd__decap_6
Xaccumulator._1995_ accumulator._1036_ accumulator._1038_ accumulator._1092_ accumulator._1020_
+ VGND VGND VPWR VPWR accumulator._1093_ sky130_fd_sc_hd__a31oi_1
XFILLER_0_3_385 VGND VGND VPWR VPWR sky130_fd_sc_hd__decap_6
XTAP_TAPCELL_ROW_39_420 VGND VPWR sky130_fd_sc_hd__tapvpwrvgnd_1
Xaccumulator._1429_ accumulator._0475_ accumulator._0526_ accumulator._0413_ VGND
+ VGND VPWR VPWR accumulator._0527_ sky130_fd_sc_hd__a21o_1
XFILLER_0_34_277 VPWR VGND VPWR VGND sky130_ef_sc_hd__decap_12
XFILLER_0_27_38 VPWR VGND VPWR VGND sky130_ef_sc_hd__decap_12
XFILLER_0_43_15 VPWR VGND VPWR VGND sky130_ef_sc_hd__decap_12
Xaccumulator._1780_ accumulator._0804_ accumulator._0877_ accumulator._0805_ VGND
+ VGND VPWR VPWR accumulator._0878_ sky130_fd_sc_hd__o21ba_1
XFILLER_0_40_236 VPWR VGND VPWR VGND sky130_ef_sc_hd__decap_12
XFILLER_0_0_377 VPWR VGND VPWR VGND sky130_ef_sc_hd__decap_12
XFILLER_0_0_333 VGND VGND VPWR VPWR sky130_fd_sc_hd__decap_3
XscaleAdd._417_ scaleAdd._066_ scaleAdd._095_ VGND VGND VPWR VPWR scaleAdd._096_ sky130_fd_sc_hd__xor2_1
XTAP_TAPCELL_ROW_36_401 VGND VPWR sky130_fd_sc_hd__tapvpwrvgnd_1
XscaleAdd._348_ scaleAdd._027_ scaleAdd._028_ scaleAdd._005_ VGND VGND VPWR VPWR scaleAdd._030_
+ sky130_fd_sc_hd__a21o_1
XscaleAdd._279_ scaleAdd._230_ VGND VGND VPWR VPWR accumulator.io_inMant\[3\] sky130_fd_sc_hd__buf_1
Xaccumulator._2263_ accumulator._0234_ accumulator._0232_ accumulator._0230_ VGND
+ VGND VPWR VPWR accumulator._0245_ sky130_fd_sc_hd__a21o_1
Xaccumulator._2194_ accumulator._0176_ VGND VGND VPWR VPWR accumulator._0177_ sky130_fd_sc_hd__inv_2
Xaccumulator._1214_ accumulator._0312_ accumulator._0313_ VGND VGND VPWR VPWR accumulator._0314_
+ sky130_fd_sc_hd__nor2_1
XFILLER_0_31_247 VPWR VGND VPWR VGND sky130_ef_sc_hd__decap_12
XFILLER_0_31_225 VGND VGND VPWR VPWR sky130_fd_sc_hd__decap_4
Xoperator._096_ operator._032_ operator._023_ VGND VGND VPWR VPWR operator._033_ sky130_fd_sc_hd__xnor2_2
XFILLER_0_16_288 VGND VGND VPWR VPWR sky130_fd_sc_hd__decap_8
XFILLER_0_16_299 VGND VGND VPWR VPWR sky130_fd_sc_hd__decap_8
Xaccumulator._1978_ accumulator._0946_ accumulator._1075_ VGND VGND VPWR VPWR accumulator._1076_
+ sky130_fd_sc_hd__xor2_2
XTAP_TAPCELL_ROW_59_559 VGND VPWR sky130_fd_sc_hd__tapvpwrvgnd_1
XFILLER_0_66_133 VGND VGND VPWR VPWR sky130_fd_sc_hd__decap_6
XFILLER_0_62_350 VPWR VGND VPWR VGND sky130_ef_sc_hd__decap_12
XFILLER_0_47_391 VGND VGND VPWR VPWR sky130_fd_sc_hd__fill_1
XPHY_EDGE_ROW_11_Right_11 VGND VGND VPWR VPWR sky130_fd_sc_hd__decap_3
XFILLER_0_38_15 VPWR VGND VPWR VGND sky130_ef_sc_hd__decap_12
XPHY_EDGE_ROW_20_Right_20 VGND VGND VPWR VPWR sky130_fd_sc_hd__decap_3
XFILLER_0_57_122 VGND VGND VPWR VPWR sky130_fd_sc_hd__decap_6
XFILLER_0_54_69 VPWR VGND VPWR VGND sky130_ef_sc_hd__decap_12
Xaccumulator._1832_ accumulator._0929_ VGND VGND VPWR VPWR accumulator._0930_ sky130_fd_sc_hd__inv_2
XFILLER_0_60_309 VGND VGND VPWR VPWR sky130_fd_sc_hd__decap_6
Xaccumulator._1901_ accumulator._0787_ accumulator._0782_ accumulator._0794_ accumulator._0816_
+ VGND VGND VPWR VPWR accumulator._0999_ sky130_fd_sc_hd__a211o_1
Xaccumulator._1763_ accumulator._0860_ accumulator._0714_ VGND VGND VPWR VPWR accumulator._0861_
+ sky130_fd_sc_hd__nand2_1
Xaccumulator._1694_ accumulator._0790_ accumulator._0791_ VGND VGND VPWR VPWR accumulator._0792_
+ sky130_fd_sc_hd__and2b_1
XFILLER_0_0_141 VGND VGND VPWR VPWR sky130_fd_sc_hd__decap_8
Xaccumulator._2315_ clknet_2_1__leaf_clock accumulator._0022_ VGND VGND VPWR VPWR
+ accumulator.io_accOut\[20\] sky130_fd_sc_hd__dfxtp_1
Xaccumulator._2246_ accumulator.io_accOut\[26\] accumulator._0226_ accumulator._0356_
+ VGND VGND VPWR VPWR accumulator._0227_ sky130_fd_sc_hd__mux2_1
XTAP_TAPCELL_ROW_64_595 VGND VPWR sky130_fd_sc_hd__tapvpwrvgnd_1
XFILLER_0_63_136 VPWR VGND VPWR VGND sky130_ef_sc_hd__decap_12
XFILLER_0_44_350 VGND VGND VPWR VPWR sky130_fd_sc_hd__fill_1
XFILLER_0_44_91 VGND VGND VPWR VPWR sky130_fd_sc_hd__decap_8
Xaccumulator._2177_ accumulator._0155_ accumulator._0159_ accumulator._0160_ accumulator._0092_
+ VGND VGND VPWR VPWR accumulator._0018_ sky130_fd_sc_hd__o31a_1
XFILLER_0_8_241 VGND VGND VPWR VPWR sky130_fd_sc_hd__decap_8
Xoperator._079_ net1 net8 VGND VGND VPWR VPWR operator._018_ sky130_fd_sc_hd__nand2_1
XFILLER_0_12_280 VGND VGND VPWR VPWR sky130_fd_sc_hd__fill_1
XTAP_TAPCELL_ROW_4_173 VGND VPWR sky130_fd_sc_hd__tapvpwrvgnd_1
XFILLER_0_39_122 VPWR VGND VPWR VGND sky130_ef_sc_hd__decap_12
XFILLER_0_54_158 VGND VGND VPWR VPWR sky130_fd_sc_hd__decap_6
XFILLER_0_42_309 VGND VGND VPWR VPWR sky130_fd_sc_hd__decap_8
XFILLER_0_39_199 VGND VGND VPWR VPWR sky130_fd_sc_hd__decap_3
XFILLER_0_40_27 VGND VGND VPWR VPWR sky130_fd_sc_hd__fill_1
XFILLER_0_4_49 VGND VGND VPWR VPWR sky130_fd_sc_hd__fill_2
XFILLER_0_65_57 VPWR VGND VPWR VGND sky130_ef_sc_hd__decap_12
Xaccumulator._2100_ accumulator._0051_ accumulator._0085_ accumulator._1138_ VGND
+ VGND VPWR VPWR accumulator._0086_ sky130_fd_sc_hd__mux2_2
XTAP_TAPCELL_ROW_61_576 VGND VPWR sky130_fd_sc_hd__tapvpwrvgnd_1
Xaccumulator._2031_ accumulator._1058_ accumulator._1071_ accumulator._1074_ accumulator._1076_
+ VGND VGND VPWR VPWR accumulator._1130_ sky130_fd_sc_hd__and4_1
XFILLER_0_5_222 VGND VGND VPWR VPWR sky130_fd_sc_hd__fill_2
XTAP_TAPCELL_ROW_18_275 VGND VPWR sky130_fd_sc_hd__tapvpwrvgnd_1
XFILLER_0_18_306 VGND VGND VPWR VPWR sky130_fd_sc_hd__fill_2
Xaccumulator._1815_ accumulator._0752_ accumulator._0912_ VGND VGND VPWR VPWR accumulator._0913_
+ sky130_fd_sc_hd__nand2_1
XFILLER_0_60_117 VPWR VGND VPWR VGND sky130_ef_sc_hd__decap_12
Xaccumulator._1746_ accumulator._0840_ accumulator._0533_ accumulator._0843_ accumulator._0669_
+ accumulator._0740_ VGND VGND VPWR VPWR accumulator._0844_ sky130_fd_sc_hd__a32o_2
Xaccumulator._1677_ accumulator.io_accOut\[17\] accumulator._0521_ accumulator._0355_
+ VGND VGND VPWR VPWR accumulator._0775_ sky130_fd_sc_hd__mux2_1
XFILLER_0_64_401 VGND VGND VPWR VPWR sky130_fd_sc_hd__decap_8
XTAP_TAPCELL_ROW_52_510 VGND VPWR sky130_fd_sc_hd__tapvpwrvgnd_1
Xaccumulator._2229_ accumulator.io_accOut\[24\] accumulator._0210_ accumulator._0356_
+ VGND VGND VPWR VPWR accumulator._0211_ sky130_fd_sc_hd__mux2_1
XTAP_TAPCELL_ROW_1_154 VGND VPWR sky130_fd_sc_hd__tapvpwrvgnd_1
XFILLER_0_51_128 VGND VGND VPWR VPWR sky130_fd_sc_hd__fill_2
XFILLER_0_36_136 VGND VGND VPWR VPWR sky130_fd_sc_hd__decap_4
XTAP_TAPCELL_ROW_9_210 VGND VPWR sky130_fd_sc_hd__tapvpwrvgnd_1
XFILLER_0_19_39 VPWR VGND VPWR VGND sky130_ef_sc_hd__decap_12
XFILLER_0_35_27 VPWR VGND VPWR VGND sky130_ef_sc_hd__decap_12
XFILLER_0_67_272 VGND VGND VPWR VPWR sky130_fd_sc_hd__decap_8
XFILLER_0_51_15 VPWR VGND VPWR VGND sky130_ef_sc_hd__decap_12
XTAP_TAPCELL_ROW_15_256 VGND VPWR sky130_fd_sc_hd__tapvpwrvgnd_1
XFILLER_0_50_183 VPWR VGND VPWR VGND sky130_ef_sc_hd__decap_12
XFILLER_0_2_214 VPWR VGND VPWR VGND sky130_ef_sc_hd__decap_12
Xaccumulator._1600_ accumulator.io_accOut\[0\] accumulator._0348_ VGND VGND VPWR VPWR
+ accumulator._0698_ sky130_fd_sc_hd__nand2_1
Xaccumulator._1531_ accumulator.io_accOut\[3\] net65 accumulator._0575_ VGND VGND
+ VPWR VPWR accumulator._0629_ sky130_fd_sc_hd__and3_1
Xaccumulator._1462_ accumulator._0472_ accumulator._0556_ accumulator._0559_ VGND
+ VGND VPWR VPWR accumulator._0560_ sky130_fd_sc_hd__and3_1
XTAP_TAPCELL_ROW_66_613 VGND VPWR sky130_fd_sc_hd__tapvpwrvgnd_1
Xaccumulator._1393_ accumulator._0475_ accumulator._0489_ accumulator._0490_ VGND
+ VGND VPWR VPWR accumulator._0491_ sky130_fd_sc_hd__a21o_1
Xaccumulator._2014_ accumulator._1088_ accumulator._1110_ accumulator._1111_ VGND
+ VGND VPWR VPWR accumulator._1112_ sky130_fd_sc_hd__o21ai_1
XFILLER_0_18_169 VGND VGND VPWR VPWR sky130_fd_sc_hd__fill_1
XFILLER_0_41_161 VGND VGND VPWR VPWR sky130_fd_sc_hd__fill_1
Xaccumulator._1729_ accumulator._0819_ accumulator._0738_ accumulator._0820_ accumulator._0826_
+ VGND VGND VPWR VPWR accumulator._0827_ sky130_fd_sc_hd__o31a_1
XTAP_TAPCELL_ROW_29_348 VGND VPWR sky130_fd_sc_hd__tapvpwrvgnd_1
XFILLER_0_64_253 VPWR VGND VPWR VGND sky130_ef_sc_hd__decap_12
XFILLER_0_64_220 VGND VGND VPWR VPWR sky130_fd_sc_hd__decap_8
XFILLER_0_49_294 VGND VGND VPWR VPWR sky130_fd_sc_hd__decap_8
XFILLER_0_21_18 VPWR VGND VPWR VGND sky130_ef_sc_hd__decap_12
XFILLER_0_64_297 VGND VGND VPWR VPWR sky130_fd_sc_hd__decap_8
XFILLER_0_32_150 VGND VGND VPWR VPWR sky130_fd_sc_hd__decap_4
XscaleAdd._450_ scaleAdd._122_ scaleAdd._101_ scaleAdd._084_ scaleAdd._124_ VGND VGND
+ VPWR VPWR scaleAdd._127_ sky130_fd_sc_hd__a31o_1
XFILLER_0_9_391 VGND VGND VPWR VPWR sky130_fd_sc_hd__fill_1
XFILLER_0_20_301 VGND VGND VPWR VPWR sky130_fd_sc_hd__decap_6
XFILLER_0_20_334 VGND VGND VPWR VPWR sky130_fd_sc_hd__decap_8
XFILLER_0_46_15 VPWR VGND VPWR VGND sky130_ef_sc_hd__decap_12
X_21_ accumulator.io_accOut\[21\] VGND VGND VPWR VPWR net42 sky130_fd_sc_hd__buf_1
XscaleAdd._381_ scaleAdd._039_ scaleAdd._053_ VGND VGND VPWR VPWR scaleAdd._061_ sky130_fd_sc_hd__nand2_1
XFILLER_0_20_356 VGND VGND VPWR VPWR sky130_fd_sc_hd__decap_8
XFILLER_0_1_39 VPWR VGND VPWR VGND sky130_ef_sc_hd__decap_12
XFILLER_0_7_317 VPWR VGND VPWR VGND sky130_ef_sc_hd__decap_12
XFILLER_0_15_106 VGND VGND VPWR VPWR sky130_fd_sc_hd__fill_1
XFILLER_0_15_139 VGND VGND VPWR VPWR sky130_fd_sc_hd__decap_8
XPHY_EDGE_ROW_49_Right_49 VGND VGND VPWR VPWR sky130_fd_sc_hd__decap_3
XFILLER_0_30_109 VGND VGND VPWR VPWR sky130_fd_sc_hd__decap_4
XPHY_EDGE_ROW_58_Right_58 VGND VGND VPWR VPWR sky130_fd_sc_hd__decap_3
Xaccumulator._1514_ accumulator._0440_ accumulator._0554_ accumulator._0555_ accumulator._0560_
+ VGND VGND VPWR VPWR accumulator._0612_ sky130_fd_sc_hd__a31o_1
XFILLER_0_36_81 VGND VGND VPWR VPWR sky130_fd_sc_hd__decap_3
Xaccumulator._1445_ accumulator._0438_ accumulator._0541_ accumulator._0542_ VGND
+ VGND VPWR VPWR accumulator._0543_ sky130_fd_sc_hd__and3_1
Xaccumulator._1376_ accumulator._0456_ accumulator._0471_ accumulator._0473_ VGND
+ VGND VPWR VPWR accumulator._0474_ sky130_fd_sc_hd__a21o_1
XTAP_TAPCELL_ROW_34_384 VGND VPWR sky130_fd_sc_hd__tapvpwrvgnd_1
XTAP_TAPCELL_ROW_26_329 VGND VPWR sky130_fd_sc_hd__tapvpwrvgnd_1
XPHY_EDGE_ROW_67_Right_67 VGND VGND VPWR VPWR sky130_fd_sc_hd__decap_3
XFILLER_0_61_234 VGND VGND VPWR VPWR sky130_fd_sc_hd__decap_3
XFILLER_0_46_275 VGND VGND VPWR VPWR sky130_fd_sc_hd__decap_4
XFILLER_0_46_253 VGND VGND VPWR VPWR sky130_fd_sc_hd__fill_2
XFILLER_0_16_29 VGND VGND VPWR VPWR sky130_fd_sc_hd__decap_3
XFILLER_0_52_223 VGND VGND VPWR VPWR sky130_fd_sc_hd__fill_1
XFILLER_0_37_275 VGND VGND VPWR VPWR sky130_fd_sc_hd__decap_4
XFILLER_0_4_309 VPWR VGND VPWR VGND sky130_ef_sc_hd__decap_12
XscaleAdd._502_ scaleAdd._159_ scaleAdd._171_ scaleAdd._172_ VGND VGND VPWR VPWR scaleAdd._173_
+ sky130_fd_sc_hd__and3_1
XscaleAdd._433_ operator.io_outMant\[5\] scaleAdd._009_ VGND VGND VPWR VPWR scaleAdd._111_
+ sky130_fd_sc_hd__and2_1
X_04_ accumulator.io_accOut\[4\] VGND VGND VPWR VPWR net55 sky130_fd_sc_hd__buf_1
XscaleAdd._364_ operator.io_outMant\[2\] scaleAdd._247_ scaleAdd._044_ VGND VGND VPWR
+ VPWR scaleAdd._045_ sky130_fd_sc_hd__and3_1
XscaleAdd._295_ scaleAdd._245_ VGND VGND VPWR VPWR accumulator.io_inMant\[4\] sky130_fd_sc_hd__buf_1
XFILLER_0_20_197 VGND VGND VPWR VPWR sky130_fd_sc_hd__decap_4
XTAP_TAPCELL_ROW_48_487 VGND VPWR sky130_fd_sc_hd__tapvpwrvgnd_1
Xaccumulator._1230_ accumulator._0328_ accumulator._0327_ accumulator._0329_ VGND
+ VGND VPWR VPWR accumulator._0330_ sky130_fd_sc_hd__a21bo_4
Xaccumulator._1161_ accumulator.io_inMant\[9\] accumulator.io_inMant\[10\] accumulator._0152_
+ VGND VGND VPWR VPWR accumulator._0161_ sky130_fd_sc_hd__or3_4
Xaccumulator._1994_ accumulator._1043_ accumulator._1086_ accumulator._1091_ VGND
+ VGND VPWR VPWR accumulator._1092_ sky130_fd_sc_hd__a21bo_1
XTAP_TAPCELL_ROW_31_365 VGND VPWR sky130_fd_sc_hd__tapvpwrvgnd_1
XFILLER_0_28_253 VGND VGND VPWR VPWR sky130_fd_sc_hd__fill_2
XFILLER_0_7_169 VGND VGND VPWR VPWR sky130_fd_sc_hd__decap_8
XFILLER_0_22_50 VGND VGND VPWR VPWR sky130_fd_sc_hd__decap_6
XFILLER_0_51_3 VPWR VGND VPWR VGND sky130_ef_sc_hd__decap_12
XFILLER_0_11_131 VGND VGND VPWR VPWR sky130_fd_sc_hd__fill_1
XFILLER_0_11_142 VGND VGND VPWR VPWR sky130_fd_sc_hd__decap_3
XFILLER_0_47_91 VGND VGND VPWR VPWR sky130_fd_sc_hd__decap_4
XTAP_TAPCELL_ROW_39_421 VGND VPWR sky130_fd_sc_hd__tapvpwrvgnd_1
Xaccumulator._1428_ accumulator.io_accOut\[16\] accumulator._0525_ accumulator._0347_
+ VGND VGND VPWR VPWR accumulator._0526_ sky130_fd_sc_hd__mux2_1
XFILLER_0_19_253 VGND VGND VPWR VPWR sky130_fd_sc_hd__decap_4
Xaccumulator._1359_ accumulator.io_inMant\[0\] accumulator._0427_ accumulator._0239_
+ accumulator._0249_ VGND VGND VPWR VPWR accumulator._0457_ sky130_fd_sc_hd__and4_1
XFILLER_0_34_289 VGND VGND VPWR VPWR sky130_fd_sc_hd__decap_3
XFILLER_0_57_337 VGND VGND VPWR VPWR sky130_fd_sc_hd__fill_1
XFILLER_0_57_315 VGND VGND VPWR VPWR sky130_fd_sc_hd__fill_1
XFILLER_0_43_27 VPWR VGND VPWR VGND sky130_ef_sc_hd__decap_12
Xmax_cap62 scaleAdd._000_ VGND VGND VPWR VPWR net62 sky130_fd_sc_hd__clkbuf_1
XFILLER_0_25_289 VGND VGND VPWR VPWR sky130_fd_sc_hd__fill_2
XFILLER_0_4_117 VGND VGND VPWR VPWR sky130_fd_sc_hd__fill_1
XFILLER_0_68_57 VPWR VGND VPWR VGND sky130_ef_sc_hd__decap_12
XFILLER_0_40_248 VGND VGND VPWR VPWR sky130_fd_sc_hd__decap_4
XFILLER_0_0_389 VGND VGND VPWR VPWR sky130_fd_sc_hd__decap_3
XFILLER_0_0_301 VGND VGND VPWR VPWR sky130_fd_sc_hd__decap_3
XscaleAdd._416_ scaleAdd._094_ scaleAdd._093_ VGND VGND VPWR VPWR scaleAdd._095_ sky130_fd_sc_hd__xnor2_2
XFILLER_0_7_38 VGND VGND VPWR VPWR sky130_fd_sc_hd__fill_2
XscaleAdd._347_ scaleAdd._005_ scaleAdd._027_ scaleAdd._028_ VGND VGND VPWR VPWR scaleAdd._029_
+ sky130_fd_sc_hd__nand3_2
XTAP_TAPCELL_ROW_36_402 VGND VPWR sky130_fd_sc_hd__tapvpwrvgnd_1
XscaleAdd._278_ scaleAdd._225_ scaleAdd._229_ VGND VGND VPWR VPWR scaleAdd._230_ sky130_fd_sc_hd__and2b_1
Xaccumulator._1213_ accumulator._0239_ accumulator._0249_ VGND VGND VPWR VPWR accumulator._0313_
+ sky130_fd_sc_hd__nand2_2
Xaccumulator._2262_ accumulator._0242_ accumulator._0243_ VGND VGND VPWR VPWR accumulator._0244_
+ sky130_fd_sc_hd__and2b_1
XFILLER_0_63_307 VPWR VGND VPWR VGND sky130_ef_sc_hd__decap_12
Xaccumulator._2193_ accumulator._1013_ accumulator._1028_ net94 VGND VGND VPWR VPWR
+ accumulator._0176_ sky130_fd_sc_hd__mux2_1
XFILLER_0_48_326 VPWR VGND VPWR VGND sky130_ef_sc_hd__decap_12
XFILLER_0_48_315 VGND VGND VPWR VPWR sky130_fd_sc_hd__fill_1
XFILLER_0_8_401 VGND VGND VPWR VPWR sky130_fd_sc_hd__decap_8
Xaccumulator._1977_ accumulator._0902_ accumulator._1053_ VGND VGND VPWR VPWR accumulator._1075_
+ sky130_fd_sc_hd__nand2_1
XFILLER_0_31_259 VGND VGND VPWR VPWR sky130_fd_sc_hd__decap_6
Xoperator._095_ net8 net3 VGND VGND VPWR VPWR operator._032_ sky130_fd_sc_hd__nand2_1
XFILLER_0_16_245 VGND VGND VPWR VPWR sky130_fd_sc_hd__decap_6
XFILLER_0_62_362 VGND VGND VPWR VPWR sky130_fd_sc_hd__fill_2
XFILLER_0_38_27 VGND VGND VPWR VPWR sky130_fd_sc_hd__fill_1
XFILLER_0_54_59 VGND VGND VPWR VPWR sky130_fd_sc_hd__fill_1
XFILLER_0_54_15 VPWR VGND VPWR VGND sky130_ef_sc_hd__decap_12
XPHY_EDGE_ROW_35_Left_104 VGND VGND VPWR VPWR sky130_fd_sc_hd__decap_3
XFILLER_0_57_101 VGND VGND VPWR VPWR sky130_fd_sc_hd__decap_4
Xaccumulator._1831_ accumulator._0365_ accumulator._0856_ accumulator._0859_ accumulator._0928_
+ VGND VGND VPWR VPWR accumulator._0929_ sky130_fd_sc_hd__o31a_1
Xaccumulator._1900_ accumulator._0876_ accumulator._0880_ VGND VGND VPWR VPWR accumulator._0998_
+ sky130_fd_sc_hd__and2_1
XPHY_EDGE_ROW_44_Left_113 VGND VGND VPWR VPWR sky130_fd_sc_hd__decap_3
Xaccumulator._1762_ accumulator._0583_ accumulator._0584_ VGND VGND VPWR VPWR accumulator._0860_
+ sky130_fd_sc_hd__xnor2_2
Xaccumulator._1693_ accumulator._0534_ accumulator._0447_ accumulator._0495_ accumulator._0789_
+ VGND VGND VPWR VPWR accumulator._0791_ sky130_fd_sc_hd__a31o_1
XFILLER_0_0_197 VPWR VGND VPWR VGND sky130_ef_sc_hd__decap_12
XPHY_EDGE_ROW_53_Left_122 VGND VGND VPWR VPWR sky130_fd_sc_hd__decap_3
XFILLER_0_44_70 VGND VGND VPWR VPWR sky130_fd_sc_hd__fill_1
Xaccumulator._2176_ accumulator._0089_ accumulator._0097_ VGND VGND VPWR VPWR accumulator._0160_
+ sky130_fd_sc_hd__nor2_1
Xaccumulator._2314_ clknet_2_1__leaf_clock accumulator._0021_ VGND VGND VPWR VPWR
+ accumulator.io_accOut\[19\] sky130_fd_sc_hd__dfxtp_1
Xaccumulator._2245_ accumulator._0319_ accumulator._0322_ VGND VGND VPWR VPWR accumulator._0226_
+ sky130_fd_sc_hd__nor2_1
XTAP_TAPCELL_ROW_64_596 VGND VPWR sky130_fd_sc_hd__tapvpwrvgnd_1
XFILLER_0_63_148 VGND VGND VPWR VPWR sky130_fd_sc_hd__fill_1
XFILLER_0_63_126 VGND VGND VPWR VPWR sky130_fd_sc_hd__decap_3
XPHY_EDGE_ROW_62_Left_131 VGND VGND VPWR VPWR sky130_fd_sc_hd__decap_3
XFILLER_0_36_329 VGND VGND VPWR VPWR sky130_fd_sc_hd__decap_3
XFILLER_0_8_253 VPWR VGND VPWR VGND sky130_ef_sc_hd__decap_12
Xoperator._078_ operator._017_ VGND VGND VPWR VPWR operator.io_outExp\[0\] sky130_fd_sc_hd__clkbuf_1
XTAP_TAPCELL_ROW_4_174 VGND VPWR sky130_fd_sc_hd__tapvpwrvgnd_1
XTAP_TAPCELL_ROW_55_530 VGND VPWR sky130_fd_sc_hd__tapvpwrvgnd_1
XFILLER_0_39_134 VGND VGND VPWR VPWR sky130_fd_sc_hd__fill_1
XFILLER_0_24_29 VPWR VGND VPWR VGND sky130_ef_sc_hd__decap_12
XFILLER_0_50_365 VPWR VGND VPWR VGND sky130_ef_sc_hd__decap_12
XFILLER_0_50_332 VGND VGND VPWR VPWR sky130_fd_sc_hd__decap_4
XFILLER_0_49_15 VPWR VGND VPWR VGND sky130_ef_sc_hd__decap_12
XFILLER_0_65_69 VPWR VGND VPWR VGND sky130_ef_sc_hd__decap_12
Xaccumulator._2030_ accumulator._1085_ accumulator._1043_ VGND VGND VPWR VPWR accumulator._1129_
+ sky130_fd_sc_hd__nand2_1
XTAP_TAPCELL_ROW_18_276 VGND VPWR sky130_fd_sc_hd__tapvpwrvgnd_1
XTAP_TAPCELL_ROW_61_577 VGND VPWR sky130_fd_sc_hd__tapvpwrvgnd_1
XFILLER_0_60_129 VGND VGND VPWR VPWR sky130_fd_sc_hd__decap_8
XFILLER_0_45_104 VGND VGND VPWR VPWR sky130_fd_sc_hd__decap_8
XFILLER_0_18_329 VGND VGND VPWR VPWR sky130_fd_sc_hd__fill_1
Xaccumulator._1814_ accumulator._0730_ accumulator._0746_ accumulator._0765_ VGND
+ VGND VPWR VPWR accumulator._0912_ sky130_fd_sc_hd__o21ai_1
Xaccumulator._1745_ accumulator._0512_ accumulator._0680_ accumulator._0842_ VGND
+ VGND VPWR VPWR accumulator._0843_ sky130_fd_sc_hd__a21o_1
XFILLER_0_5_278 VGND VGND VPWR VPWR sky130_fd_sc_hd__fill_2
Xaccumulator._1676_ accumulator._0391_ accumulator._0773_ VGND VGND VPWR VPWR accumulator._0774_
+ sky130_fd_sc_hd__nor2_1
XTAP_TAPCELL_ROW_52_511 VGND VPWR sky130_fd_sc_hd__tapvpwrvgnd_1
Xaccumulator._2159_ accumulator._0080_ accumulator._0143_ accumulator._0061_ VGND
+ VGND VPWR VPWR accumulator._0144_ sky130_fd_sc_hd__mux2_2
Xaccumulator._2228_ accumulator._0317_ accumulator._0322_ VGND VGND VPWR VPWR accumulator._0210_
+ sky130_fd_sc_hd__nor2_1
XTAP_TAPCELL_ROW_1_155 VGND VPWR sky130_fd_sc_hd__tapvpwrvgnd_1
XFILLER_0_44_192 VGND VGND VPWR VPWR sky130_fd_sc_hd__decap_4
XFILLER_0_32_365 VPWR VGND VPWR VGND sky130_ef_sc_hd__decap_12
XFILLER_0_17_340 VPWR VGND VPWR VGND sky130_ef_sc_hd__decap_12
XFILLER_0_3_3 VPWR VGND VPWR VGND sky130_ef_sc_hd__decap_12
XTAP_TAPCELL_ROW_9_211 VGND VPWR sky130_fd_sc_hd__tapvpwrvgnd_1
XFILLER_0_19_18 VGND VGND VPWR VPWR sky130_fd_sc_hd__decap_8
XFILLER_0_35_39 VGND VGND VPWR VPWR sky130_fd_sc_hd__decap_4
XFILLER_0_55_402 VGND VGND VPWR VPWR sky130_fd_sc_hd__decap_3
XFILLER_0_51_27 VPWR VGND VPWR VGND sky130_ef_sc_hd__decap_12
XFILLER_0_27_137 VGND VGND VPWR VPWR sky130_fd_sc_hd__fill_1
XFILLER_0_27_126 VGND VGND VPWR VPWR sky130_fd_sc_hd__fill_2
XFILLER_0_27_104 VGND VGND VPWR VPWR sky130_fd_sc_hd__decap_8
XFILLER_0_50_195 VGND VGND VPWR VPWR sky130_fd_sc_hd__fill_1
XFILLER_0_35_192 VGND VGND VPWR VPWR sky130_fd_sc_hd__decap_8
XFILLER_0_35_181 VGND VGND VPWR VPWR sky130_fd_sc_hd__fill_2
XFILLER_0_23_343 VPWR VGND VPWR VGND sky130_ef_sc_hd__decap_12
XFILLER_0_23_321 VGND VGND VPWR VPWR sky130_fd_sc_hd__fill_1
XFILLER_0_2_226 VGND VGND VPWR VPWR sky130_fd_sc_hd__fill_2
Xaccumulator._1530_ accumulator.io_accOut\[4\] net65 accumulator._0575_ VGND VGND
+ VPWR VPWR accumulator._0628_ sky130_fd_sc_hd__and3_1
Xaccumulator._1461_ net70 accumulator._0558_ accumulator._0470_ VGND VGND VPWR VPWR
+ accumulator._0559_ sky130_fd_sc_hd__a21o_1
Xaccumulator._1392_ accumulator._0470_ VGND VGND VPWR VPWR accumulator._0490_ sky130_fd_sc_hd__buf_2
Xaccumulator._2013_ accumulator._1090_ VGND VGND VPWR VPWR accumulator._1111_ sky130_fd_sc_hd__inv_2
XFILLER_0_61_405 VGND VGND VPWR VPWR sky130_fd_sc_hd__decap_4
XFILLER_0_14_365 VPWR VGND VPWR VGND sky130_ef_sc_hd__decap_12
Xaccumulator._1728_ accumulator._0821_ accumulator._0825_ accumulator._0737_ VGND
+ VGND VPWR VPWR accumulator._0826_ sky130_fd_sc_hd__a21o_1
XFILLER_0_1_281 VPWR VGND VPWR VGND sky130_ef_sc_hd__decap_12
Xaccumulator._1659_ accumulator.io_accOut\[15\] accumulator._0528_ accumulator._0355_
+ VGND VGND VPWR VPWR accumulator._0757_ sky130_fd_sc_hd__mux2_4
XTAP_TAPCELL_ROW_29_349 VGND VPWR sky130_fd_sc_hd__tapvpwrvgnd_1
XFILLER_0_64_265 VPWR VGND VPWR VGND sky130_ef_sc_hd__decap_12
XFILLER_0_49_273 VGND VGND VPWR VPWR sky130_fd_sc_hd__fill_1
XscaleAdd._380_ scaleAdd._056_ scaleAdd._058_ scaleAdd._059_ VGND VGND VPWR VPWR scaleAdd._060_
+ sky130_fd_sc_hd__a21bo_1
XFILLER_0_46_27 VGND VGND VPWR VPWR sky130_fd_sc_hd__fill_1
X_20_ accumulator.io_accOut\[20\] VGND VGND VPWR VPWR net41 sky130_fd_sc_hd__buf_1
XFILLER_0_62_15 VPWR VGND VPWR VGND sky130_ef_sc_hd__decap_12
XFILLER_0_28_402 VGND VGND VPWR VPWR sky130_fd_sc_hd__decap_3
XFILLER_0_55_287 VGND VGND VPWR VPWR sky130_fd_sc_hd__fill_1
XFILLER_0_7_329 VGND VGND VPWR VPWR sky130_fd_sc_hd__decap_6
XFILLER_0_11_335 VGND VGND VPWR VPWR sky130_fd_sc_hd__fill_1
Xaccumulator._1513_ accumulator._0609_ accumulator._0610_ accumulator._0446_ VGND
+ VGND VPWR VPWR accumulator._0611_ sky130_fd_sc_hd__a21oi_1
Xaccumulator._1375_ accumulator._0472_ VGND VGND VPWR VPWR accumulator._0473_ sky130_fd_sc_hd__clkbuf_4
Xaccumulator._1444_ accumulator._0453_ accumulator._0481_ accumulator._0470_ VGND
+ VGND VPWR VPWR accumulator._0542_ sky130_fd_sc_hd__a21o_1
Xinput1 io_inA[0] VGND VGND VPWR VPWR net1 sky130_fd_sc_hd__buf_1
XTAP_TAPCELL_ROW_34_385 VGND VPWR sky130_fd_sc_hd__tapvpwrvgnd_1
XFILLER_0_61_279 VGND VGND VPWR VPWR sky130_fd_sc_hd__fill_1
XFILLER_0_61_213 VGND VGND VPWR VPWR sky130_fd_sc_hd__decap_4
XFILLER_0_14_173 VGND VGND VPWR VPWR sky130_fd_sc_hd__decap_3
XFILLER_0_32_29 VPWR VGND VPWR VGND sky130_ef_sc_hd__decap_12
XFILLER_0_57_15 VPWR VGND VPWR VGND sky130_ef_sc_hd__decap_12
XscaleAdd._501_ net18 net23 VGND VGND VPWR VPWR scaleAdd._172_ sky130_fd_sc_hd__or2_1
XscaleAdd._363_ operator.io_outMant\[3\] scaleAdd._009_ VGND VGND VPWR VPWR scaleAdd._044_
+ sky130_fd_sc_hd__and2_1
XscaleAdd._432_ operator.io_outMant\[4\] scaleAdd._014_ VGND VGND VPWR VPWR scaleAdd._110_
+ sky130_fd_sc_hd__nand2_1
XFILLER_0_20_165 VPWR VGND VPWR VGND sky130_ef_sc_hd__decap_12
X_03_ accumulator.io_accOut\[3\] VGND VGND VPWR VPWR net54 sky130_fd_sc_hd__buf_1
XscaleAdd._294_ scaleAdd._243_ scaleAdd._244_ VGND VGND VPWR VPWR scaleAdd._245_ sky130_fd_sc_hd__and2_1
Xaccumulator._1160_ accumulator.io_inMant\[6\] accumulator.io_inMant\[5\] accumulator._0132_
+ accumulator._0142_ VGND VGND VPWR VPWR accumulator._0152_ sky130_fd_sc_hd__o31a_1
Xaccumulator._1993_ accumulator._1088_ accumulator._1090_ VGND VGND VPWR VPWR accumulator._1091_
+ sky130_fd_sc_hd__nor2_1
XFILLER_0_43_268 VPWR VGND VPWR VGND sky130_ef_sc_hd__decap_12
XFILLER_0_43_246 VGND VGND VPWR VPWR sky130_fd_sc_hd__decap_8
XTAP_TAPCELL_ROW_31_366 VGND VPWR sky130_fd_sc_hd__tapvpwrvgnd_1
XFILLER_0_44_3 VPWR VGND VPWR VGND sky130_ef_sc_hd__decap_12
XFILLER_0_11_176 VPWR VGND VPWR VGND sky130_ef_sc_hd__decap_12
XFILLER_0_66_316 VGND VGND VPWR VPWR sky130_fd_sc_hd__fill_2
XFILLER_0_66_305 VGND VGND VPWR VPWR sky130_fd_sc_hd__decap_3
XTAP_TAPCELL_ROW_39_422 VGND VPWR sky130_fd_sc_hd__tapvpwrvgnd_1
Xaccumulator._1358_ accumulator._0454_ accumulator._0432_ accumulator._0455_ VGND
+ VGND VPWR VPWR accumulator._0456_ sky130_fd_sc_hd__a21o_1
Xaccumulator._1427_ accumulator._0476_ accumulator._0478_ accumulator._0273_ VGND
+ VGND VPWR VPWR accumulator._0525_ sky130_fd_sc_hd__mux2_1
XFILLER_0_2_83 VGND VGND VPWR VPWR sky130_fd_sc_hd__fill_1
Xaccumulator._1289_ accumulator._0354_ accumulator._0383_ VGND VGND VPWR VPWR accumulator._0387_
+ sky130_fd_sc_hd__nand2_1
XTAP_TAPCELL_ROW_22_300 VGND VPWR sky130_fd_sc_hd__tapvpwrvgnd_1
XFILLER_0_19_210 VPWR VGND VPWR VGND sky130_ef_sc_hd__decap_12
XFILLER_0_27_18 VPWR VGND VPWR VGND sky130_ef_sc_hd__decap_12
XFILLER_0_65_360 VPWR VGND VPWR VGND sky130_ef_sc_hd__decap_12
XFILLER_0_43_39 VGND VGND VPWR VPWR sky130_fd_sc_hd__fill_2
XFILLER_0_65_393 VPWR VGND VPWR VGND sky130_ef_sc_hd__decap_12
XFILLER_0_68_69 VPWR VGND VPWR VGND sky130_ef_sc_hd__decap_12
XscaleAdd._415_ operator.io_outMant\[4\] scaleAdd._248_ scaleAdd._073_ scaleAdd._072_
+ VGND VGND VPWR VPWR scaleAdd._094_ sky130_fd_sc_hd__a31o_1
XscaleAdd._346_ scaleAdd._026_ scaleAdd._023_ scaleAdd._024_ VGND VGND VPWR VPWR scaleAdd._028_
+ sky130_fd_sc_hd__nand3_1
XscaleAdd._277_ operator.io_outMant\[1\] scaleAdd._226_ scaleAdd._224_ accumulator.io_inMant\[0\]
+ scaleAdd._228_ VGND VGND VPWR VPWR scaleAdd._229_ sky130_fd_sc_hd__a221o_1
XFILLER_0_48_305 VGND VGND VPWR VPWR sky130_fd_sc_hd__decap_3
Xaccumulator._2192_ accumulator._0149_ VGND VGND VPWR VPWR accumulator._0175_ sky130_fd_sc_hd__inv_2
XTAP_TAPCELL_ROW_36_403 VGND VPWR sky130_fd_sc_hd__tapvpwrvgnd_1
XFILLER_0_17_62 VPWR VGND VPWR VGND sky130_ef_sc_hd__decap_12
Xaccumulator._2261_ accumulator._0060_ accumulator._0227_ accumulator._0241_ VGND
+ VGND VPWR VPWR accumulator._0243_ sky130_fd_sc_hd__a21o_1
Xaccumulator._1212_ accumulator.io_inExp\[0\] VGND VGND VPWR VPWR accumulator._0312_
+ sky130_fd_sc_hd__inv_2
XFILLER_0_63_319 VPWR VGND VPWR VGND sky130_ef_sc_hd__decap_12
XFILLER_0_48_338 VGND VGND VPWR VPWR sky130_fd_sc_hd__decap_8
XFILLER_0_16_202 VGND VGND VPWR VPWR sky130_fd_sc_hd__decap_6
Xaccumulator._1976_ accumulator._0942_ accumulator._1073_ VGND VGND VPWR VPWR accumulator._1074_
+ sky130_fd_sc_hd__xnor2_2
Xoperator._094_ net7 operator._030_ VGND VGND VPWR VPWR operator._031_ sky130_fd_sc_hd__nand2_1
XTAP_TAPCELL_ROW_42_439 VGND VPWR sky130_fd_sc_hd__tapvpwrvgnd_1
XFILLER_0_47_393 VGND VGND VPWR VPWR sky130_fd_sc_hd__decap_8
XFILLER_0_54_27 VGND VGND VPWR VPWR sky130_fd_sc_hd__fill_1
XTAP_TAPCELL_ROW_7_194 VGND VPWR sky130_fd_sc_hd__tapvpwrvgnd_1
XFILLER_0_45_308 VPWR VGND VPWR VGND sky130_ef_sc_hd__decap_12
XFILLER_0_5_405 VGND VGND VPWR VPWR sky130_fd_sc_hd__decap_4
Xaccumulator._1761_ accumulator._0858_ accumulator._0626_ VGND VGND VPWR VPWR accumulator._0859_
+ sky130_fd_sc_hd__or2_1
Xaccumulator._1830_ accumulator._0365_ accumulator._0863_ VGND VGND VPWR VPWR accumulator._0928_
+ sky130_fd_sc_hd__or2_1
XFILLER_0_53_374 VPWR VGND VPWR VGND sky130_ef_sc_hd__decap_12
XPHY_EDGE_ROW_9_Right_9 VGND VGND VPWR VPWR sky130_fd_sc_hd__decap_3
Xaccumulator._1692_ accumulator._0788_ accumulator._0789_ VGND VGND VPWR VPWR accumulator._0790_
+ sky130_fd_sc_hd__and2b_1
Xaccumulator._2313_ clknet_2_3__leaf_clock accumulator._0020_ VGND VGND VPWR VPWR
+ accumulator.io_accOut\[18\] sky130_fd_sc_hd__dfxtp_1
XscaleAdd._329_ scaleAdd._259_ scaleAdd._011_ VGND VGND VPWR VPWR scaleAdd._012_ sky130_fd_sc_hd__xor2_1
XTAP_TAPCELL_ROW_64_597 VGND VPWR sky130_fd_sc_hd__tapvpwrvgnd_1
Xaccumulator._2175_ accumulator._0046_ accumulator._0157_ accumulator._0158_ accumulator._1032_
+ VGND VGND VPWR VPWR accumulator._0159_ sky130_fd_sc_hd__a211oi_1
Xaccumulator._2244_ accumulator._1137_ accumulator._0216_ VGND VGND VPWR VPWR accumulator._0225_
+ sky130_fd_sc_hd__nand2_1
XFILLER_0_48_179 VGND VGND VPWR VPWR sky130_fd_sc_hd__fill_1
XFILLER_0_44_330 VGND VGND VPWR VPWR sky130_fd_sc_hd__decap_8
XFILLER_0_8_265 VPWR VGND VPWR VGND sky130_ef_sc_hd__decap_12
Xoperator._077_ operator._004_ operator._016_ VGND VGND VPWR VPWR operator._017_ sky130_fd_sc_hd__and2_1
Xaccumulator._1959_ accumulator._0902_ accumulator._0953_ VGND VGND VPWR VPWR accumulator._1057_
+ sky130_fd_sc_hd__and2_1
XTAP_TAPCELL_ROW_55_531 VGND VPWR sky130_fd_sc_hd__tapvpwrvgnd_1
XTAP_TAPCELL_ROW_4_175 VGND VPWR sky130_fd_sc_hd__tapvpwrvgnd_1
XFILLER_0_54_138 VGND VGND VPWR VPWR sky130_fd_sc_hd__fill_2
XFILLER_0_39_113 VGND VGND VPWR VPWR sky130_fd_sc_hd__decap_4
XFILLER_0_40_29 VPWR VGND VPWR VGND sky130_ef_sc_hd__decap_12
XFILLER_0_50_377 VGND VGND VPWR VPWR sky130_fd_sc_hd__decap_6
XFILLER_0_49_27 VPWR VGND VPWR VGND sky130_ef_sc_hd__decap_12
XFILLER_0_35_374 VGND VGND VPWR VPWR sky130_fd_sc_hd__decap_4
XFILLER_0_35_352 VGND VGND VPWR VPWR sky130_fd_sc_hd__decap_6
XFILLER_0_65_15 VPWR VGND VPWR VGND sky130_ef_sc_hd__decap_12
XFILLER_0_4_29 VPWR VGND VPWR VGND sky130_ef_sc_hd__decap_12
XTAP_TAPCELL_ROW_18_277 VGND VPWR sky130_fd_sc_hd__tapvpwrvgnd_1
XTAP_TAPCELL_ROW_61_578 VGND VPWR sky130_fd_sc_hd__tapvpwrvgnd_1
XFILLER_0_14_85 VGND VGND VPWR VPWR sky130_fd_sc_hd__fill_1
Xaccumulator._1813_ accumulator._0882_ accumulator._0910_ VGND VGND VPWR VPWR accumulator._0911_
+ sky130_fd_sc_hd__xnor2_2
Xaccumulator._1744_ accumulator._0449_ accumulator._0440_ accumulator._0841_ accumulator._0394_
+ VGND VGND VPWR VPWR accumulator._0842_ sky130_fd_sc_hd__a31o_1
XPHY_EDGE_ROW_18_Left_87 VGND VGND VPWR VPWR sky130_fd_sc_hd__decap_3
Xaccumulator._1675_ accumulator._0447_ accumulator._0718_ VGND VGND VPWR VPWR accumulator._0773_
+ sky130_fd_sc_hd__nand2_1
XTAP_TAPCELL_ROW_1_156 VGND VPWR sky130_fd_sc_hd__tapvpwrvgnd_1
XTAP_TAPCELL_ROW_52_512 VGND VPWR sky130_fd_sc_hd__tapvpwrvgnd_1
Xaccumulator._2158_ accumulator._0108_ accumulator._0141_ accumulator._1138_ VGND
+ VGND VPWR VPWR accumulator._0143_ sky130_fd_sc_hd__mux2_4
XFILLER_0_36_149 VGND VGND VPWR VPWR sky130_fd_sc_hd__decap_3
Xaccumulator._2089_ accumulator.io_accOut\[5\] accumulator._0364_ accumulator._0058_
+ accumulator._0075_ VGND VGND VPWR VPWR accumulator._0076_ sky130_fd_sc_hd__o2bb2a_1
Xaccumulator._2227_ net113 accumulator._0120_ accumulator._0092_ accumulator._0208_
+ VGND VGND VPWR VPWR accumulator._0025_ sky130_fd_sc_hd__o211a_1
XFILLER_0_51_119 VGND VGND VPWR VPWR sky130_fd_sc_hd__fill_1
XFILLER_0_32_377 VGND VGND VPWR VPWR sky130_fd_sc_hd__fill_1
XTAP_TAPCELL_ROW_9_212 VGND VPWR sky130_fd_sc_hd__tapvpwrvgnd_1
XFILLER_0_17_352 VPWR VGND VPWR VGND sky130_ef_sc_hd__decap_12
XFILLER_0_67_296 VPWR VGND VPWR VGND sky130_ef_sc_hd__decap_12
XFILLER_0_51_39 VPWR VGND VPWR VGND sky130_ef_sc_hd__decap_12
XFILLER_0_50_141 VGND VGND VPWR VPWR sky130_fd_sc_hd__decap_8
XFILLER_0_23_366 VPWR VGND VPWR VGND sky130_ef_sc_hd__decap_12
XFILLER_0_23_355 VGND VGND VPWR VPWR sky130_fd_sc_hd__decap_3
Xaccumulator._1460_ accumulator.io_accOut\[10\] accumulator._0557_ accumulator._0346_
+ VGND VGND VPWR VPWR accumulator._0558_ sky130_fd_sc_hd__mux2_2
Xaccumulator._1391_ accumulator.io_accOut\[19\] accumulator._0488_ accumulator._0347_
+ VGND VGND VPWR VPWR accumulator._0489_ sky130_fd_sc_hd__mux2_1
Xaccumulator._2012_ accumulator._1109_ accumulator._1040_ accumulator._1042_ VGND
+ VGND VPWR VPWR accumulator._1110_ sky130_fd_sc_hd__o21ba_1
XFILLER_0_58_241 VGND VGND VPWR VPWR sky130_fd_sc_hd__fill_2
XFILLER_0_41_50 VGND VGND VPWR VPWR sky130_fd_sc_hd__decap_6
XFILLER_0_25_95 VPWR VGND VPWR VGND sky130_ef_sc_hd__decap_12
XFILLER_0_25_62 VPWR VGND VPWR VGND sky130_ef_sc_hd__decap_12
XFILLER_0_25_51 VGND VGND VPWR VPWR sky130_fd_sc_hd__decap_4
XFILLER_0_41_185 VPWR VGND VPWR VGND sky130_ef_sc_hd__decap_12
XFILLER_0_14_377 VPWR VGND VPWR VGND sky130_ef_sc_hd__decap_12
Xaccumulator._1727_ accumulator._0823_ accumulator._0727_ accumulator._0724_ accumulator._0824_
+ accumulator._0536_ VGND VGND VPWR VPWR accumulator._0825_ sky130_fd_sc_hd__a32oi_1
Xaccumulator._1658_ accumulator._0390_ accumulator._0755_ VGND VGND VPWR VPWR accumulator._0756_
+ sky130_fd_sc_hd__nor2_2
XFILLER_0_1_293 VPWR VGND VPWR VGND sky130_ef_sc_hd__decap_12
Xaccumulator._1589_ accumulator._0400_ accumulator._0639_ accumulator._0640_ VGND
+ VGND VPWR VPWR accumulator._0687_ sky130_fd_sc_hd__nand3_1
XFILLER_0_64_277 VPWR VGND VPWR VGND sky130_ef_sc_hd__decap_12
XFILLER_0_9_393 VPWR VGND VPWR VGND sky130_ef_sc_hd__decap_12
XFILLER_0_32_141 VGND VGND VPWR VPWR sky130_fd_sc_hd__fill_2
XFILLER_0_62_49 VGND VGND VPWR VPWR sky130_fd_sc_hd__decap_3
XFILLER_0_62_27 VGND VGND VPWR VPWR sky130_fd_sc_hd__fill_1
XFILLER_0_55_233 VGND VGND VPWR VPWR sky130_fd_sc_hd__decap_6
XFILLER_0_55_222 VGND VGND VPWR VPWR sky130_fd_sc_hd__fill_2
XFILLER_0_55_277 VGND VGND VPWR VPWR sky130_fd_sc_hd__decap_3
XFILLER_0_23_152 VGND VGND VPWR VPWR sky130_fd_sc_hd__fill_1
Xaccumulator._1512_ accumulator._0549_ accumulator._0552_ accumulator._0400_ VGND
+ VGND VPWR VPWR accumulator._0610_ sky130_fd_sc_hd__a21o_1
Xaccumulator._1443_ net70 accumulator._0469_ accumulator._0455_ VGND VGND VPWR VPWR
+ accumulator._0541_ sky130_fd_sc_hd__a21o_1
Xaccumulator._1374_ accumulator._0436_ accumulator._0437_ VGND VGND VPWR VPWR accumulator._0472_
+ sky130_fd_sc_hd__nor2_4
Xinput2 io_inA[1] VGND VGND VPWR VPWR net2 sky130_fd_sc_hd__dlymetal6s2s_1
XTAP_TAPCELL_ROW_34_386 VGND VPWR sky130_fd_sc_hd__tapvpwrvgnd_1
XFILLER_0_6_363 VGND VGND VPWR VPWR sky130_fd_sc_hd__fill_1
XFILLER_0_14_141 VPWR VGND VPWR VGND sky130_ef_sc_hd__decap_12
XTAP_TAPCELL_ROW_25_320 VGND VPWR sky130_fd_sc_hd__tapvpwrvgnd_1
XscaleAdd._500_ net18 net23 VGND VGND VPWR VPWR scaleAdd._171_ sky130_fd_sc_hd__nand2_1
XFILLER_0_57_27 VPWR VGND VPWR VGND sky130_ef_sc_hd__decap_12
XscaleAdd._431_ scaleAdd._095_ scaleAdd._014_ operator.io_outMant\[3\] VGND VGND VPWR
+ VPWR scaleAdd._109_ sky130_fd_sc_hd__and3_1
XscaleAdd._362_ scaleAdd._041_ scaleAdd._042_ VGND VGND VPWR VPWR scaleAdd._043_ sky130_fd_sc_hd__xnor2_2
XscaleAdd._293_ scaleAdd._225_ scaleAdd._242_ VGND VGND VPWR VPWR scaleAdd._244_ sky130_fd_sc_hd__or2_1
XFILLER_0_20_177 VGND VGND VPWR VPWR sky130_fd_sc_hd__decap_4
X_02_ accumulator.io_accOut\[2\] VGND VGND VPWR VPWR net51 sky130_fd_sc_hd__buf_1
XFILLER_0_43_203 VGND VGND VPWR VPWR sky130_fd_sc_hd__decap_4
XTAP_TAPCELL_ROW_31_367 VGND VPWR sky130_fd_sc_hd__tapvpwrvgnd_1
Xaccumulator._1992_ accumulator._0987_ accumulator._1089_ VGND VGND VPWR VPWR accumulator._1090_
+ sky130_fd_sc_hd__xnor2_2
XFILLER_0_11_111 VGND VGND VPWR VPWR sky130_fd_sc_hd__fill_1
XTAP_TAPCELL_ROW_39_423 VGND VPWR sky130_fd_sc_hd__tapvpwrvgnd_1
XFILLER_0_37_3 VPWR VGND VPWR VGND sky130_ef_sc_hd__decap_12
XFILLER_0_59_391 VGND VGND VPWR VPWR sky130_fd_sc_hd__fill_1
Xaccumulator._1426_ accumulator._0518_ accumulator._0523_ accumulator._0473_ VGND
+ VGND VPWR VPWR accumulator._0524_ sky130_fd_sc_hd__a21o_1
Xaccumulator._1357_ accumulator._0412_ VGND VGND VPWR VPWR accumulator._0455_ sky130_fd_sc_hd__clkbuf_4
Xaccumulator._1288_ accumulator._0373_ accumulator._0385_ VGND VGND VPWR VPWR accumulator._0386_
+ sky130_fd_sc_hd__xnor2_2
XFILLER_0_19_200 VGND VGND VPWR VPWR sky130_fd_sc_hd__fill_1
XFILLER_0_19_222 VGND VGND VPWR VPWR sky130_fd_sc_hd__fill_2
XFILLER_0_34_214 VGND VGND VPWR VPWR sky130_fd_sc_hd__fill_2
XTAP_TAPCELL_ROW_22_301 VGND VPWR sky130_fd_sc_hd__tapvpwrvgnd_1
XFILLER_0_19_277 VGND VGND VPWR VPWR sky130_fd_sc_hd__decap_3
XFILLER_0_19_299 VGND VGND VPWR VPWR sky130_fd_sc_hd__fill_1
XPHY_EDGE_ROW_6_Left_75 VGND VGND VPWR VPWR sky130_fd_sc_hd__decap_3
XFILLER_0_65_372 VPWR VGND VPWR VGND sky130_ef_sc_hd__decap_12
XFILLER_0_57_328 VGND VGND VPWR VPWR sky130_fd_sc_hd__decap_8
XFILLER_0_68_15 VPWR VGND VPWR VGND sky130_ef_sc_hd__decap_12
XFILLER_0_40_206 VPWR VGND VPWR VGND sky130_ef_sc_hd__decap_12
XscaleAdd._414_ scaleAdd._089_ scaleAdd._092_ VGND VGND VPWR VPWR scaleAdd._093_ sky130_fd_sc_hd__xnor2_4
XFILLER_0_7_18 VPWR VGND VPWR VGND sky130_ef_sc_hd__decap_12
XscaleAdd._345_ scaleAdd._023_ scaleAdd._024_ scaleAdd._026_ VGND VGND VPWR VPWR scaleAdd._027_
+ sky130_fd_sc_hd__a21o_1
XscaleAdd._276_ net13 operator.io_outMant\[3\] VGND VGND VPWR VPWR scaleAdd._228_
+ sky130_fd_sc_hd__and2_1
XFILLER_0_17_30 VGND VGND VPWR VPWR sky130_fd_sc_hd__fill_2
Xaccumulator._2191_ accumulator._0168_ accumulator._0174_ accumulator._0362_ VGND
+ VGND VPWR VPWR accumulator._0020_ sky130_fd_sc_hd__a21oi_1
Xaccumulator._1211_ accumulator._0269_ accumulator._0310_ VGND VGND VPWR VPWR accumulator._0311_
+ sky130_fd_sc_hd__xnor2_2
XFILLER_0_17_74 VPWR VGND VPWR VGND sky130_ef_sc_hd__decap_12
Xaccumulator._2260_ accumulator._0060_ accumulator._0227_ accumulator._0241_ VGND
+ VGND VPWR VPWR accumulator._0242_ sky130_fd_sc_hd__and3_1
XFILLER_0_56_361 VGND VGND VPWR VPWR sky130_fd_sc_hd__decap_3
XFILLER_0_33_84 VGND VGND VPWR VPWR sky130_fd_sc_hd__fill_2
Xoperator._093_ net4 net5 VGND VGND VPWR VPWR operator._030_ sky130_fd_sc_hd__or2_1
Xaccumulator._1975_ accumulator._1014_ accumulator._0958_ VGND VGND VPWR VPWR accumulator._1073_
+ sky130_fd_sc_hd__nor2_1
XFILLER_0_58_81 VGND VGND VPWR VPWR sky130_fd_sc_hd__decap_3
Xaccumulator._1409_ accumulator._0306_ accumulator._0273_ accumulator._0484_ VGND
+ VGND VPWR VPWR accumulator._0507_ sky130_fd_sc_hd__and3_1
XFILLER_0_54_309 VGND VGND VPWR VPWR sky130_fd_sc_hd__decap_6
XFILLER_0_47_361 VPWR VGND VPWR VGND sky130_ef_sc_hd__decap_12
XFILLER_0_62_386 VPWR VGND VPWR VGND sky130_ef_sc_hd__decap_12
XTAP_TAPCELL_ROW_50_495 VGND VPWR sky130_fd_sc_hd__tapvpwrvgnd_1
XFILLER_0_38_29 VPWR VGND VPWR VGND sky130_ef_sc_hd__decap_12
XFILLER_0_30_294 VPWR VGND VPWR VGND sky130_ef_sc_hd__decap_12
XTAP_TAPCELL_ROW_7_195 VGND VPWR sky130_fd_sc_hd__tapvpwrvgnd_1
XTAP_TAPCELL_ROW_58_551 VGND VPWR sky130_fd_sc_hd__tapvpwrvgnd_1
XFILLER_0_65_180 VGND VGND VPWR VPWR sky130_fd_sc_hd__fill_1
XFILLER_0_38_372 VGND VGND VPWR VPWR sky130_fd_sc_hd__decap_8
Xaccumulator._1760_ accumulator._0857_ accumulator._0706_ VGND VGND VPWR VPWR accumulator._0858_
+ sky130_fd_sc_hd__nor2_1
XFILLER_0_53_386 VGND VGND VPWR VPWR sky130_fd_sc_hd__decap_6
Xaccumulator._1691_ accumulator.io_accOut\[19\] accumulator._0488_ accumulator._0355_
+ VGND VGND VPWR VPWR accumulator._0789_ sky130_fd_sc_hd__mux2_1
XFILLER_0_0_111 VGND VGND VPWR VPWR sky130_fd_sc_hd__fill_1
XFILLER_0_0_133 VGND VGND VPWR VPWR sky130_fd_sc_hd__decap_3
XFILLER_0_13_239 VGND VGND VPWR VPWR sky130_fd_sc_hd__fill_2
XFILLER_0_21_250 VPWR VGND VPWR VGND sky130_ef_sc_hd__decap_12
XFILLER_0_21_294 VGND VGND VPWR VPWR sky130_fd_sc_hd__fill_2
Xaccumulator._2312_ clknet_2_3__leaf_clock accumulator._0019_ VGND VGND VPWR VPWR
+ accumulator.io_accOut\[17\] sky130_fd_sc_hd__dfxtp_1
XscaleAdd._328_ scaleAdd._008_ scaleAdd._010_ VGND VGND VPWR VPWR scaleAdd._011_ sky130_fd_sc_hd__xnor2_1
XFILLER_0_21_6 VPWR VGND VPWR VGND sky130_ef_sc_hd__decap_12
XTAP_TAPCELL_ROW_64_598 VGND VPWR sky130_fd_sc_hd__tapvpwrvgnd_1
Xaccumulator._2174_ accumulator._0046_ accumulator._0127_ VGND VGND VPWR VPWR accumulator._0158_
+ sky130_fd_sc_hd__nor2_1
XFILLER_0_36_309 VPWR VGND VPWR VGND sky130_ef_sc_hd__decap_12
XFILLER_0_29_372 VGND VGND VPWR VPWR sky130_fd_sc_hd__decap_8
Xaccumulator._2243_ accumulator.io_accOut\[25\] accumulator._0120_ accumulator._0352_
+ accumulator._0224_ VGND VGND VPWR VPWR accumulator._0027_ sky130_fd_sc_hd__o211a_1
XFILLER_0_60_93 VPWR VGND VPWR VGND sky130_ef_sc_hd__decap_12
XFILLER_0_56_191 VGND VGND VPWR VPWR sky130_fd_sc_hd__fill_1
XFILLER_0_8_72 VGND VGND VPWR VPWR sky130_fd_sc_hd__fill_2
XFILLER_0_8_83 VGND VGND VPWR VPWR sky130_fd_sc_hd__fill_1
XFILLER_0_8_277 VPWR VGND VPWR VGND sky130_ef_sc_hd__decap_12
Xoperator._076_ net9 operator._003_ net5 operator._012_ VGND VGND VPWR VPWR operator._016_
+ sky130_fd_sc_hd__a2bb2o_1
Xaccumulator._1889_ accumulator._0752_ accumulator._0986_ VGND VGND VPWR VPWR accumulator._0987_
+ sky130_fd_sc_hd__xor2_4
Xaccumulator._1958_ accumulator._1052_ accumulator._1055_ VGND VGND VPWR VPWR accumulator._1056_
+ sky130_fd_sc_hd__nand2_1
XTAP_TAPCELL_ROW_55_532 VGND VPWR sky130_fd_sc_hd__tapvpwrvgnd_1
XTAP_TAPCELL_ROW_4_176 VGND VPWR sky130_fd_sc_hd__tapvpwrvgnd_1
XFILLER_0_35_364 VGND VGND VPWR VPWR sky130_fd_sc_hd__fill_2
XFILLER_0_49_39 VPWR VGND VPWR VGND sky130_ef_sc_hd__decap_12
XFILLER_0_10_209 VGND VGND VPWR VPWR sky130_fd_sc_hd__fill_2
XFILLER_0_65_27 VPWR VGND VPWR VGND sky130_ef_sc_hd__decap_12
XFILLER_0_58_401 VGND VGND VPWR VPWR sky130_fd_sc_hd__decap_8
XFILLER_0_18_309 VGND VGND VPWR VPWR sky130_fd_sc_hd__decap_4
XFILLER_0_53_150 VGND VGND VPWR VPWR sky130_fd_sc_hd__decap_4
Xaccumulator._1812_ accumulator._0367_ accumulator._0907_ accumulator._0909_ VGND
+ VGND VPWR VPWR accumulator._0910_ sky130_fd_sc_hd__o21a_1
XFILLER_0_41_334 VGND VGND VPWR VPWR sky130_fd_sc_hd__fill_2
XFILLER_0_30_85 VPWR VGND VPWR VGND sky130_ef_sc_hd__decap_12
XFILLER_0_30_52 VPWR VGND VPWR VGND sky130_ef_sc_hd__decap_12
XFILLER_0_26_397 VGND VGND VPWR VPWR sky130_fd_sc_hd__fill_2
XFILLER_0_5_225 VPWR VGND VPWR VGND sky130_ef_sc_hd__decap_12
Xaccumulator._1674_ accumulator._0770_ accumulator._0771_ VGND VGND VPWR VPWR accumulator._0772_
+ sky130_fd_sc_hd__nor2b_2
Xaccumulator._1743_ accumulator.io_accOut\[0\] accumulator._0490_ accumulator._0574_
+ VGND VGND VPWR VPWR accumulator._0841_ sky130_fd_sc_hd__and3_1
XFILLER_0_68_209 VPWR VGND VPWR VGND sky130_ef_sc_hd__decap_12
XFILLER_0_55_82 VPWR VGND VPWR VGND sky130_ef_sc_hd__decap_12
Xaccumulator._2226_ accumulator._0206_ accumulator._0207_ accumulator._0351_ VGND
+ VGND VPWR VPWR accumulator._0208_ sky130_fd_sc_hd__a21o_1
XTAP_TAPCELL_ROW_1_157 VGND VPWR sky130_fd_sc_hd__tapvpwrvgnd_1
Xaccumulator._2157_ accumulator._0139_ accumulator._0140_ accumulator._1097_ VGND
+ VGND VPWR VPWR accumulator._0141_ sky130_fd_sc_hd__mux2_4
XTAP_TAPCELL_ROW_52_513 VGND VPWR sky130_fd_sc_hd__tapvpwrvgnd_1
XFILLER_0_36_106 VPWR VGND VPWR VGND sky130_ef_sc_hd__decap_12
Xaccumulator._2088_ accumulator._0070_ accumulator._0073_ accumulator._0061_ VGND
+ VGND VPWR VPWR accumulator._0075_ sky130_fd_sc_hd__mux2_4
XFILLER_0_17_364 VPWR VGND VPWR VGND sky130_ef_sc_hd__decap_12
XFILLER_0_44_183 VGND VGND VPWR VPWR sky130_fd_sc_hd__fill_2
XFILLER_0_4_280 VPWR VGND VPWR VGND sky130_ef_sc_hd__decap_12
XTAP_TAPCELL_ROW_9_213 VGND VPWR sky130_fd_sc_hd__tapvpwrvgnd_1
Xoperator._059_ net11 operator._002_ VGND VGND VPWR VPWR operator._003_ sky130_fd_sc_hd__nor2_1
XFILLER_0_67_220 VGND VGND VPWR VPWR sky130_fd_sc_hd__decap_4
XFILLER_0_50_197 VGND VGND VPWR VPWR sky130_fd_sc_hd__fill_2
XFILLER_0_23_378 VPWR VGND VPWR VGND sky130_ef_sc_hd__decap_12
Xaccumulator._1390_ accumulator._0285_ accumulator._0273_ accumulator._0484_ accumulator._0487_
+ VGND VGND VPWR VPWR accumulator._0488_ sky130_fd_sc_hd__a31o_1
Xaccumulator._2011_ accumulator._1108_ accumulator._1098_ accumulator._1084_ VGND
+ VGND VPWR VPWR accumulator._1109_ sky130_fd_sc_hd__a21oi_1
XFILLER_0_46_404 VGND VGND VPWR VPWR sky130_fd_sc_hd__fill_1
XFILLER_0_25_74 VGND VGND VPWR VPWR sky130_fd_sc_hd__fill_2
XFILLER_0_18_139 VGND VGND VPWR VPWR sky130_fd_sc_hd__fill_1
XFILLER_0_67_3 VPWR VGND VPWR VGND sky130_ef_sc_hd__decap_12
XFILLER_0_41_197 VGND VGND VPWR VPWR sky130_fd_sc_hd__decap_8
XFILLER_0_41_95 VGND VGND VPWR VPWR sky130_fd_sc_hd__fill_1
XFILLER_0_26_194 VGND VGND VPWR VPWR sky130_fd_sc_hd__fill_2
XFILLER_0_14_389 VPWR VGND VPWR VGND sky130_ef_sc_hd__decap_12
Xaccumulator._1657_ accumulator._0753_ accumulator._0754_ VGND VGND VPWR VPWR accumulator._0755_
+ sky130_fd_sc_hd__nand2_1
Xaccumulator._1588_ accumulator._0449_ accumulator._0646_ accumulator._0647_ VGND
+ VGND VPWR VPWR accumulator._0686_ sky130_fd_sc_hd__nand3_1
Xaccumulator._1726_ accumulator.io_accOut\[11\] accumulator._0355_ accumulator._0537_
+ VGND VGND VPWR VPWR accumulator._0824_ sky130_fd_sc_hd__o21a_1
XFILLER_0_64_201 VGND VGND VPWR VPWR sky130_fd_sc_hd__fill_2
XFILLER_0_49_242 VGND VGND VPWR VPWR sky130_fd_sc_hd__fill_2
Xaccumulator._2209_ accumulator._0075_ accumulator._0185_ VGND VGND VPWR VPWR accumulator._0192_
+ sky130_fd_sc_hd__nor2_1
XFILLER_0_64_289 VGND VGND VPWR VPWR sky130_fd_sc_hd__decap_4
XFILLER_0_64_245 VGND VGND VPWR VPWR sky130_fd_sc_hd__decap_6
XFILLER_0_9_361 VPWR VGND VPWR VGND sky130_ef_sc_hd__decap_12
XTAP_TAPCELL_ROW_12_229 VGND VPWR sky130_fd_sc_hd__tapvpwrvgnd_1
XFILLER_0_17_194 VPWR VGND VPWR VGND sky130_ef_sc_hd__decap_12
XFILLER_0_46_29 VPWR VGND VPWR VGND sky130_ef_sc_hd__decap_12
XFILLER_0_11_337 VPWR VGND VPWR VGND sky130_ef_sc_hd__decap_12
Xaccumulator._1442_ accumulator._0475_ accumulator._0517_ accumulator._0490_ VGND
+ VGND VPWR VPWR accumulator._0540_ sky130_fd_sc_hd__a21o_1
Xaccumulator._1511_ accumulator._0502_ accumulator._0539_ accumulator._0540_ accumulator._0543_
+ accumulator._0448_ VGND VGND VPWR VPWR accumulator._0609_ sky130_fd_sc_hd__a311o_1
XPHY_EDGE_ROW_18_Right_18 VGND VGND VPWR VPWR sky130_fd_sc_hd__decap_3
XFILLER_0_36_73 VGND VGND VPWR VPWR sky130_fd_sc_hd__decap_8
Xaccumulator._1373_ accumulator._0454_ accumulator._0469_ accumulator._0470_ VGND
+ VGND VPWR VPWR accumulator._0471_ sky130_fd_sc_hd__a21o_1
XPHY_EDGE_ROW_27_Right_27 VGND VGND VPWR VPWR sky130_fd_sc_hd__decap_3
Xinput3 io_inA[2] VGND VGND VPWR VPWR net3 sky130_fd_sc_hd__buf_1
XFILLER_0_61_204 VGND VGND VPWR VPWR sky130_fd_sc_hd__fill_2
XFILLER_0_46_289 VGND VGND VPWR VPWR sky130_fd_sc_hd__decap_6
XTAP_TAPCELL_ROW_34_387 VGND VPWR sky130_fd_sc_hd__tapvpwrvgnd_1
XPHY_EDGE_ROW_36_Right_36 VGND VGND VPWR VPWR sky130_fd_sc_hd__decap_3
XFILLER_0_14_153 VGND VGND VPWR VPWR sky130_fd_sc_hd__fill_2
XFILLER_0_14_197 VGND VGND VPWR VPWR sky130_fd_sc_hd__decap_3
Xaccumulator._1709_ accumulator._0799_ accumulator._0801_ accumulator._0806_ VGND
+ VGND VPWR VPWR accumulator._0807_ sky130_fd_sc_hd__and3_1
XPHY_EDGE_ROW_45_Right_45 VGND VGND VPWR VPWR sky130_fd_sc_hd__decap_3
XTAP_TAPCELL_ROW_25_321 VGND VPWR sky130_fd_sc_hd__tapvpwrvgnd_1
XPHY_EDGE_ROW_54_Right_54 VGND VGND VPWR VPWR sky130_fd_sc_hd__decap_3
XscaleAdd._430_ scaleAdd._093_ scaleAdd._094_ VGND VGND VPWR VPWR scaleAdd._108_ sky130_fd_sc_hd__and2b_1
XFILLER_0_57_39 VPWR VGND VPWR VGND sky130_ef_sc_hd__decap_12
X_01_ accumulator.io_accOut\[1\] VGND VGND VPWR VPWR net40 sky130_fd_sc_hd__buf_1
XscaleAdd._361_ scaleAdd._221_ operator.io_outMant\[5\] scaleAdd._224_ scaleAdd._226_
+ scaleAdd._262_ VGND VGND VPWR VPWR scaleAdd._042_ sky130_fd_sc_hd__a32oi_4
XscaleAdd._292_ scaleAdd._225_ scaleAdd._242_ VGND VGND VPWR VPWR scaleAdd._243_ sky130_fd_sc_hd__nand2_1
XPHY_EDGE_ROW_63_Right_63 VGND VGND VPWR VPWR sky130_fd_sc_hd__decap_3
Xaccumulator._1991_ accumulator._0903_ accumulator._0984_ VGND VGND VPWR VPWR accumulator._1089_
+ sky130_fd_sc_hd__nand2_1
XTAP_TAPCELL_ROW_31_368 VGND VPWR sky130_fd_sc_hd__tapvpwrvgnd_1
XFILLER_0_28_278 VPWR VGND VPWR VGND sky130_ef_sc_hd__decap_12
XFILLER_0_51_281 VPWR VGND VPWR VGND sky130_ef_sc_hd__decap_12
XTAP_TAPCELL_ROW_39_424 VGND VPWR sky130_fd_sc_hd__tapvpwrvgnd_1
Xaccumulator._1425_ accumulator._0454_ accumulator._0522_ accumulator._0490_ VGND
+ VGND VPWR VPWR accumulator._0523_ sky130_fd_sc_hd__a21o_1
XPHY_EDGE_ROW_22_Left_91 VGND VGND VPWR VPWR sky130_fd_sc_hd__decap_3
Xaccumulator._1287_ accumulator._0347_ accumulator._0384_ VGND VGND VPWR VPWR accumulator._0385_
+ sky130_fd_sc_hd__nor2_1
Xaccumulator._1356_ accumulator._0453_ VGND VGND VPWR VPWR accumulator._0454_ sky130_fd_sc_hd__buf_2
XTAP_TAPCELL_ROW_22_302 VGND VPWR sky130_fd_sc_hd__tapvpwrvgnd_1
XFILLER_0_2_85 VPWR VGND VPWR VGND sky130_ef_sc_hd__decap_12
XFILLER_0_42_270 VGND VGND VPWR VPWR sky130_fd_sc_hd__fill_1
XFILLER_0_6_161 VGND VGND VPWR VPWR sky130_fd_sc_hd__decap_8
XFILLER_0_57_307 VGND VGND VPWR VPWR sky130_fd_sc_hd__decap_8
XFILLER_0_65_384 VGND VGND VPWR VPWR sky130_fd_sc_hd__decap_8
XFILLER_0_25_204 VGND VGND VPWR VPWR sky130_fd_sc_hd__decap_4
XFILLER_0_68_27 VGND VGND VPWR VPWR sky130_fd_sc_hd__fill_1
XFILLER_0_40_218 VPWR VGND VPWR VGND sky130_ef_sc_hd__decap_12
XFILLER_0_33_281 VGND VGND VPWR VPWR sky130_fd_sc_hd__decap_6
XscaleAdd._413_ scaleAdd._091_ scaleAdd._090_ VGND VGND VPWR VPWR scaleAdd._092_ sky130_fd_sc_hd__or2_4
XFILLER_0_0_337 VPWR VGND VPWR VGND sky130_ef_sc_hd__decap_12
XscaleAdd._344_ scaleAdd._264_ net62 scaleAdd._025_ VGND VGND VPWR VPWR scaleAdd._026_
+ sky130_fd_sc_hd__a21o_1
XscaleAdd._275_ scaleAdd._227_ VGND VGND VPWR VPWR accumulator.io_inMant\[0\] sky130_fd_sc_hd__buf_1
XFILLER_0_17_42 VGND VGND VPWR VPWR sky130_fd_sc_hd__decap_6
Xaccumulator._2190_ accumulator.io_accOut\[18\] accumulator._0364_ accumulator._1031_
+ accumulator._0173_ VGND VGND VPWR VPWR accumulator._0174_ sky130_fd_sc_hd__o2bb2a_1
XFILLER_0_33_63 VGND VGND VPWR VPWR sky130_fd_sc_hd__fill_1
XFILLER_0_33_52 VGND VGND VPWR VPWR sky130_fd_sc_hd__decap_4
Xaccumulator._1210_ accumulator._0274_ accumulator._0093_ VGND VGND VPWR VPWR accumulator._0310_
+ sky130_fd_sc_hd__and2b_1
XFILLER_0_17_86 VPWR VGND VPWR VGND sky130_ef_sc_hd__decap_12
Xaccumulator._1974_ accumulator._1064_ accumulator._1069_ accumulator._1071_ VGND
+ VGND VPWR VPWR accumulator._1072_ sky130_fd_sc_hd__a21boi_1
XFILLER_0_3_131 VPWR VGND VPWR VGND sky130_ef_sc_hd__decap_12
Xoperator._092_ operator._029_ VGND VGND VPWR VPWR operator.io_outMant\[2\] sky130_fd_sc_hd__buf_2
XFILLER_0_16_226 VGND VGND VPWR VPWR sky130_fd_sc_hd__fill_1
XFILLER_0_16_259 VGND VGND VPWR VPWR sky130_fd_sc_hd__fill_1
XFILLER_0_58_93 VGND VGND VPWR VPWR sky130_fd_sc_hd__fill_1
Xaccumulator._1408_ accumulator._0454_ accumulator._0505_ accumulator._0455_ VGND
+ VGND VPWR VPWR accumulator._0506_ sky130_fd_sc_hd__a21o_1
XFILLER_0_66_115 VGND VGND VPWR VPWR sky130_fd_sc_hd__fill_1
XFILLER_0_62_321 VGND VGND VPWR VPWR sky130_fd_sc_hd__decap_3
XFILLER_0_47_373 VPWR VGND VPWR VGND sky130_ef_sc_hd__decap_12
Xaccumulator._1339_ accumulator._0397_ accumulator._0381_ accumulator._0435_ VGND
+ VGND VPWR VPWR accumulator._0437_ sky130_fd_sc_hd__a21oi_2
XPHY_EDGE_ROW_0_Right_0 VGND VGND VPWR VPWR sky130_fd_sc_hd__decap_3
XFILLER_0_62_398 VGND VGND VPWR VPWR sky130_fd_sc_hd__decap_8
XTAP_TAPCELL_ROW_50_496 VGND VPWR sky130_fd_sc_hd__tapvpwrvgnd_1
XFILLER_0_30_273 VGND VGND VPWR VPWR sky130_fd_sc_hd__decap_4
XFILLER_0_15_281 VGND VGND VPWR VPWR sky130_fd_sc_hd__decap_6
XFILLER_0_15_292 VGND VGND VPWR VPWR sky130_fd_sc_hd__decap_3
XFILLER_0_54_29 VPWR VGND VPWR VGND sky130_ef_sc_hd__decap_12
XTAP_TAPCELL_ROW_7_196 VGND VPWR sky130_fd_sc_hd__tapvpwrvgnd_1
XTAP_TAPCELL_ROW_58_552 VGND VPWR sky130_fd_sc_hd__tapvpwrvgnd_1
XFILLER_0_53_310 VPWR VGND VPWR VGND sky130_ef_sc_hd__decap_12
Xaccumulator._1690_ accumulator._0390_ accumulator._0635_ VGND VGND VPWR VPWR accumulator._0788_
+ sky130_fd_sc_hd__or2_1
XFILLER_0_0_156 VPWR VGND VPWR VGND sky130_ef_sc_hd__decap_12
XscaleAdd._327_ net63 scaleAdd._009_ VGND VGND VPWR VPWR scaleAdd._010_ sky130_fd_sc_hd__nand2_1
XFILLER_0_21_262 VGND VGND VPWR VPWR sky130_fd_sc_hd__fill_1
XFILLER_0_44_62 VGND VGND VPWR VPWR sky130_fd_sc_hd__decap_8
Xaccumulator._2311_ clknet_2_2__leaf_clock accumulator._0018_ VGND VGND VPWR VPWR
+ accumulator.io_accOut\[16\] sky130_fd_sc_hd__dfxtp_1
XFILLER_0_28_85 VGND VGND VPWR VPWR sky130_fd_sc_hd__decap_6
Xaccumulator._2242_ accumulator._0358_ accumulator._0223_ VGND VGND VPWR VPWR accumulator._0224_
+ sky130_fd_sc_hd__nand2_1
XTAP_TAPCELL_ROW_64_599 VGND VPWR sky130_fd_sc_hd__tapvpwrvgnd_1
XFILLER_0_63_118 VGND VGND VPWR VPWR sky130_fd_sc_hd__decap_8
Xaccumulator._2173_ accumulator._0156_ accumulator._0139_ accumulator._0047_ VGND
+ VGND VPWR VPWR accumulator._0157_ sky130_fd_sc_hd__mux2_1
XFILLER_0_48_137 VGND VGND VPWR VPWR sky130_fd_sc_hd__decap_3
XFILLER_0_48_115 VGND VGND VPWR VPWR sky130_fd_sc_hd__fill_1
XFILLER_0_8_212 VPWR VGND VPWR VGND sky130_ef_sc_hd__decap_12
Xaccumulator._1957_ accumulator._0949_ accumulator._1054_ VGND VGND VPWR VPWR accumulator._1055_
+ sky130_fd_sc_hd__xnor2_1
XFILLER_0_44_365 VGND VGND VPWR VPWR sky130_fd_sc_hd__decap_8
XPHY_EDGE_ROW_31_Left_100 VGND VGND VPWR VPWR sky130_fd_sc_hd__decap_3
Xoperator._075_ operator._015_ VGND VGND VPWR VPWR operator.io_outExp\[4\] sky130_fd_sc_hd__clkbuf_2
XFILLER_0_8_289 VPWR VGND VPWR VGND sky130_ef_sc_hd__decap_12
Xaccumulator._1888_ accumulator._0985_ accumulator._0912_ accumulator._0366_ VGND
+ VGND VPWR VPWR accumulator._0986_ sky130_fd_sc_hd__mux2_2
XFILLER_0_5_9 VGND VGND VPWR VPWR sky130_fd_sc_hd__fill_2
XTAP_TAPCELL_ROW_55_533 VGND VPWR sky130_fd_sc_hd__tapvpwrvgnd_1
XFILLER_0_39_104 VGND VGND VPWR VPWR sky130_fd_sc_hd__decap_8
XTAP_TAPCELL_ROW_4_177 VGND VPWR sky130_fd_sc_hd__tapvpwrvgnd_1
Xclone31 accumulator._1118_ VGND VGND VPWR VPWR net94 sky130_fd_sc_hd__buf_6
XFILLER_0_50_346 VPWR VGND VPWR VGND sky130_ef_sc_hd__decap_12
XFILLER_0_65_39 VPWR VGND VPWR VGND sky130_ef_sc_hd__decap_12
XFILLER_0_14_10 VGND VGND VPWR VPWR sky130_fd_sc_hd__decap_4
XFILLER_0_14_32 VPWR VGND VPWR VGND sky130_ef_sc_hd__decap_12
XFILLER_0_14_54 VGND VGND VPWR VPWR sky130_fd_sc_hd__decap_4
Xaccumulator._1811_ accumulator._0808_ accumulator._0803_ accumulator._0908_ accumulator._0816_
+ VGND VGND VPWR VPWR accumulator._0909_ sky130_fd_sc_hd__a211o_1
XFILLER_0_30_97 VPWR VGND VPWR VGND sky130_ef_sc_hd__decap_12
XFILLER_0_30_64 VPWR VGND VPWR VGND sky130_ef_sc_hd__decap_12
XFILLER_0_26_365 VPWR VGND VPWR VGND sky130_ef_sc_hd__decap_12
Xaccumulator._1673_ accumulator._0768_ accumulator._0769_ VGND VGND VPWR VPWR accumulator._0771_
+ sky130_fd_sc_hd__nand2_1
Xaccumulator._1742_ accumulator._0493_ accumulator._0598_ accumulator._0446_ accumulator._0601_
+ VGND VGND VPWR VPWR accumulator._0840_ sky130_fd_sc_hd__a211o_1
Xaccumulator._2156_ accumulator._0126_ VGND VGND VPWR VPWR accumulator._0140_ sky130_fd_sc_hd__inv_2
XFILLER_0_55_94 VPWR VGND VPWR VGND sky130_ef_sc_hd__decap_12
XTAP_TAPCELL_ROW_52_514 VGND VPWR sky130_fd_sc_hd__tapvpwrvgnd_1
Xaccumulator._2225_ net102 accumulator._0205_ VGND VGND VPWR VPWR accumulator._0207_
+ sky130_fd_sc_hd__nand2_1
XTAP_TAPCELL_ROW_1_158 VGND VPWR sky130_fd_sc_hd__tapvpwrvgnd_1
XFILLER_0_44_151 VGND VGND VPWR VPWR sky130_fd_sc_hd__decap_8
Xaccumulator._2087_ accumulator._1145_ accumulator._0072_ accumulator._1137_ VGND
+ VGND VPWR VPWR accumulator._0073_ sky130_fd_sc_hd__mux2_4
XFILLER_0_36_118 VGND VGND VPWR VPWR sky130_fd_sc_hd__fill_1
XFILLER_0_29_192 VGND VGND VPWR VPWR sky130_fd_sc_hd__fill_1
XFILLER_0_17_376 VPWR VGND VPWR VGND sky130_ef_sc_hd__decap_12
XFILLER_0_4_292 VPWR VGND VPWR VGND sky130_ef_sc_hd__decap_12
XTAP_TAPCELL_ROW_9_214 VGND VPWR sky130_fd_sc_hd__tapvpwrvgnd_1
Xoperator._058_ net9 net10 VGND VGND VPWR VPWR operator._002_ sky130_fd_sc_hd__or2_4
XFILLER_0_35_162 VGND VGND VPWR VPWR sky130_fd_sc_hd__decap_6
Xaccumulator._2010_ accumulator._1046_ accumulator._1107_ accumulator._1048_ VGND
+ VGND VPWR VPWR accumulator._1108_ sky130_fd_sc_hd__a21bo_1
XFILLER_0_58_287 VGND VGND VPWR VPWR sky130_fd_sc_hd__fill_1
Xaccumulator._1725_ accumulator._0720_ accumulator._0822_ accumulator._0726_ VGND
+ VGND VPWR VPWR accumulator._0823_ sky130_fd_sc_hd__o21bai_1
Xaccumulator._1587_ accumulator._0675_ accumulator._0683_ accumulator._0684_ VGND
+ VGND VPWR VPWR accumulator._0685_ sky130_fd_sc_hd__and3_1
Xaccumulator._1656_ accumulator._0567_ accumulator._0568_ accumulator._0394_ VGND
+ VGND VPWR VPWR accumulator._0754_ sky130_fd_sc_hd__a21o_1
Xaccumulator._2139_ accumulator._0065_ VGND VGND VPWR VPWR accumulator._0124_ sky130_fd_sc_hd__inv_2
Xaccumulator._2208_ accumulator._0184_ accumulator._0185_ accumulator._0189_ accumulator._0190_
+ VGND VGND VPWR VPWR accumulator._0022_ sky130_fd_sc_hd__o211a_1
XFILLER_0_32_154 VGND VGND VPWR VPWR sky130_fd_sc_hd__fill_1
XFILLER_0_9_373 VPWR VGND VPWR VGND sky130_ef_sc_hd__decap_12
XFILLER_0_17_140 VGND VGND VPWR VPWR sky130_fd_sc_hd__decap_8
XFILLER_0_17_184 VGND VGND VPWR VPWR sky130_fd_sc_hd__fill_1
XTAP_TAPCELL_ROW_20_285 VGND VPWR sky130_fd_sc_hd__tapvpwrvgnd_1
XFILLER_0_1_3 VPWR VGND VPWR VGND sky130_ef_sc_hd__decap_12
XFILLER_0_62_29 VPWR VGND VPWR VGND sky130_ef_sc_hd__decap_12
XTAP_TAPCELL_ROW_28_341 VGND VPWR sky130_fd_sc_hd__tapvpwrvgnd_1
XFILLER_0_55_246 VPWR VGND VPWR VGND sky130_ef_sc_hd__decap_12
XFILLER_0_55_202 VPWR VGND VPWR VGND sky130_ef_sc_hd__decap_12
XFILLER_0_23_165 VGND VGND VPWR VPWR sky130_fd_sc_hd__decap_3
XFILLER_0_11_88 VGND VGND VPWR VPWR sky130_fd_sc_hd__decap_3
XFILLER_0_11_305 VPWR VGND VPWR VGND sky130_ef_sc_hd__decap_12
XFILLER_0_11_349 VPWR VGND VPWR VGND sky130_ef_sc_hd__decap_12
Xaccumulator._1510_ accumulator._0606_ accumulator._0607_ VGND VGND VPWR VPWR accumulator._0608_
+ sky130_fd_sc_hd__nand2_1
XFILLER_0_36_41 VGND VGND VPWR VPWR sky130_fd_sc_hd__fill_2
Xaccumulator._1372_ accumulator._0381_ VGND VGND VPWR VPWR accumulator._0470_ sky130_fd_sc_hd__buf_2
Xaccumulator._1441_ accumulator._0475_ accumulator._0489_ accumulator._0413_ VGND
+ VGND VPWR VPWR accumulator._0539_ sky130_fd_sc_hd__a21o_1
Xinput4 io_inA[3] VGND VGND VPWR VPWR net4 sky130_fd_sc_hd__buf_1
XFILLER_0_36_85 VGND VGND VPWR VPWR sky130_fd_sc_hd__decap_3
XFILLER_0_19_405 VGND VGND VPWR VPWR sky130_fd_sc_hd__fill_1
XFILLER_0_46_279 VGND VGND VPWR VPWR sky130_fd_sc_hd__fill_1
XTAP_TAPCELL_ROW_34_388 VGND VPWR sky130_fd_sc_hd__tapvpwrvgnd_1
XFILLER_0_6_321 VPWR VGND VPWR VGND sky130_ef_sc_hd__decap_12
XFILLER_0_6_365 VPWR VGND VPWR VGND sky130_ef_sc_hd__decap_12
XFILLER_0_14_165 VGND VGND VPWR VPWR sky130_fd_sc_hd__decap_8
Xaccumulator._1708_ accumulator._0804_ accumulator._0805_ VGND VGND VPWR VPWR accumulator._0806_
+ sky130_fd_sc_hd__or2_2
Xaccumulator._1639_ accumulator._0733_ accumulator._0735_ VGND VGND VPWR VPWR accumulator._0737_
+ sky130_fd_sc_hd__and2_1
XFILLER_0_52_205 VGND VGND VPWR VPWR sky130_fd_sc_hd__fill_1
XFILLER_0_37_279 VGND VGND VPWR VPWR sky130_fd_sc_hd__fill_1
XTAP_TAPCELL_ROW_25_322 VGND VPWR sky130_fd_sc_hd__tapvpwrvgnd_1
XscaleAdd._360_ operator.io_outMant\[4\] scaleAdd._239_ VGND VGND VPWR VPWR scaleAdd._041_
+ sky130_fd_sc_hd__and2_1
X_00_ accumulator.io_accOut\[0\] VGND VGND VPWR VPWR net29 sky130_fd_sc_hd__buf_1
XscaleAdd._291_ scaleAdd._240_ scaleAdd._241_ VGND VGND VPWR VPWR scaleAdd._242_ sky130_fd_sc_hd__and2_1
XFILLER_0_68_393 VPWR VGND VPWR VGND sky130_ef_sc_hd__decap_12
Xaccumulator._1990_ accumulator._0926_ accumulator._1087_ VGND VGND VPWR VPWR accumulator._1088_
+ sky130_fd_sc_hd__xnor2_2
XFILLER_0_43_238 VGND VGND VPWR VPWR sky130_fd_sc_hd__fill_1
XFILLER_0_3_335 VGND VGND VPWR VPWR sky130_fd_sc_hd__fill_1
XFILLER_0_51_293 VPWR VGND VPWR VGND sky130_ef_sc_hd__decap_12
XFILLER_0_11_113 VPWR VGND VPWR VGND sky130_ef_sc_hd__decap_12
XscaleAdd._489_ scaleAdd._159_ scaleAdd._160_ VGND VGND VPWR VPWR scaleAdd._161_ sky130_fd_sc_hd__nand2_1
XFILLER_0_47_51 VGND VGND VPWR VPWR sky130_fd_sc_hd__decap_4
Xaccumulator._1424_ accumulator.io_accOut\[17\] accumulator._0521_ accumulator._0347_
+ VGND VGND VPWR VPWR accumulator._0522_ sky130_fd_sc_hd__mux2_1
Xaccumulator._1355_ accumulator._0451_ accumulator._0452_ accumulator._0353_ VGND
+ VGND VPWR VPWR accumulator._0453_ sky130_fd_sc_hd__mux2_4
XFILLER_0_59_393 VPWR VGND VPWR VGND sky130_ef_sc_hd__decap_12
XTAP_TAPCELL_ROW_47_480 VGND VPWR sky130_fd_sc_hd__tapvpwrvgnd_1
Xaccumulator._1286_ accumulator._0374_ accumulator._0383_ VGND VGND VPWR VPWR accumulator._0384_
+ sky130_fd_sc_hd__nor2_2
XTAP_TAPCELL_ROW_22_303 VGND VPWR sky130_fd_sc_hd__tapvpwrvgnd_1
XFILLER_0_2_97 VPWR VGND VPWR VGND sky130_ef_sc_hd__decap_12
XFILLER_0_19_246 VGND VGND VPWR VPWR sky130_fd_sc_hd__fill_1
XFILLER_0_19_257 VGND VGND VPWR VPWR sky130_fd_sc_hd__fill_1
XFILLER_0_34_249 VGND VGND VPWR VPWR sky130_fd_sc_hd__decap_3
XFILLER_0_6_184 VPWR VGND VPWR VGND sky130_ef_sc_hd__decap_12
XFILLER_0_65_341 VGND VGND VPWR VPWR sky130_fd_sc_hd__fill_1
XFILLER_0_33_260 VGND VGND VPWR VPWR sky130_fd_sc_hd__fill_1
XscaleAdd._412_ scaleAdd._262_ scaleAdd._239_ scaleAdd._248_ operator.io_outMant\[5\]
+ VGND VGND VPWR VPWR scaleAdd._091_ sky130_fd_sc_hd__a22oi_1
XFILLER_0_0_349 VPWR VGND VPWR VGND sky130_ef_sc_hd__decap_12
XscaleAdd._343_ scaleAdd._001_ scaleAdd._002_ VGND VGND VPWR VPWR scaleAdd._025_ sky130_fd_sc_hd__nor2_1
XscaleAdd._274_ scaleAdd._221_ net63 VGND VGND VPWR VPWR scaleAdd._227_ sky130_fd_sc_hd__and2_1
XFILLER_0_17_54 VGND VGND VPWR VPWR sky130_fd_sc_hd__fill_2
XFILLER_0_17_98 VPWR VGND VPWR VGND sky130_ef_sc_hd__decap_12
XFILLER_0_56_341 VPWR VGND VPWR VGND sky130_ef_sc_hd__decap_12
Xaccumulator._1973_ accumulator._0952_ accumulator._1070_ VGND VGND VPWR VPWR accumulator._1071_
+ sky130_fd_sc_hd__xnor2_2
XFILLER_0_24_271 VGND VGND VPWR VPWR sky130_fd_sc_hd__decap_8
XFILLER_0_3_143 VPWR VGND VPWR VGND sky130_ef_sc_hd__decap_12
Xoperator._091_ operator._027_ operator._028_ VGND VGND VPWR VPWR operator._029_ sky130_fd_sc_hd__and2_1
XFILLER_0_42_3 VPWR VGND VPWR VGND sky130_ef_sc_hd__decap_12
Xaccumulator._1407_ accumulator.io_accOut\[12\] accumulator._0504_ net64 VGND VGND
+ VPWR VPWR accumulator._0505_ sky130_fd_sc_hd__mux2_1
Xaccumulator._1338_ accumulator._0353_ accumulator._0381_ accumulator._0435_ VGND
+ VGND VPWR VPWR accumulator._0436_ sky130_fd_sc_hd__and3_1
Xaccumulator._1269_ accumulator._0366_ VGND VGND VPWR VPWR accumulator._0367_ sky130_fd_sc_hd__buf_2
XFILLER_0_62_333 VPWR VGND VPWR VGND sky130_ef_sc_hd__decap_12
XFILLER_0_62_300 VGND VGND VPWR VPWR sky130_fd_sc_hd__decap_8
XTAP_TAPCELL_ROW_50_497 VGND VPWR sky130_fd_sc_hd__tapvpwrvgnd_1
XFILLER_0_47_385 VGND VGND VPWR VPWR sky130_fd_sc_hd__decap_6
XFILLER_0_22_219 VGND VGND VPWR VPWR sky130_fd_sc_hd__fill_1
XFILLER_0_15_260 VGND VGND VPWR VPWR sky130_fd_sc_hd__decap_4
XTAP_TAPCELL_ROW_58_553 VGND VPWR sky130_fd_sc_hd__tapvpwrvgnd_1
XTAP_TAPCELL_ROW_7_197 VGND VPWR sky130_fd_sc_hd__tapvpwrvgnd_1
XFILLER_0_57_105 VGND VGND VPWR VPWR sky130_fd_sc_hd__fill_1
XFILLER_0_38_363 VGND VGND VPWR VPWR sky130_fd_sc_hd__fill_1
XFILLER_0_53_355 VGND VGND VPWR VPWR sky130_fd_sc_hd__fill_1
XFILLER_0_53_322 VGND VGND VPWR VPWR sky130_fd_sc_hd__decap_3
XFILLER_0_13_208 VPWR VGND VPWR VGND sky130_ef_sc_hd__decap_12
XFILLER_0_0_113 VPWR VGND VPWR VGND sky130_ef_sc_hd__decap_12
XscaleAdd._326_ scaleAdd._234_ scaleAdd._235_ scaleAdd._222_ VGND VGND VPWR VPWR scaleAdd._009_
+ sky130_fd_sc_hd__o21ba_2
Xaccumulator._2172_ accumulator._1038_ accumulator._1019_ accumulator._1120_ VGND
+ VGND VPWR VPWR accumulator._0156_ sky130_fd_sc_hd__mux2_2
XFILLER_0_44_41 VPWR VGND VPWR VGND sky130_ef_sc_hd__decap_12
Xaccumulator._2310_ clknet_2_3__leaf_clock accumulator._0017_ VGND VGND VPWR VPWR
+ accumulator.io_accOut\[15\] sky130_fd_sc_hd__dfxtp_1
Xaccumulator._2241_ accumulator._0213_ accumulator._0222_ VGND VGND VPWR VPWR accumulator._0223_
+ sky130_fd_sc_hd__xnor2_1
XFILLER_0_44_344 VGND VGND VPWR VPWR sky130_fd_sc_hd__decap_6
XFILLER_0_44_300 VGND VGND VPWR VPWR sky130_fd_sc_hd__decap_8
XFILLER_0_8_224 VGND VGND VPWR VPWR sky130_fd_sc_hd__decap_4
Xaccumulator._1887_ accumulator._0914_ accumulator._0745_ accumulator._0870_ VGND
+ VGND VPWR VPWR accumulator._0985_ sky130_fd_sc_hd__o21a_1
Xaccumulator._1956_ accumulator._1053_ accumulator._0946_ accumulator._0902_ VGND
+ VGND VPWR VPWR accumulator._1054_ sky130_fd_sc_hd__o21a_1
XFILLER_0_44_377 VGND VGND VPWR VPWR sky130_fd_sc_hd__decap_6
XFILLER_0_8_52 VPWR VGND VPWR VGND sky130_ef_sc_hd__decap_12
XFILLER_0_8_85 VPWR VGND VPWR VGND sky130_ef_sc_hd__decap_12
XFILLER_0_12_241 VGND VGND VPWR VPWR sky130_fd_sc_hd__decap_8
Xoperator._074_ operator.io_outExp\[1\] operator._010_ VGND VGND VPWR VPWR operator._015_
+ sky130_fd_sc_hd__and2_1
XTAP_TAPCELL_ROW_4_178 VGND VPWR sky130_fd_sc_hd__tapvpwrvgnd_1
XTAP_TAPCELL_ROW_55_534 VGND VPWR sky130_fd_sc_hd__tapvpwrvgnd_1
XFILLER_0_54_119 VPWR VGND VPWR VGND sky130_ef_sc_hd__decap_12
XFILLER_0_62_141 VGND VGND VPWR VPWR sky130_fd_sc_hd__decap_8
XFILLER_0_50_358 VGND VGND VPWR VPWR sky130_fd_sc_hd__decap_6
XFILLER_0_50_336 VGND VGND VPWR VPWR sky130_fd_sc_hd__fill_1
XFILLER_0_50_303 VGND VGND VPWR VPWR sky130_fd_sc_hd__fill_2
XFILLER_0_53_130 VGND VGND VPWR VPWR sky130_fd_sc_hd__fill_1
XFILLER_0_38_171 VGND VGND VPWR VPWR sky130_fd_sc_hd__decap_8
Xaccumulator._1741_ accumulator._0533_ accumulator._0836_ accumulator._0838_ accumulator._0669_
+ accumulator._0749_ VGND VGND VPWR VPWR accumulator._0839_ sky130_fd_sc_hd__a32o_2
Xaccumulator._1810_ accumulator._0806_ accumulator._0796_ VGND VGND VPWR VPWR accumulator._0908_
+ sky130_fd_sc_hd__and2_1
XFILLER_0_30_76 VGND VGND VPWR VPWR sky130_fd_sc_hd__decap_8
XFILLER_0_30_43 VGND VGND VPWR VPWR sky130_fd_sc_hd__decap_3
Xaccumulator._1672_ accumulator._0768_ accumulator._0769_ VGND VGND VPWR VPWR accumulator._0770_
+ sky130_fd_sc_hd__nor2_1
XFILLER_0_55_62 VPWR VGND VPWR VGND sky130_ef_sc_hd__decap_12
XFILLER_0_55_51 VGND VGND VPWR VPWR sky130_fd_sc_hd__decap_4
XFILLER_0_39_63 VPWR VGND VPWR VGND sky130_ef_sc_hd__decap_12
XscaleAdd._309_ scaleAdd._240_ scaleAdd._243_ scaleAdd._258_ VGND VGND VPWR VPWR scaleAdd._259_
+ sky130_fd_sc_hd__a21oi_2
Xaccumulator._2155_ accumulator._1111_ accumulator._1036_ accumulator._1120_ VGND
+ VGND VPWR VPWR accumulator._0139_ sky130_fd_sc_hd__mux2_4
XTAP_TAPCELL_ROW_52_515 VGND VPWR sky130_fd_sc_hd__tapvpwrvgnd_1
Xaccumulator._2224_ net102 accumulator._0205_ VGND VGND VPWR VPWR accumulator._0206_
+ sky130_fd_sc_hd__or2_1
XTAP_TAPCELL_ROW_60_570 VGND VPWR sky130_fd_sc_hd__tapvpwrvgnd_1
Xaccumulator._2086_ accumulator._0071_ accumulator._0050_ accumulator._1127_ VGND
+ VGND VPWR VPWR accumulator._0072_ sky130_fd_sc_hd__mux2_4
XFILLER_0_44_174 VGND VGND VPWR VPWR sky130_fd_sc_hd__decap_4
XFILLER_0_29_182 VGND VGND VPWR VPWR sky130_fd_sc_hd__decap_4
Xoperator._057_ net5 VGND VGND VPWR VPWR operator._001_ sky130_fd_sc_hd__inv_2
XFILLER_0_17_388 VGND VGND VPWR VPWR sky130_fd_sc_hd__decap_4
Xaccumulator._1939_ accumulator._0984_ accumulator._0987_ accumulator._0918_ accumulator._0903_
+ VGND VGND VPWR VPWR accumulator._1037_ sky130_fd_sc_hd__o31ai_2
XFILLER_0_23_303 VGND VGND VPWR VPWR sky130_fd_sc_hd__decap_3
XTAP_TAPCELL_ROW_66_607 VGND VPWR sky130_fd_sc_hd__tapvpwrvgnd_1
XPHY_EDGE_ROW_50_Left_119 VGND VGND VPWR VPWR sky130_fd_sc_hd__decap_3
XFILLER_0_41_133 VGND VGND VPWR VPWR sky130_fd_sc_hd__decap_6
XFILLER_0_41_111 VGND VGND VPWR VPWR sky130_fd_sc_hd__fill_1
XFILLER_0_41_100 VGND VGND VPWR VPWR sky130_fd_sc_hd__decap_3
XFILLER_0_26_163 VPWR VGND VPWR VGND sky130_ef_sc_hd__decap_12
XFILLER_0_26_141 VGND VGND VPWR VPWR sky130_fd_sc_hd__fill_2
Xaccumulator._1724_ accumulator._0721_ VGND VGND VPWR VPWR accumulator._0822_ sky130_fd_sc_hd__inv_2
XFILLER_0_41_177 VGND VGND VPWR VPWR sky130_fd_sc_hd__fill_2
XFILLER_0_1_263 VPWR VGND VPWR VGND sky130_ef_sc_hd__decap_12
XFILLER_0_66_83 VGND VGND VPWR VPWR sky130_fd_sc_hd__fill_1
Xaccumulator._1586_ accumulator.io_accOut\[1\] accumulator._0348_ VGND VGND VPWR VPWR
+ accumulator._0684_ sky130_fd_sc_hd__nand2_1
Xaccumulator._1655_ accumulator._0395_ accumulator._0408_ VGND VGND VPWR VPWR accumulator._0753_
+ sky130_fd_sc_hd__nand2_1
Xaccumulator._2069_ accumulator._0363_ accumulator._0055_ VGND VGND VPWR VPWR accumulator._0005_
+ sky130_fd_sc_hd__nor2_1
Xaccumulator._2138_ accumulator._0066_ accumulator._0121_ accumulator._0351_ VGND
+ VGND VPWR VPWR accumulator._0123_ sky130_fd_sc_hd__a21o_1
Xaccumulator._2207_ accumulator.io_accOut\[20\] accumulator._0357_ accumulator._0089_
+ accumulator._0128_ accumulator._0352_ VGND VGND VPWR VPWR accumulator._0190_ sky130_fd_sc_hd__o221a_1
XFILLER_0_9_385 VGND VGND VPWR VPWR sky130_fd_sc_hd__decap_6
Xoperator._109_ operator._023_ operator._032_ operator._044_ VGND VGND VPWR VPWR operator._045_
+ sky130_fd_sc_hd__o21ai_1
XTAP_TAPCELL_ROW_20_286 VGND VPWR sky130_fd_sc_hd__tapvpwrvgnd_1
XFILLER_0_13_391 VGND VGND VPWR VPWR sky130_fd_sc_hd__fill_1
XTAP_TAPCELL_ROW_28_342 VGND VPWR sky130_fd_sc_hd__tapvpwrvgnd_1
XFILLER_0_55_258 VGND VGND VPWR VPWR sky130_fd_sc_hd__decap_4
XFILLER_0_55_225 VGND VGND VPWR VPWR sky130_fd_sc_hd__fill_2
XFILLER_0_55_214 VGND VGND VPWR VPWR sky130_fd_sc_hd__decap_4
XFILLER_0_23_111 VGND VGND VPWR VPWR sky130_fd_sc_hd__fill_1
XFILLER_0_11_12 VGND VGND VPWR VPWR sky130_fd_sc_hd__decap_8
XFILLER_0_23_133 VGND VGND VPWR VPWR sky130_fd_sc_hd__fill_1
XFILLER_0_11_317 VPWR VGND VPWR VGND sky130_ef_sc_hd__decap_12
Xaccumulator._1440_ accumulator.io_accOut\[11\] accumulator._0354_ accumulator._0537_
+ VGND VGND VPWR VPWR accumulator._0538_ sky130_fd_sc_hd__o21ai_4
Xaccumulator._1371_ accumulator.io_accOut\[21\] accumulator._0468_ net64 VGND VGND
+ VPWR VPWR accumulator._0469_ sky130_fd_sc_hd__mux2_1
Xinput5 io_inA[4] VGND VGND VPWR VPWR net5 sky130_fd_sc_hd__buf_1
XFILLER_0_52_85 VGND VGND VPWR VPWR sky130_fd_sc_hd__decap_3
XFILLER_0_52_41 VPWR VGND VPWR VGND sky130_ef_sc_hd__decap_12
XTAP_TAPCELL_ROW_34_389 VGND VPWR sky130_fd_sc_hd__tapvpwrvgnd_1
XFILLER_0_61_217 VGND VGND VPWR VPWR sky130_fd_sc_hd__fill_1
XFILLER_0_54_291 VGND VGND VPWR VPWR sky130_fd_sc_hd__decap_4
XFILLER_0_6_333 VPWR VGND VPWR VGND sky130_ef_sc_hd__decap_12
XFILLER_0_6_377 VPWR VGND VPWR VGND sky130_ef_sc_hd__decap_12
Xaccumulator._1638_ accumulator._0733_ accumulator._0735_ VGND VGND VPWR VPWR accumulator._0736_
+ sky130_fd_sc_hd__nor2_1
Xaccumulator._1707_ accumulator._0802_ accumulator._0803_ VGND VGND VPWR VPWR accumulator._0805_
+ sky130_fd_sc_hd__and2_1
Xaccumulator._1569_ accumulator._0434_ accumulator._0440_ accumulator._0400_ VGND
+ VGND VPWR VPWR accumulator._0667_ sky130_fd_sc_hd__o21a_1
XTAP_TAPCELL_ROW_25_323 VGND VPWR sky130_fd_sc_hd__tapvpwrvgnd_1
XFILLER_0_52_239 VPWR VGND VPWR VGND sky130_ef_sc_hd__decap_12
XFILLER_0_37_225 VPWR VGND VPWR VGND sky130_ef_sc_hd__decap_12
XFILLER_0_9_160 VGND VGND VPWR VPWR sky130_fd_sc_hd__fill_2
XFILLER_0_9_193 VPWR VGND VPWR VGND sky130_ef_sc_hd__decap_12
XscaleAdd._290_ scaleAdd._232_ scaleAdd._233_ scaleAdd._239_ net63 VGND VGND VPWR
+ VPWR scaleAdd._241_ sky130_fd_sc_hd__a2bb2o_1
XFILLER_0_68_361 VGND VGND VPWR VPWR sky130_fd_sc_hd__decap_3
XFILLER_0_43_217 VGND VGND VPWR VPWR sky130_fd_sc_hd__fill_1
XFILLER_0_22_88 VPWR VGND VPWR VGND sky130_ef_sc_hd__decap_12
XFILLER_0_11_125 VGND VGND VPWR VPWR sky130_fd_sc_hd__decap_6
XscaleAdd._488_ net17 net22 VGND VGND VPWR VPWR scaleAdd._160_ sky130_fd_sc_hd__nand2_1
XFILLER_0_63_51 VGND VGND VPWR VPWR sky130_fd_sc_hd__decap_4
Xaccumulator._1285_ accumulator._0376_ accumulator._0377_ accumulator._0382_ VGND
+ VGND VPWR VPWR accumulator._0383_ sky130_fd_sc_hd__or3_1
Xaccumulator._1354_ accumulator._0402_ accumulator._0403_ VGND VGND VPWR VPWR accumulator._0452_
+ sky130_fd_sc_hd__and2_1
Xaccumulator._1423_ accumulator._0074_ accumulator._0460_ accumulator._0464_ accumulator._0054_
+ accumulator._0520_ VGND VGND VPWR VPWR accumulator._0521_ sky130_fd_sc_hd__o221a_1
XFILLER_0_2_43 VGND VGND VPWR VPWR sky130_fd_sc_hd__fill_1
XFILLER_0_63_95 VGND VGND VPWR VPWR sky130_fd_sc_hd__decap_6
XFILLER_0_34_206 VGND VGND VPWR VPWR sky130_fd_sc_hd__decap_8
XTAP_TAPCELL_ROW_22_304 VGND VPWR sky130_fd_sc_hd__tapvpwrvgnd_1
XFILLER_0_6_141 VGND VGND VPWR VPWR sky130_fd_sc_hd__decap_4
XFILLER_0_19_225 VGND VGND VPWR VPWR sky130_fd_sc_hd__decap_4
XFILLER_0_10_191 VGND VGND VPWR VPWR sky130_fd_sc_hd__decap_4
XFILLER_0_68_29 VPWR VGND VPWR VGND sky130_ef_sc_hd__decap_12
XscaleAdd._411_ scaleAdd._262_ operator.io_outMant\[5\] scaleAdd._239_ scaleAdd._247_
+ VGND VGND VPWR VPWR scaleAdd._090_ sky130_fd_sc_hd__and4_1
XscaleAdd._342_ scaleAdd._021_ scaleAdd._022_ scaleAdd._015_ VGND VGND VPWR VPWR scaleAdd._024_
+ sky130_fd_sc_hd__a21o_1
XscaleAdd._273_ net13 net14 VGND VGND VPWR VPWR scaleAdd._226_ sky130_fd_sc_hd__nor2b_2
XFILLER_0_48_309 VGND VGND VPWR VPWR sky130_fd_sc_hd__decap_6
XFILLER_0_17_22 VGND VGND VPWR VPWR sky130_fd_sc_hd__decap_8
XFILLER_0_56_386 VGND VGND VPWR VPWR sky130_fd_sc_hd__decap_3
XFILLER_0_56_353 VGND VGND VPWR VPWR sky130_fd_sc_hd__decap_4
XFILLER_0_33_76 VGND VGND VPWR VPWR sky130_fd_sc_hd__decap_8
Xoperator._090_ operator._021_ operator._026_ VGND VGND VPWR VPWR operator._028_ sky130_fd_sc_hd__or2_1
Xaccumulator._1972_ accumulator._0851_ accumulator._0902_ VGND VGND VPWR VPWR accumulator._1070_
+ sky130_fd_sc_hd__nand2_1
XFILLER_0_3_177 VGND VGND VPWR VPWR sky130_fd_sc_hd__fill_2
XFILLER_0_3_155 VGND VGND VPWR VPWR sky130_fd_sc_hd__fill_1
XFILLER_0_12_401 VGND VGND VPWR VPWR sky130_fd_sc_hd__decap_4
XFILLER_0_58_73 VGND VGND VPWR VPWR sky130_fd_sc_hd__decap_8
XFILLER_0_35_3 VPWR VGND VPWR VGND sky130_ef_sc_hd__decap_12
XFILLER_0_66_139 VGND VGND VPWR VPWR sky130_fd_sc_hd__fill_1
Xaccumulator._1268_ accumulator._0365_ VGND VGND VPWR VPWR accumulator._0366_ sky130_fd_sc_hd__buf_2
Xaccumulator._1406_ accumulator._0306_ accumulator._0273_ accumulator._0476_ VGND
+ VGND VPWR VPWR accumulator._0504_ sky130_fd_sc_hd__and3_1
Xaccumulator._1337_ net76 accumulator._0378_ VGND VGND VPWR VPWR accumulator._0435_
+ sky130_fd_sc_hd__xor2_2
XFILLER_0_62_345 VGND VGND VPWR VPWR sky130_fd_sc_hd__fill_2
XTAP_TAPCELL_ROW_50_498 VGND VPWR sky130_fd_sc_hd__tapvpwrvgnd_1
XFILLER_0_22_209 VGND VGND VPWR VPWR sky130_fd_sc_hd__fill_1
Xaccumulator._1199_ accumulator._0297_ accumulator._0298_ VGND VGND VPWR VPWR accumulator._0299_
+ sky130_fd_sc_hd__or2_1
XFILLER_0_30_253 VGND VGND VPWR VPWR sky130_fd_sc_hd__decap_3
XTAP_TAPCELL_ROW_58_554 VGND VPWR sky130_fd_sc_hd__tapvpwrvgnd_1
XTAP_TAPCELL_ROW_7_198 VGND VPWR sky130_fd_sc_hd__tapvpwrvgnd_1
XTAP_TAPCELL_ROW_41_432 VGND VPWR sky130_fd_sc_hd__tapvpwrvgnd_1
XFILLER_0_38_331 VGND VGND VPWR VPWR sky130_fd_sc_hd__decap_8
XFILLER_0_53_334 VGND VGND VPWR VPWR sky130_fd_sc_hd__fill_2
XFILLER_0_0_103 VGND VGND VPWR VPWR sky130_fd_sc_hd__decap_8
XFILLER_0_0_125 VGND VGND VPWR VPWR sky130_fd_sc_hd__decap_8
XFILLER_0_28_76 VGND VGND VPWR VPWR sky130_fd_sc_hd__decap_8
XFILLER_0_28_54 VPWR VGND VPWR VGND sky130_ef_sc_hd__decap_12
XFILLER_0_0_169 VPWR VGND VPWR VGND sky130_ef_sc_hd__decap_12
XscaleAdd._325_ scaleAdd._261_ scaleAdd._007_ VGND VGND VPWR VPWR scaleAdd._008_ sky130_fd_sc_hd__xor2_1
XFILLER_0_44_53 VGND VGND VPWR VPWR sky130_fd_sc_hd__decap_3
Xaccumulator._2171_ accumulator._1139_ accumulator._0154_ accumulator.io_accOut\[16\]
+ accumulator._0350_ VGND VGND VPWR VPWR accumulator._0155_ sky130_fd_sc_hd__a2bb2o_1
Xaccumulator._2240_ accumulator._0221_ accumulator._0220_ VGND VGND VPWR VPWR accumulator._0222_
+ sky130_fd_sc_hd__nor2_1
XFILLER_0_63_109 VGND VGND VPWR VPWR sky130_fd_sc_hd__decap_3
XFILLER_0_60_85 VGND VGND VPWR VPWR sky130_fd_sc_hd__decap_4
XFILLER_0_60_41 VPWR VGND VPWR VGND sky130_ef_sc_hd__decap_12
XFILLER_0_29_386 VGND VGND VPWR VPWR sky130_fd_sc_hd__decap_6
Xoperator._073_ operator._014_ VGND VGND VPWR VPWR operator.io_outExp\[3\] sky130_fd_sc_hd__clkbuf_1
Xaccumulator._1886_ accumulator._0926_ accumulator._0983_ VGND VGND VPWR VPWR accumulator._0984_
+ sky130_fd_sc_hd__or2b_4
Xaccumulator._1955_ accumulator._0953_ accumulator._0957_ accumulator._0942_ VGND
+ VGND VPWR VPWR accumulator._1053_ sky130_fd_sc_hd__or3_1
XFILLER_0_8_64 VGND VGND VPWR VPWR sky130_fd_sc_hd__decap_8
XFILLER_0_8_97 VPWR VGND VPWR VGND sky130_ef_sc_hd__decap_12
XFILLER_0_12_286 VPWR VGND VPWR VGND sky130_ef_sc_hd__decap_12
XTAP_TAPCELL_ROW_4_179 VGND VPWR sky130_fd_sc_hd__tapvpwrvgnd_1
XTAP_TAPCELL_ROW_63_590 VGND VPWR sky130_fd_sc_hd__tapvpwrvgnd_1
XTAP_TAPCELL_ROW_55_535 VGND VPWR sky130_fd_sc_hd__tapvpwrvgnd_1
XFILLER_0_47_161 VGND VGND VPWR VPWR sky130_fd_sc_hd__decap_6
XFILLER_0_62_164 VGND VGND VPWR VPWR sky130_fd_sc_hd__fill_1
XFILLER_0_35_378 VGND VGND VPWR VPWR sky130_fd_sc_hd__fill_1
XFILLER_0_53_164 VGND VGND VPWR VPWR sky130_fd_sc_hd__decap_4
XFILLER_0_5_206 VPWR VGND VPWR VGND sky130_ef_sc_hd__decap_12
Xaccumulator._1740_ accumulator._0512_ accumulator._0664_ accumulator._0837_ VGND
+ VGND VPWR VPWR accumulator._0838_ sky130_fd_sc_hd__a21o_1
XFILLER_0_41_337 VPWR VGND VPWR VGND sky130_ef_sc_hd__decap_12
XFILLER_0_41_326 VGND VGND VPWR VPWR sky130_fd_sc_hd__decap_8
Xaccumulator._1671_ accumulator.io_accOut\[16\] accumulator._0525_ accumulator._0355_
+ VGND VGND VPWR VPWR accumulator._0769_ sky130_fd_sc_hd__mux2_1
XFILLER_0_39_75 VGND VGND VPWR VPWR sky130_fd_sc_hd__decap_3
XFILLER_0_55_74 VGND VGND VPWR VPWR sky130_fd_sc_hd__fill_1
XscaleAdd._308_ scaleAdd._249_ scaleAdd._257_ VGND VGND VPWR VPWR scaleAdd._258_ sky130_fd_sc_hd__xnor2_1
Xaccumulator._2085_ accumulator._1055_ accumulator._1052_ accumulator._1124_ VGND
+ VGND VPWR VPWR accumulator._0071_ sky130_fd_sc_hd__mux2_4
Xaccumulator._2154_ accumulator.io_accOut\[13\] accumulator._0120_ accumulator._0131_
+ accumulator._0138_ accumulator._0092_ VGND VGND VPWR VPWR accumulator._0015_ sky130_fd_sc_hd__o221a_1
Xaccumulator._2223_ accumulator.io_accOut\[23\] accumulator._0204_ accumulator._0356_
+ VGND VGND VPWR VPWR accumulator._0205_ sky130_fd_sc_hd__mux2_1
XFILLER_0_17_312 VGND VGND VPWR VPWR sky130_fd_sc_hd__fill_1
XTAP_TAPCELL_ROW_17_270 VGND VPWR sky130_fd_sc_hd__tapvpwrvgnd_1
XTAP_TAPCELL_ROW_60_571 VGND VPWR sky130_fd_sc_hd__tapvpwrvgnd_1
Xoperator._056_ operator._000_ VGND VGND VPWR VPWR operator.io_outMant\[0\] sky130_fd_sc_hd__buf_1
Xaccumulator._1869_ accumulator._0717_ accumulator._0723_ accumulator._0816_ accumulator._0725_
+ VGND VGND VPWR VPWR accumulator._0967_ sky130_fd_sc_hd__a211o_1
Xaccumulator._1938_ accumulator._0918_ accumulator._1035_ VGND VGND VPWR VPWR accumulator._1036_
+ sky130_fd_sc_hd__xnor2_2
XFILLER_0_23_315 VGND VGND VPWR VPWR sky130_fd_sc_hd__decap_6
XFILLER_0_50_156 VGND VGND VPWR VPWR sky130_fd_sc_hd__fill_2
XFILLER_0_31_370 VGND VGND VPWR VPWR sky130_fd_sc_hd__decap_8
XTAP_TAPCELL_ROW_66_608 VGND VPWR sky130_fd_sc_hd__tapvpwrvgnd_1
XFILLER_0_25_55 VGND VGND VPWR VPWR sky130_fd_sc_hd__fill_1
XFILLER_0_41_167 VGND VGND VPWR VPWR sky130_fd_sc_hd__fill_1
XFILLER_0_41_43 VGND VGND VPWR VPWR sky130_fd_sc_hd__fill_1
XFILLER_0_26_197 VPWR VGND VPWR VGND sky130_ef_sc_hd__decap_12
XFILLER_0_26_175 VGND VGND VPWR VPWR sky130_fd_sc_hd__fill_1
Xaccumulator._1654_ accumulator._0750_ accumulator._0751_ VGND VGND VPWR VPWR accumulator._0752_
+ sky130_fd_sc_hd__nand2b_2
Xaccumulator._1723_ accumulator._0733_ accumulator._0735_ VGND VGND VPWR VPWR accumulator._0821_
+ sky130_fd_sc_hd__or2_1
XFILLER_0_5_32 VGND VGND VPWR VPWR sky130_fd_sc_hd__fill_2
XFILLER_0_1_275 VGND VGND VPWR VPWR sky130_fd_sc_hd__decap_4
Xaccumulator._1585_ accumulator._0394_ accumulator._0676_ accumulator._0677_ accumulator._0682_
+ accumulator._0389_ VGND VGND VPWR VPWR accumulator._0683_ sky130_fd_sc_hd__a311o_1
XFILLER_0_49_223 VGND VGND VPWR VPWR sky130_fd_sc_hd__fill_1
Xaccumulator._2206_ accumulator._1031_ accumulator._0186_ accumulator._0188_ VGND
+ VGND VPWR VPWR accumulator._0189_ sky130_fd_sc_hd__or3_1
Xaccumulator._2068_ accumulator.io_accOut\[3\] accumulator._0364_ accumulator._1032_
+ accumulator._0053_ VGND VGND VPWR VPWR accumulator._0055_ sky130_fd_sc_hd__o2bb2a_1
Xaccumulator._2137_ accumulator._0059_ accumulator._0057_ VGND VGND VPWR VPWR accumulator._0121_
+ sky130_fd_sc_hd__and2b_1
XFILLER_0_17_131 VGND VGND VPWR VPWR sky130_fd_sc_hd__fill_1
XFILLER_0_32_112 VGND VGND VPWR VPWR sky130_fd_sc_hd__decap_4
Xoperator._108_ operator._031_ operator._033_ VGND VGND VPWR VPWR operator._044_ sky130_fd_sc_hd__or2_1
XTAP_TAPCELL_ROW_20_287 VGND VPWR sky130_fd_sc_hd__tapvpwrvgnd_1
XFILLER_0_20_307 VGND VGND VPWR VPWR sky130_fd_sc_hd__fill_1
XTAP_TAPCELL_ROW_28_343 VGND VPWR sky130_fd_sc_hd__tapvpwrvgnd_1
XFILLER_0_63_281 VGND VGND VPWR VPWR sky130_fd_sc_hd__decap_8
XFILLER_0_23_101 VGND VGND VPWR VPWR sky130_fd_sc_hd__decap_6
XFILLER_0_11_57 VGND VGND VPWR VPWR sky130_fd_sc_hd__decap_4
XFILLER_0_11_68 VGND VGND VPWR VPWR sky130_fd_sc_hd__decap_3
XFILLER_0_11_329 VGND VGND VPWR VPWR sky130_fd_sc_hd__decap_6
Xinput6 io_inA[5] VGND VGND VPWR VPWR net6 sky130_fd_sc_hd__buf_1
Xaccumulator._1370_ accumulator._0285_ accumulator._0461_ accumulator._0464_ accumulator._0429_
+ accumulator._0467_ VGND VGND VPWR VPWR accumulator._0468_ sky130_fd_sc_hd__a221o_1
XFILLER_0_52_53 VGND VGND VPWR VPWR sky130_fd_sc_hd__decap_4
XFILLER_0_65_3 VPWR VGND VPWR VGND sky130_ef_sc_hd__decap_12
XFILLER_0_6_345 VPWR VGND VPWR VGND sky130_ef_sc_hd__decap_12
XFILLER_0_6_389 VPWR VGND VPWR VGND sky130_ef_sc_hd__decap_12
Xaccumulator._1568_ accumulator._0450_ accumulator._0664_ accumulator._0665_ accumulator._0394_
+ VGND VGND VPWR VPWR accumulator._0666_ sky130_fd_sc_hd__a211o_1
Xaccumulator._1706_ accumulator._0802_ accumulator._0803_ VGND VGND VPWR VPWR accumulator._0804_
+ sky130_fd_sc_hd__nor2_1
Xaccumulator._1637_ accumulator.io_accOut\[12\] accumulator._0355_ accumulator._0734_
+ VGND VGND VPWR VPWR accumulator._0735_ sky130_fd_sc_hd__o21ai_2
XFILLER_0_37_204 VPWR VGND VPWR VGND sky130_ef_sc_hd__decap_12
Xaccumulator._1499_ accumulator._0593_ accumulator._0594_ accumulator._0595_ accumulator._0413_
+ accumulator._0596_ VGND VGND VPWR VPWR accumulator._0597_ sky130_fd_sc_hd__a221o_1
XTAP_TAPCELL_ROW_25_324 VGND VPWR sky130_fd_sc_hd__tapvpwrvgnd_1
XFILLER_0_37_237 VGND VGND VPWR VPWR sky130_fd_sc_hd__decap_4
XPHY_EDGE_ROW_14_Right_14 VGND VGND VPWR VPWR sky130_fd_sc_hd__decap_3
XPHY_EDGE_ROW_23_Right_23 VGND VGND VPWR VPWR sky130_fd_sc_hd__decap_3
XFILLER_0_20_137 VGND VGND VPWR VPWR sky130_fd_sc_hd__decap_3
XFILLER_0_20_148 VGND VGND VPWR VPWR sky130_fd_sc_hd__fill_1
XPHY_EDGE_ROW_32_Right_32 VGND VGND VPWR VPWR sky130_fd_sc_hd__decap_3
XFILLER_0_28_204 VGND VGND VPWR VPWR sky130_fd_sc_hd__fill_1
XFILLER_0_22_56 VGND VGND VPWR VPWR sky130_fd_sc_hd__fill_1
XFILLER_0_36_292 VGND VGND VPWR VPWR sky130_fd_sc_hd__fill_1
XscaleAdd._556_ operator.io_outSign VGND VGND VPWR VPWR accumulator.io_inSign sky130_fd_sc_hd__buf_2
XFILLER_0_3_337 VPWR VGND VPWR VGND sky130_ef_sc_hd__decap_12
XPHY_EDGE_ROW_41_Right_41 VGND VGND VPWR VPWR sky130_fd_sc_hd__decap_3
Xaccumulator._1422_ accumulator._0285_ accumulator._0519_ VGND VGND VPWR VPWR accumulator._0520_
+ sky130_fd_sc_hd__nand2_1
XscaleAdd._487_ net17 net22 VGND VGND VPWR VPWR scaleAdd._159_ sky130_fd_sc_hd__or2_1
XFILLER_0_59_351 VGND VGND VPWR VPWR sky130_fd_sc_hd__decap_8
XPHY_EDGE_ROW_50_Right_50 VGND VGND VPWR VPWR sky130_fd_sc_hd__decap_3
Xaccumulator._1284_ accumulator._0378_ accumulator._0381_ VGND VGND VPWR VPWR accumulator._0382_
+ sky130_fd_sc_hd__or2_4
Xaccumulator._1353_ accumulator._0402_ VGND VGND VPWR VPWR accumulator._0451_ sky130_fd_sc_hd__inv_2
XFILLER_0_2_66 VGND VGND VPWR VPWR sky130_fd_sc_hd__fill_1
XTAP_TAPCELL_ROW_30_360 VGND VPWR sky130_fd_sc_hd__tapvpwrvgnd_1
XTAP_TAPCELL_ROW_22_305 VGND VPWR sky130_fd_sc_hd__tapvpwrvgnd_1
XFILLER_0_42_295 VGND VGND VPWR VPWR sky130_fd_sc_hd__fill_2
XFILLER_0_42_262 VGND VGND VPWR VPWR sky130_fd_sc_hd__decap_8
XFILLER_0_42_251 VGND VGND VPWR VPWR sky130_fd_sc_hd__fill_1
XFILLER_0_6_197 VPWR VGND VPWR VGND sky130_ef_sc_hd__decap_12
XFILLER_0_65_310 VGND VGND VPWR VPWR sky130_fd_sc_hd__fill_1
XscaleAdd._410_ operator.io_outMant\[4\] scaleAdd._009_ VGND VGND VPWR VPWR scaleAdd._089_
+ sky130_fd_sc_hd__nand2_1
XscaleAdd._341_ scaleAdd._015_ scaleAdd._021_ scaleAdd._022_ VGND VGND VPWR VPWR scaleAdd._023_
+ sky130_fd_sc_hd__nand3_1
XscaleAdd._272_ scaleAdd._221_ operator.io_outMant\[3\] net63 scaleAdd._224_ VGND
+ VGND VPWR VPWR scaleAdd._225_ sky130_fd_sc_hd__and4_1
XFILLER_0_68_181 VPWR VGND VPWR VGND sky130_ef_sc_hd__decap_12
XFILLER_0_56_398 VGND VGND VPWR VPWR sky130_fd_sc_hd__decap_6
XFILLER_0_56_365 VGND VGND VPWR VPWR sky130_fd_sc_hd__decap_4
Xinput20 io_inScaleA[7] VGND VGND VPWR VPWR net20 sky130_fd_sc_hd__buf_1
XPHY_EDGE_ROW_26_Left_95 VGND VGND VPWR VPWR sky130_fd_sc_hd__decap_3
XFILLER_0_58_41 VPWR VGND VPWR VGND sky130_ef_sc_hd__decap_12
Xaccumulator._1971_ accumulator._1067_ accumulator._1068_ accumulator._0902_ VGND
+ VGND VPWR VPWR accumulator._1069_ sky130_fd_sc_hd__mux2_4
XscaleAdd._539_ scaleAdd._206_ scaleAdd._207_ VGND VGND VPWR VPWR scaleAdd._208_ sky130_fd_sc_hd__nand2_1
XFILLER_0_3_167 VGND VGND VPWR VPWR sky130_fd_sc_hd__fill_1
XPHY_EDGE_ROW_10_Left_79 VGND VGND VPWR VPWR sky130_fd_sc_hd__decap_3
XFILLER_0_58_85 VGND VGND VPWR VPWR sky130_fd_sc_hd__decap_4
Xaccumulator._1405_ accumulator._0498_ accumulator._0501_ accumulator._0502_ VGND
+ VGND VPWR VPWR accumulator._0503_ sky130_fd_sc_hd__a21o_1
XFILLER_0_28_3 VPWR VGND VPWR VGND sky130_ef_sc_hd__decap_12
XFILLER_0_59_192 VGND VGND VPWR VPWR sky130_fd_sc_hd__decap_6
Xaccumulator._1267_ accumulator.io_accOut\[31\] accumulator.io_inSign VGND VGND VPWR
+ VPWR accumulator._0365_ sky130_fd_sc_hd__xnor2_4
Xaccumulator._1336_ accumulator._0413_ net73 accumulator._0406_ accumulator._0433_
+ VGND VGND VPWR VPWR accumulator._0434_ sky130_fd_sc_hd__o31a_4
Xaccumulator._1198_ net69 accumulator._0289_ VGND VGND VPWR VPWR accumulator._0298_
+ sky130_fd_sc_hd__xnor2_2
XTAP_TAPCELL_ROW_50_499 VGND VPWR sky130_fd_sc_hd__tapvpwrvgnd_1
XFILLER_0_15_273 VGND VGND VPWR VPWR sky130_fd_sc_hd__decap_6
XTAP_TAPCELL_ROW_7_199 VGND VPWR sky130_fd_sc_hd__tapvpwrvgnd_1
XTAP_TAPCELL_ROW_58_555 VGND VPWR sky130_fd_sc_hd__tapvpwrvgnd_1
XTAP_TAPCELL_ROW_41_433 VGND VPWR sky130_fd_sc_hd__tapvpwrvgnd_1
XFILLER_0_21_221 VGND VGND VPWR VPWR sky130_fd_sc_hd__decap_3
XFILLER_0_28_66 VGND VGND VPWR VPWR sky130_fd_sc_hd__decap_3
XscaleAdd._324_ scaleAdd._005_ scaleAdd._006_ VGND VGND VPWR VPWR scaleAdd._007_ sky130_fd_sc_hd__or2_1
XFILLER_0_44_76 VGND VGND VPWR VPWR sky130_fd_sc_hd__decap_8
Xaccumulator._2170_ accumulator._0357_ accumulator._0121_ VGND VGND VPWR VPWR accumulator._0154_
+ sky130_fd_sc_hd__nand2_1
Xaccumulator._1954_ accumulator._1051_ VGND VGND VPWR VPWR accumulator._1052_ sky130_fd_sc_hd__inv_2
XFILLER_0_60_53 VGND VGND VPWR VPWR sky130_fd_sc_hd__fill_1
XFILLER_0_29_365 VGND VGND VPWR VPWR sky130_fd_sc_hd__decap_3
Xoperator._072_ operator.io_outExp\[1\] operator._010_ VGND VGND VPWR VPWR operator._014_
+ sky130_fd_sc_hd__and2_1
Xaccumulator._1885_ accumulator._0977_ accumulator._0972_ accumulator._0966_ accumulator._0982_
+ VGND VGND VPWR VPWR accumulator._0983_ sky130_fd_sc_hd__nor4b_4
XPHY_EDGE_ROW_4_Right_4 VGND VGND VPWR VPWR sky130_fd_sc_hd__decap_3
XFILLER_0_12_298 VGND VGND VPWR VPWR sky130_fd_sc_hd__decap_8
XFILLER_0_67_405 VGND VGND VPWR VPWR sky130_fd_sc_hd__decap_4
XTAP_TAPCELL_ROW_55_536 VGND VPWR sky130_fd_sc_hd__tapvpwrvgnd_1
XTAP_TAPCELL_ROW_63_591 VGND VPWR sky130_fd_sc_hd__tapvpwrvgnd_1
XFILLER_0_47_184 VPWR VGND VPWR VGND sky130_ef_sc_hd__decap_12
XFILLER_0_35_346 VGND VGND VPWR VPWR sky130_fd_sc_hd__fill_2
XFILLER_0_35_335 VGND VGND VPWR VPWR sky130_fd_sc_hd__fill_1
Xaccumulator._2299_ clknet_2_2__leaf_clock accumulator._0006_ VGND VGND VPWR VPWR
+ accumulator.io_accOut\[4\] sky130_fd_sc_hd__dfxtp_1
Xaccumulator._1319_ accumulator.io_inMant\[14\] accumulator.io_inMant\[12\] accumulator.io_inMant\[13\]
+ VGND VGND VPWR VPWR accumulator._0417_ sky130_fd_sc_hd__o21a_1
XFILLER_0_50_316 VPWR VGND VPWR VGND sky130_ef_sc_hd__decap_12
XFILLER_0_7_281 VPWR VGND VPWR VGND sky130_ef_sc_hd__decap_12
XFILLER_0_41_349 VPWR VGND VPWR VGND sky130_ef_sc_hd__decap_12
XFILLER_0_38_195 VGND VGND VPWR VPWR sky130_fd_sc_hd__fill_1
XFILLER_0_5_218 VGND VGND VPWR VPWR sky130_fd_sc_hd__fill_1
Xaccumulator._1670_ accumulator._0390_ accumulator._0396_ accumulator._0710_ VGND
+ VGND VPWR VPWR accumulator._0768_ sky130_fd_sc_hd__or3b_1
XFILLER_0_39_98 VGND VGND VPWR VPWR sky130_fd_sc_hd__fill_1
XscaleAdd._307_ scaleAdd._232_ scaleAdd._256_ VGND VGND VPWR VPWR scaleAdd._257_ sky130_fd_sc_hd__xnor2_1
Xaccumulator._2222_ accumulator._0379_ VGND VGND VPWR VPWR accumulator._0204_ sky130_fd_sc_hd__inv_2
XFILLER_0_44_121 VPWR VGND VPWR VGND sky130_ef_sc_hd__decap_12
Xaccumulator._2084_ accumulator._1142_ accumulator._1138_ VGND VGND VPWR VPWR accumulator._0070_
+ sky130_fd_sc_hd__or2b_4
Xaccumulator._2153_ accumulator._0133_ accumulator._0137_ accumulator._0061_ VGND
+ VGND VPWR VPWR accumulator._0138_ sky130_fd_sc_hd__mux2_1
Xaccumulator._1937_ accumulator._1014_ accumulator._0988_ VGND VGND VPWR VPWR accumulator._1035_
+ sky130_fd_sc_hd__nor2_1
XFILLER_0_4_251 VGND VGND VPWR VPWR sky130_fd_sc_hd__fill_1
Xoperator._055_ net7 net1 VGND VGND VPWR VPWR operator._000_ sky130_fd_sc_hd__and2_1
Xaccumulator._1868_ accumulator._0933_ accumulator._0937_ accumulator._0965_ VGND
+ VGND VPWR VPWR accumulator._0966_ sky130_fd_sc_hd__or3b_4
Xaccumulator._1799_ accumulator._0807_ accumulator._0896_ accumulator._0809_ VGND
+ VGND VPWR VPWR accumulator._0897_ sky130_fd_sc_hd__a21o_1
XPHY_EDGE_ROW_13_Left_82 VGND VGND VPWR VPWR sky130_fd_sc_hd__decap_3
XFILLER_0_67_246 VGND VGND VPWR VPWR sky130_fd_sc_hd__fill_1
XTAP_TAPCELL_ROW_0_150 VGND VPWR sky130_fd_sc_hd__tapvpwrvgnd_1
XFILLER_0_50_113 VGND VGND VPWR VPWR sky130_fd_sc_hd__decap_8
XFILLER_0_31_393 VGND VGND VPWR VPWR sky130_fd_sc_hd__decap_8
XTAP_TAPCELL_ROW_66_609 VGND VPWR sky130_fd_sc_hd__tapvpwrvgnd_1
XFILLER_0_58_279 VGND VGND VPWR VPWR sky130_fd_sc_hd__decap_8
XFILLER_0_26_121 VPWR VGND VPWR VGND sky130_ef_sc_hd__decap_12
XFILLER_0_41_157 VGND VGND VPWR VPWR sky130_fd_sc_hd__decap_4
XFILLER_0_41_77 VPWR VGND VPWR VGND sky130_ef_sc_hd__decap_12
XFILLER_0_66_85 VPWR VGND VPWR VGND sky130_ef_sc_hd__decap_12
XFILLER_0_66_41 VPWR VGND VPWR VGND sky130_ef_sc_hd__decap_12
Xaccumulator._1722_ accumulator._0724_ accumulator._0728_ VGND VGND VPWR VPWR accumulator._0820_
+ sky130_fd_sc_hd__nand2_1
Xaccumulator._1653_ accumulator._0534_ accumulator._0749_ accumulator._0747_ VGND
+ VGND VPWR VPWR accumulator._0751_ sky130_fd_sc_hd__a21bo_1
Xaccumulator._1584_ accumulator._0493_ accumulator._0680_ accumulator._0681_ accumulator._0394_
+ VGND VGND VPWR VPWR accumulator._0682_ sky130_fd_sc_hd__a211oi_1
Xaccumulator._2205_ accumulator._0187_ accumulator._0169_ accumulator._0047_ VGND
+ VGND VPWR VPWR accumulator._0188_ sky130_fd_sc_hd__mux2_1
XFILLER_0_49_257 VPWR VGND VPWR VGND sky130_ef_sc_hd__decap_12
Xaccumulator._2067_ accumulator._0046_ accumulator._0049_ accumulator._0052_ VGND
+ VGND VPWR VPWR accumulator._0053_ sky130_fd_sc_hd__o21ai_2
Xoperator._107_ operator._041_ operator._042_ VGND VGND VPWR VPWR operator._043_ sky130_fd_sc_hd__nand2_1
XFILLER_0_17_110 VGND VGND VPWR VPWR sky130_fd_sc_hd__fill_2
XFILLER_0_17_165 VGND VGND VPWR VPWR sky130_fd_sc_hd__decap_3
Xaccumulator._2136_ accumulator._0358_ VGND VGND VPWR VPWR accumulator._0120_ sky130_fd_sc_hd__clkbuf_4
XFILLER_0_13_393 VPWR VGND VPWR VGND sky130_ef_sc_hd__decap_12
XTAP_TAPCELL_ROW_20_288 VGND VPWR sky130_fd_sc_hd__tapvpwrvgnd_1
XTAP_TAPCELL_ROW_28_344 VGND VPWR sky130_fd_sc_hd__tapvpwrvgnd_1
XFILLER_0_23_146 VGND VGND VPWR VPWR sky130_fd_sc_hd__decap_6
XTAP_TAPCELL_ROW_11_222 VGND VPWR sky130_fd_sc_hd__tapvpwrvgnd_1
XFILLER_0_36_55 VGND VGND VPWR VPWR sky130_fd_sc_hd__decap_6
Xinput7 io_inB[0] VGND VGND VPWR VPWR net7 sky130_fd_sc_hd__buf_1
XFILLER_0_46_249 VGND VGND VPWR VPWR sky130_fd_sc_hd__decap_3
XFILLER_0_46_238 VGND VGND VPWR VPWR sky130_fd_sc_hd__decap_3
XFILLER_0_6_357 VGND VGND VPWR VPWR sky130_fd_sc_hd__decap_6
XFILLER_0_14_102 VPWR VGND VPWR VGND sky130_ef_sc_hd__decap_12
XFILLER_0_58_3 VPWR VGND VPWR VGND sky130_ef_sc_hd__decap_12
Xaccumulator._1705_ accumulator.io_accOut\[20\] accumulator._0480_ accumulator._0356_
+ VGND VGND VPWR VPWR accumulator._0803_ sky130_fd_sc_hd__mux2_1
XFILLER_0_10_363 VGND VGND VPWR VPWR sky130_fd_sc_hd__fill_1
Xaccumulator._1567_ accumulator._0493_ accumulator._0618_ VGND VGND VPWR VPWR accumulator._0665_
+ sky130_fd_sc_hd__nor2_1
Xaccumulator._1636_ accumulator._0348_ accumulator._0504_ VGND VGND VPWR VPWR accumulator._0734_
+ sky130_fd_sc_hd__or2_1
XFILLER_0_37_216 VGND VGND VPWR VPWR sky130_fd_sc_hd__decap_8
Xaccumulator._1498_ accumulator.io_accOut\[6\] accumulator._0354_ accumulator._0381_
+ accumulator._0575_ VGND VGND VPWR VPWR accumulator._0596_ sky130_fd_sc_hd__and4_1
Xaccumulator._2119_ accumulator._0036_ accumulator._0089_ accumulator._0102_ accumulator._1032_
+ accumulator._0104_ VGND VGND VPWR VPWR accumulator._0105_ sky130_fd_sc_hd__o221a_1
XTAP_TAPCELL_ROW_25_325 VGND VPWR sky130_fd_sc_hd__tapvpwrvgnd_1
XTAP_TAPCELL_ROW_33_380 VGND VPWR sky130_fd_sc_hd__tapvpwrvgnd_1
XFILLER_0_60_285 VGND VGND VPWR VPWR sky130_fd_sc_hd__fill_2
XPHY_EDGE_ROW_38_Left_107 VGND VGND VPWR VPWR sky130_fd_sc_hd__decap_3
XFILLER_0_28_238 VPWR VGND VPWR VGND sky130_ef_sc_hd__decap_12
XFILLER_0_28_227 VGND VGND VPWR VPWR sky130_fd_sc_hd__fill_2
XFILLER_0_51_241 VPWR VGND VPWR VGND sky130_ef_sc_hd__decap_12
XPHY_EDGE_ROW_47_Left_116 VGND VGND VPWR VPWR sky130_fd_sc_hd__decap_3
XFILLER_0_36_282 VGND VGND VPWR VPWR sky130_fd_sc_hd__decap_6
XFILLER_0_3_349 VPWR VGND VPWR VGND sky130_ef_sc_hd__decap_12
XFILLER_0_3_305 VPWR VGND VPWR VGND sky130_ef_sc_hd__decap_12
XscaleAdd._486_ scaleAdd._158_ VGND VGND VPWR VPWR accumulator.io_inExp\[0\] sky130_fd_sc_hd__buf_1
XscaleAdd._555_ accumulator.io_inExp\[8\] VGND VGND VPWR VPWR accumulator.io_inExp\[7\]
+ sky130_fd_sc_hd__buf_1
Xaccumulator._1421_ accumulator._0273_ accumulator._0457_ VGND VGND VPWR VPWR accumulator._0519_
+ sky130_fd_sc_hd__nand2_1
XPHY_EDGE_ROW_56_Left_125 VGND VGND VPWR VPWR sky130_fd_sc_hd__decap_3
Xaccumulator._1352_ accumulator._0449_ VGND VGND VPWR VPWR accumulator._0450_ sky130_fd_sc_hd__clkbuf_4
Xaccumulator._1283_ net75 accumulator._0380_ VGND VGND VPWR VPWR accumulator._0381_
+ sky130_fd_sc_hd__nand2_4
XPHY_EDGE_ROW_65_Left_134 VGND VGND VPWR VPWR sky130_fd_sc_hd__decap_3
XFILLER_0_30_403 VGND VGND VPWR VPWR sky130_fd_sc_hd__fill_2
XTAP_TAPCELL_ROW_30_361 VGND VPWR sky130_fd_sc_hd__tapvpwrvgnd_1
Xaccumulator._1619_ accumulator._0585_ accumulator._0709_ accumulator._0715_ accumulator._0716_
+ VGND VGND VPWR VPWR accumulator._0717_ sky130_fd_sc_hd__o211ai_2
XFILLER_0_65_333 VGND VGND VPWR VPWR sky130_fd_sc_hd__decap_3
XscaleAdd._340_ scaleAdd._018_ scaleAdd._019_ scaleAdd._020_ VGND VGND VPWR VPWR scaleAdd._022_
+ sky130_fd_sc_hd__a21o_1
XscaleAdd._271_ scaleAdd._222_ scaleAdd._223_ VGND VGND VPWR VPWR scaleAdd._224_ sky130_fd_sc_hd__or2_4
XFILLER_0_17_35 VGND VGND VPWR VPWR sky130_fd_sc_hd__fill_2
XTAP_TAPCELL_ROW_44_453 VGND VPWR sky130_fd_sc_hd__tapvpwrvgnd_1
XPHY_EDGE_ROW_1_Left_70 VGND VGND VPWR VPWR sky130_fd_sc_hd__decap_3
XFILLER_0_68_193 VGND VGND VPWR VPWR sky130_fd_sc_hd__decap_3
Xaccumulator._1970_ accumulator._1065_ accumulator._1067_ accumulator._1060_ VGND
+ VGND VPWR VPWR accumulator._1068_ sky130_fd_sc_hd__o21bai_1
XFILLER_0_3_113 VPWR VGND VPWR VGND sky130_ef_sc_hd__decap_12
Xinput10 io_inB[3] VGND VGND VPWR VPWR net10 sky130_fd_sc_hd__buf_4
Xinput21 io_inScaleB[3] VGND VGND VPWR VPWR net21 sky130_fd_sc_hd__buf_1
XFILLER_0_58_53 VGND VGND VPWR VPWR sky130_fd_sc_hd__decap_6
XscaleAdd._538_ operator.io_outExp\[4\] scaleAdd._205_ VGND VGND VPWR VPWR scaleAdd._207_
+ sky130_fd_sc_hd__nand2_1
XscaleAdd._469_ scaleAdd._143_ scaleAdd._145_ VGND VGND VPWR VPWR scaleAdd._146_ sky130_fd_sc_hd__and2_4
Xaccumulator._1404_ accumulator._0472_ VGND VGND VPWR VPWR accumulator._0502_ sky130_fd_sc_hd__buf_2
Xaccumulator._1335_ accumulator._0381_ accumulator._0405_ accumulator._0432_ VGND
+ VGND VPWR VPWR accumulator._0433_ sky130_fd_sc_hd__or3b_4
Xaccumulator._1266_ accumulator._0350_ VGND VGND VPWR VPWR accumulator._0364_ sky130_fd_sc_hd__clkbuf_2
Xaccumulator._1197_ accumulator._0296_ accumulator._0294_ VGND VGND VPWR VPWR accumulator._0297_
+ sky130_fd_sc_hd__xnor2_4
XFILLER_0_30_244 VGND VGND VPWR VPWR sky130_fd_sc_hd__decap_4
XFILLER_0_30_211 VPWR VGND VPWR VGND sky130_ef_sc_hd__decap_12
XFILLER_0_30_277 VGND VGND VPWR VPWR sky130_fd_sc_hd__fill_1
XTAP_TAPCELL_ROW_58_556 VGND VPWR sky130_fd_sc_hd__tapvpwrvgnd_1
XFILLER_0_65_130 VPWR VGND VPWR VGND sky130_ef_sc_hd__decap_12
XTAP_TAPCELL_ROW_41_434 VGND VPWR sky130_fd_sc_hd__tapvpwrvgnd_1
XFILLER_0_38_388 VGND VGND VPWR VPWR sky130_fd_sc_hd__decap_4
XFILLER_0_61_391 VGND VGND VPWR VPWR sky130_fd_sc_hd__fill_1
XscaleAdd._323_ scaleAdd._251_ scaleAdd._255_ scaleAdd._004_ VGND VGND VPWR VPWR scaleAdd._006_
+ sky130_fd_sc_hd__nor3_1
XFILLER_0_21_277 VGND VGND VPWR VPWR sky130_fd_sc_hd__decap_3
XFILLER_0_28_34 VGND VGND VPWR VPWR sky130_fd_sc_hd__decap_8
XFILLER_0_56_130 VGND VGND VPWR VPWR sky130_fd_sc_hd__decap_3
XFILLER_0_8_249 VGND VGND VPWR VPWR sky130_fd_sc_hd__decap_3
Xaccumulator._1884_ accumulator._0922_ accumulator._0981_ VGND VGND VPWR VPWR accumulator._0982_
+ sky130_fd_sc_hd__xnor2_1
Xaccumulator._1953_ accumulator._0964_ accumulator._1050_ VGND VGND VPWR VPWR accumulator._1051_
+ sky130_fd_sc_hd__xor2_1
XFILLER_0_60_76 VGND VGND VPWR VPWR sky130_fd_sc_hd__decap_8
XFILLER_0_8_11 VGND VGND VPWR VPWR sky130_fd_sc_hd__decap_3
XFILLER_0_12_233 VGND VGND VPWR VPWR sky130_fd_sc_hd__fill_1
Xoperator._071_ operator._011_ operator._013_ VGND VGND VPWR VPWR operator.io_outExp\[2\]
+ sky130_fd_sc_hd__xnor2_1
XFILLER_0_40_3 VPWR VGND VPWR VGND sky130_ef_sc_hd__decap_12
Xaccumulator._2298_ clknet_2_2__leaf_clock accumulator._0005_ VGND VGND VPWR VPWR
+ accumulator.io_accOut\[3\] sky130_fd_sc_hd__dfxtp_1
Xaccumulator._1318_ accumulator.io_inMant\[11\] accumulator.io_inMant\[10\] accumulator._0415_
+ VGND VGND VPWR VPWR accumulator._0416_ sky130_fd_sc_hd__mux2_1
XTAP_TAPCELL_ROW_63_592 VGND VPWR sky130_fd_sc_hd__tapvpwrvgnd_1
XFILLER_0_47_196 VPWR VGND VPWR VGND sky130_ef_sc_hd__decap_12
Xaccumulator._1249_ accumulator._0348_ VGND VGND VPWR VPWR accumulator._0349_ sky130_fd_sc_hd__clkbuf_4
XFILLER_0_7_293 VPWR VGND VPWR VGND sky130_ef_sc_hd__decap_12
XFILLER_0_50_328 VGND VGND VPWR VPWR sky130_fd_sc_hd__fill_1
XTAP_TAPCELL_ROW_3_170 VGND VPWR sky130_fd_sc_hd__tapvpwrvgnd_1
XFILLER_0_14_58 VGND VGND VPWR VPWR sky130_fd_sc_hd__fill_1
XFILLER_0_53_177 VGND VGND VPWR VPWR sky130_fd_sc_hd__fill_1
XFILLER_0_41_306 VPWR VGND VPWR VGND sky130_ef_sc_hd__decap_12
XFILLER_0_30_35 VGND VGND VPWR VPWR sky130_fd_sc_hd__decap_8
XFILLER_0_26_336 VPWR VGND VPWR VGND sky130_ef_sc_hd__decap_12
XscaleAdd._306_ scaleAdd._254_ scaleAdd._255_ VGND VGND VPWR VPWR scaleAdd._256_ sky130_fd_sc_hd__nor2_1
Xaccumulator._2152_ accumulator._0046_ accumulator._0101_ accumulator._0136_ VGND
+ VGND VPWR VPWR accumulator._0137_ sky130_fd_sc_hd__o21ai_1
Xaccumulator._2221_ accumulator._0197_ accumulator._0203_ accumulator._0362_ VGND
+ VGND VPWR VPWR accumulator._0024_ sky130_fd_sc_hd__a21oi_1
XFILLER_0_44_133 VGND VGND VPWR VPWR sky130_fd_sc_hd__decap_6
XFILLER_0_32_306 VGND VGND VPWR VPWR sky130_fd_sc_hd__fill_2
Xaccumulator._2083_ accumulator._0363_ accumulator._0069_ VGND VGND VPWR VPWR accumulator._0006_
+ sky130_fd_sc_hd__nor2_1
XFILLER_0_29_130 VGND VGND VPWR VPWR sky130_fd_sc_hd__decap_4
Xaccumulator._1867_ accumulator._0959_ accumulator._0961_ accumulator._0964_ VGND
+ VGND VPWR VPWR accumulator._0965_ sky130_fd_sc_hd__nor3b_2
Xaccumulator._1936_ accumulator._1026_ accumulator._1011_ VGND VGND VPWR VPWR accumulator._1034_
+ sky130_fd_sc_hd__nor2_1
Xoperator._054_ net12 net6 VGND VGND VPWR VPWR operator.io_outSign sky130_fd_sc_hd__xor2_1
XFILLER_0_25_391 VGND VGND VPWR VPWR sky130_fd_sc_hd__fill_1
Xaccumulator._1798_ accumulator._0781_ accumulator._0793_ accumulator._0795_ VGND
+ VGND VPWR VPWR accumulator._0896_ sky130_fd_sc_hd__a21o_1
XTAP_TAPCELL_ROW_0_151 VGND VPWR sky130_fd_sc_hd__tapvpwrvgnd_1
XTAP_TAPCELL_ROW_0_140 VGND VPWR sky130_fd_sc_hd__tapvpwrvgnd_1
XFILLER_0_25_57 VGND VGND VPWR VPWR sky130_fd_sc_hd__fill_1
XFILLER_0_41_89 VGND VGND VPWR VPWR sky130_fd_sc_hd__decap_6
XFILLER_0_26_133 VGND VGND VPWR VPWR sky130_fd_sc_hd__decap_6
Xclkbuf_2_1__f_clock clknet_0_clock VGND VGND VPWR VPWR clknet_2_1__leaf_clock sky130_fd_sc_hd__clkbuf_16
Xaccumulator._1721_ accumulator._0818_ accumulator._0725_ VGND VGND VPWR VPWR accumulator._0819_
+ sky130_fd_sc_hd__nor2_1
XFILLER_0_41_169 VGND VGND VPWR VPWR sky130_fd_sc_hd__decap_8
XFILLER_0_1_200 VGND VGND VPWR VPWR sky130_fd_sc_hd__decap_4
XFILLER_0_14_306 VGND VGND VPWR VPWR sky130_fd_sc_hd__fill_2
XFILLER_0_14_317 VGND VGND VPWR VPWR sky130_fd_sc_hd__decap_3
XFILLER_0_66_97 VGND VGND VPWR VPWR sky130_fd_sc_hd__fill_2
XFILLER_0_66_53 VPWR VGND VPWR VGND sky130_ef_sc_hd__decap_12
Xaccumulator._1652_ accumulator._0390_ accumulator._0747_ accumulator._0749_ VGND
+ VGND VPWR VPWR accumulator._0750_ sky130_fd_sc_hd__nor3b_1
Xaccumulator._1583_ accumulator._0502_ accumulator._0577_ accumulator._0597_ accumulator._0399_
+ VGND VGND VPWR VPWR accumulator._0681_ sky130_fd_sc_hd__o211a_1
Xaccumulator._2204_ accumulator._1028_ accumulator._1011_ net102 VGND VGND VPWR VPWR
+ accumulator._0187_ sky130_fd_sc_hd__mux2_1
XFILLER_0_49_269 VGND VGND VPWR VPWR sky130_fd_sc_hd__decap_4
Xaccumulator._2135_ accumulator._0363_ accumulator._0119_ VGND VGND VPWR VPWR accumulator._0013_
+ sky130_fd_sc_hd__nor2_1
XFILLER_0_64_228 VGND VGND VPWR VPWR sky130_fd_sc_hd__fill_2
Xaccumulator._2066_ accumulator._0046_ accumulator._0051_ VGND VGND VPWR VPWR accumulator._0052_
+ sky130_fd_sc_hd__nand2_1
Xoperator._106_ net8 net3 operator._040_ operator._030_ VGND VGND VPWR VPWR operator._042_
+ sky130_fd_sc_hd__nand4_1
XFILLER_0_17_177 VGND VGND VPWR VPWR sky130_fd_sc_hd__fill_1
XTAP_TAPCELL_ROW_20_289 VGND VPWR sky130_fd_sc_hd__tapvpwrvgnd_1
Xaccumulator._1919_ accumulator._1016_ VGND VGND VPWR VPWR accumulator._1017_ sky130_fd_sc_hd__inv_2
XFILLER_0_40_191 VGND VGND VPWR VPWR sky130_fd_sc_hd__decap_4
XFILLER_0_32_169 VPWR VGND VPWR VGND sky130_ef_sc_hd__decap_12
XFILLER_0_13_361 VPWR VGND VPWR VGND sky130_ef_sc_hd__decap_12
XTAP_TAPCELL_ROW_28_345 VGND VPWR sky130_fd_sc_hd__tapvpwrvgnd_1
XFILLER_0_63_250 VGND VGND VPWR VPWR sky130_fd_sc_hd__decap_6
XTAP_TAPCELL_ROW_11_223 VGND VPWR sky130_fd_sc_hd__tapvpwrvgnd_1
Xinput8 io_inB[1] VGND VGND VPWR VPWR net8 sky130_fd_sc_hd__buf_1
XFILLER_0_54_250 VGND VGND VPWR VPWR sky130_fd_sc_hd__fill_2
XFILLER_0_52_77 VGND VGND VPWR VPWR sky130_fd_sc_hd__fill_1
XFILLER_0_14_114 VPWR VGND VPWR VGND sky130_ef_sc_hd__decap_12
Xaccumulator._1704_ accumulator._0391_ accumulator._0655_ VGND VGND VPWR VPWR accumulator._0802_
+ sky130_fd_sc_hd__or2_1
Xaccumulator._1635_ accumulator._0390_ accumulator._0731_ accumulator._0732_ VGND
+ VGND VPWR VPWR accumulator._0733_ sky130_fd_sc_hd__nor3_1
Xaccumulator._1566_ accumulator._0648_ accumulator._0663_ accumulator._0502_ VGND
+ VGND VPWR VPWR accumulator._0664_ sky130_fd_sc_hd__mux2_1
Xaccumulator._1497_ accumulator.io_accOut\[5\] accumulator._0397_ accumulator._0575_
+ VGND VGND VPWR VPWR accumulator._0595_ sky130_fd_sc_hd__and3_1
Xaccumulator._2049_ accumulator._1142_ accumulator._1145_ accumulator._0035_ VGND
+ VGND VPWR VPWR accumulator._0036_ sky130_fd_sc_hd__mux2_1
XTAP_TAPCELL_ROW_33_381 VGND VPWR sky130_fd_sc_hd__tapvpwrvgnd_1
Xaccumulator._2118_ accumulator.io_accOut\[9\] accumulator._0350_ VGND VGND VPWR VPWR
+ accumulator._0104_ sky130_fd_sc_hd__nand2_1
XTAP_TAPCELL_ROW_25_326 VGND VPWR sky130_fd_sc_hd__tapvpwrvgnd_1
XFILLER_0_60_253 VPWR VGND VPWR VGND sky130_ef_sc_hd__decap_12
XFILLER_0_5_391 VGND VGND VPWR VPWR sky130_fd_sc_hd__fill_1
XFILLER_0_36_261 VGND VGND VPWR VPWR sky130_fd_sc_hd__fill_1
XFILLER_0_36_250 VGND VGND VPWR VPWR sky130_fd_sc_hd__fill_2
XFILLER_0_3_317 VPWR VGND VPWR VGND sky130_ef_sc_hd__decap_12
XFILLER_0_51_253 VPWR VGND VPWR VGND sky130_ef_sc_hd__decap_12
XscaleAdd._554_ scaleAdd._215_ scaleAdd._218_ scaleAdd._219_ operator.io_outExp\[4\]
+ VGND VGND VPWR VPWR accumulator.io_inExp\[8\] sky130_fd_sc_hd__a22o_1
XscaleAdd._485_ scaleAdd._156_ scaleAdd._157_ VGND VGND VPWR VPWR scaleAdd._158_ sky130_fd_sc_hd__and2_1
XFILLER_0_47_55 VGND VGND VPWR VPWR sky130_fd_sc_hd__fill_1
Xaccumulator._1351_ accumulator._0448_ VGND VGND VPWR VPWR accumulator._0449_ sky130_fd_sc_hd__buf_2
XTAP_TAPCELL_ROW_39_418 VGND VPWR sky130_fd_sc_hd__tapvpwrvgnd_1
Xaccumulator._1420_ accumulator._0475_ accumulator._0517_ accumulator._0413_ VGND
+ VGND VPWR VPWR accumulator._0518_ sky130_fd_sc_hd__a21o_1
XFILLER_0_63_87 VGND VGND VPWR VPWR sky130_fd_sc_hd__decap_3
Xaccumulator._1282_ accumulator.io_accOut\[23\] accumulator._0379_ VGND VGND VPWR
+ VPWR accumulator._0380_ sky130_fd_sc_hd__nand2_1
Xaccumulator._1618_ accumulator._0583_ accumulator._0584_ VGND VGND VPWR VPWR accumulator._0716_
+ sky130_fd_sc_hd__nand2_1
XFILLER_0_10_183 VGND VGND VPWR VPWR sky130_fd_sc_hd__fill_1
Xaccumulator._1549_ accumulator._0438_ accumulator._0613_ accumulator._0614_ VGND
+ VGND VPWR VPWR accumulator._0647_ sky130_fd_sc_hd__or3_1
XFILLER_0_18_294 VPWR VGND VPWR VGND sky130_ef_sc_hd__decap_12
XFILLER_0_0_309 VPWR VGND VPWR VGND sky130_ef_sc_hd__decap_12
XscaleAdd._270_ net15 net14 VGND VGND VPWR VPWR scaleAdd._223_ sky130_fd_sc_hd__and2b_1
XTAP_TAPCELL_ROW_44_454 VGND VPWR sky130_fd_sc_hd__tapvpwrvgnd_1
XFILLER_0_56_378 VGND VGND VPWR VPWR sky130_fd_sc_hd__decap_8
XFILLER_0_24_253 VGND VGND VPWR VPWR sky130_fd_sc_hd__decap_6
XFILLER_0_3_169 VGND VGND VPWR VPWR sky130_fd_sc_hd__decap_8
XFILLER_0_3_125 VGND VGND VPWR VPWR sky130_fd_sc_hd__fill_1
Xinput11 io_inB[4] VGND VGND VPWR VPWR net11 sky130_fd_sc_hd__clkbuf_2
Xinput22 io_inScaleB[4] VGND VGND VPWR VPWR net22 sky130_fd_sc_hd__clkbuf_1
XscaleAdd._537_ operator.io_outExp\[4\] scaleAdd._205_ VGND VGND VPWR VPWR scaleAdd._206_
+ sky130_fd_sc_hd__or2_1
XscaleAdd._468_ net81 scaleAdd._144_ scaleAdd._128_ scaleAdd._142_ VGND VGND VPWR
+ VPWR scaleAdd._145_ sky130_fd_sc_hd__a31o_1
XscaleAdd._399_ scaleAdd._062_ scaleAdd._078_ VGND VGND VPWR VPWR scaleAdd._079_ sky130_fd_sc_hd__xnor2_2
Xaccumulator._1403_ accumulator._0454_ accumulator._0500_ accumulator._0490_ VGND
+ VGND VPWR VPWR accumulator._0501_ sky130_fd_sc_hd__a21o_1
Xaccumulator._1265_ accumulator._0362_ VGND VGND VPWR VPWR accumulator._0363_ sky130_fd_sc_hd__buf_2
Xaccumulator._1334_ accumulator.io_accOut\[22\] accumulator._0431_ accumulator._0346_
+ VGND VGND VPWR VPWR accumulator._0432_ sky130_fd_sc_hd__mux2_2
XFILLER_0_59_161 VGND VGND VPWR VPWR sky130_fd_sc_hd__decap_6
Xaccumulator._1196_ accumulator.io_inExp\[8\] accumulator._0295_ VGND VGND VPWR VPWR
+ accumulator._0296_ sky130_fd_sc_hd__xnor2_2
XFILLER_0_30_223 VPWR VGND VPWR VGND sky130_ef_sc_hd__decap_12
XFILLER_0_15_242 VGND VGND VPWR VPWR sky130_fd_sc_hd__decap_3
XTAP_TAPCELL_ROW_58_557 VGND VPWR sky130_fd_sc_hd__tapvpwrvgnd_1
XFILLER_0_38_323 VGND VGND VPWR VPWR sky130_fd_sc_hd__fill_1
XFILLER_0_53_337 VPWR VGND VPWR VGND sky130_ef_sc_hd__decap_12
XTAP_TAPCELL_ROW_41_435 VGND VPWR sky130_fd_sc_hd__tapvpwrvgnd_1
XscaleAdd._322_ scaleAdd._251_ scaleAdd._255_ scaleAdd._004_ VGND VGND VPWR VPWR scaleAdd._005_
+ sky130_fd_sc_hd__o21a_1
XFILLER_0_21_234 VGND VGND VPWR VPWR sky130_fd_sc_hd__decap_8
XTAP_TAPCELL_ROW_6_190 VGND VPWR sky130_fd_sc_hd__tapvpwrvgnd_1
XFILLER_0_56_175 VPWR VGND VPWR VGND sky130_ef_sc_hd__decap_12
XFILLER_0_48_109 VGND VGND VPWR VPWR sky130_fd_sc_hd__decap_6
Xoperator._070_ operator._012_ operator._001_ operator._006_ operator._008_ operator._004_
+ VGND VGND VPWR VPWR operator._013_ sky130_fd_sc_hd__o32ai_2
Xaccumulator._1883_ accumulator._0366_ accumulator._0566_ accumulator._0729_ accumulator._0980_
+ VGND VGND VPWR VPWR accumulator._0981_ sky130_fd_sc_hd__a31o_1
Xaccumulator._1952_ accumulator._0902_ accumulator._0959_ VGND VGND VPWR VPWR accumulator._1050_
+ sky130_fd_sc_hd__nand2_1
XFILLER_0_4_401 VGND VGND VPWR VPWR sky130_fd_sc_hd__decap_8
XFILLER_0_12_256 VPWR VGND VPWR VGND sky130_ef_sc_hd__decap_12
XFILLER_0_33_3 VPWR VGND VPWR VGND sky130_ef_sc_hd__decap_12
Xaccumulator._2297_ clknet_2_2__leaf_clock accumulator._0004_ VGND VGND VPWR VPWR
+ accumulator.io_accOut\[2\] sky130_fd_sc_hd__dfxtp_1
Xaccumulator._1248_ accumulator._0347_ VGND VGND VPWR VPWR accumulator._0348_ sky130_fd_sc_hd__clkbuf_4
Xaccumulator._1317_ accumulator._0313_ VGND VGND VPWR VPWR accumulator._0415_ sky130_fd_sc_hd__clkbuf_4
XFILLER_0_47_175 VGND VGND VPWR VPWR sky130_fd_sc_hd__decap_3
Xaccumulator._1179_ accumulator._0277_ accumulator._0278_ VGND VGND VPWR VPWR accumulator._0279_
+ sky130_fd_sc_hd__nand2_2
XFILLER_0_7_272 VGND VGND VPWR VPWR sky130_fd_sc_hd__decap_8
XTAP_TAPCELL_ROW_3_171 VGND VPWR sky130_fd_sc_hd__tapvpwrvgnd_1
XFILLER_0_53_101 VGND VGND VPWR VPWR sky130_fd_sc_hd__decap_8
XFILLER_0_38_197 VGND VGND VPWR VPWR sky130_fd_sc_hd__fill_1
XFILLER_0_26_326 VGND VGND VPWR VPWR sky130_fd_sc_hd__fill_1
XFILLER_0_26_304 VGND VGND VPWR VPWR sky130_fd_sc_hd__fill_1
XFILLER_0_53_189 VPWR VGND VPWR VGND sky130_ef_sc_hd__decap_12
XFILLER_0_41_318 VGND VGND VPWR VPWR sky130_fd_sc_hd__fill_2
XFILLER_0_26_348 VGND VGND VPWR VPWR sky130_fd_sc_hd__fill_1
XscaleAdd._305_ scaleAdd._221_ operator.io_outMant\[5\] scaleAdd._253_ VGND VGND VPWR
+ VPWR scaleAdd._255_ sky130_fd_sc_hd__and3_1
XFILLER_0_55_55 VGND VGND VPWR VPWR sky130_fd_sc_hd__fill_1
Xaccumulator._2151_ accumulator._0046_ accumulator._0135_ VGND VGND VPWR VPWR accumulator._0136_
+ sky130_fd_sc_hd__nand2_1
Xaccumulator._2220_ accumulator._0198_ accumulator._0357_ accumulator._0081_ accumulator._0185_
+ accumulator._0202_ VGND VGND VPWR VPWR accumulator._0203_ sky130_fd_sc_hd__o221a_1
Xaccumulator._2082_ accumulator.io_accOut\[4\] accumulator._0364_ accumulator._0058_
+ accumulator._0068_ VGND VGND VPWR VPWR accumulator._0069_ sky130_fd_sc_hd__o2bb2a_1
Xaccumulator._1866_ accumulator._0626_ accumulator._0963_ VGND VGND VPWR VPWR accumulator._0964_
+ sky130_fd_sc_hd__xor2_2
Xaccumulator._1935_ accumulator._0534_ accumulator._0840_ accumulator._0843_ accumulator._0669_
+ accumulator._0740_ VGND VGND VPWR VPWR accumulator._1033_ sky130_fd_sc_hd__a32oi_4
Xaccumulator._1797_ accumulator._0444_ accumulator._0371_ VGND VGND VPWR VPWR accumulator._0895_
+ sky130_fd_sc_hd__or2_1
XFILLER_0_40_373 VPWR VGND VPWR VGND sky130_ef_sc_hd__decap_12
XFILLER_0_40_362 VGND VGND VPWR VPWR sky130_fd_sc_hd__fill_2
XFILLER_0_4_253 VGND VGND VPWR VPWR sky130_fd_sc_hd__decap_8
XTAP_TAPCELL_ROW_9_208 VGND VPWR sky130_fd_sc_hd__tapvpwrvgnd_1
XTAP_TAPCELL_ROW_68_630 VGND VPWR sky130_fd_sc_hd__tapvpwrvgnd_1
XFILLER_0_35_101 VGND VGND VPWR VPWR sky130_fd_sc_hd__decap_8
XTAP_TAPCELL_ROW_0_141 VGND VPWR sky130_fd_sc_hd__tapvpwrvgnd_1
XFILLER_0_41_57 VGND VGND VPWR VPWR sky130_fd_sc_hd__decap_6
XTAP_TAPCELL_ROW_14_243 VGND VPWR sky130_fd_sc_hd__tapvpwrvgnd_1
Xaccumulator._1720_ accumulator._0720_ accumulator._0721_ VGND VGND VPWR VPWR accumulator._0818_
+ sky130_fd_sc_hd__and2_1
Xaccumulator._1651_ accumulator._0446_ accumulator._0609_ accumulator._0610_ accumulator._0748_
+ VGND VGND VPWR VPWR accumulator._0749_ sky130_fd_sc_hd__a31o_4
XFILLER_0_1_212 VGND VGND VPWR VPWR sky130_fd_sc_hd__decap_4
XFILLER_0_66_65 VPWR VGND VPWR VGND sky130_ef_sc_hd__decap_12
XTAP_TAPCELL_ROW_65_600 VGND VPWR sky130_fd_sc_hd__tapvpwrvgnd_1
Xaccumulator._1582_ accumulator._0630_ accumulator._0679_ accumulator._0472_ VGND
+ VGND VPWR VPWR accumulator._0680_ sky130_fd_sc_hd__mux2_1
XFILLER_0_5_79 VPWR VGND VPWR VGND sky130_ef_sc_hd__decap_12
XFILLER_0_57_281 VGND VGND VPWR VPWR sky130_fd_sc_hd__decap_4
Xaccumulator._2065_ accumulator._0050_ accumulator._1143_ accumulator._1097_ VGND
+ VGND VPWR VPWR accumulator._0051_ sky130_fd_sc_hd__mux2_1
XFILLER_0_49_204 VGND VGND VPWR VPWR sky130_fd_sc_hd__fill_1
Xaccumulator._2203_ accumulator._0046_ accumulator._0157_ VGND VGND VPWR VPWR accumulator._0186_
+ sky130_fd_sc_hd__nor2_1
Xaccumulator._2134_ accumulator._0053_ accumulator._0089_ accumulator._0117_ accumulator._1032_
+ accumulator._0118_ VGND VGND VPWR VPWR accumulator._0119_ sky130_fd_sc_hd__o221a_1
Xoperator._105_ operator._040_ net3 operator._030_ net8 VGND VGND VPWR VPWR operator._041_
+ sky130_fd_sc_hd__a22o_1
Xaccumulator._1849_ accumulator._0638_ accumulator._0660_ accumulator._0704_ accumulator._0705_
+ VGND VGND VPWR VPWR accumulator._0947_ sky130_fd_sc_hd__a31o_1
Xaccumulator._1918_ accumulator._0996_ accumulator._1015_ VGND VGND VPWR VPWR accumulator._1016_
+ sky130_fd_sc_hd__xor2_2
XFILLER_0_13_373 VPWR VGND VPWR VGND sky130_ef_sc_hd__decap_12
XTAP_TAPCELL_ROW_28_346 VGND VPWR sky130_fd_sc_hd__tapvpwrvgnd_1
XFILLER_0_11_27 VPWR VGND VPWR VGND sky130_ef_sc_hd__decap_12
XTAP_TAPCELL_ROW_11_224 VGND VPWR sky130_fd_sc_hd__tapvpwrvgnd_1
Xinput9 io_inB[2] VGND VGND VPWR VPWR net9 sky130_fd_sc_hd__buf_6
XFILLER_0_52_67 VGND VGND VPWR VPWR sky130_fd_sc_hd__fill_2
XFILLER_0_46_218 VPWR VGND VPWR VGND sky130_ef_sc_hd__decap_12
XFILLER_0_14_126 VPWR VGND VPWR VGND sky130_ef_sc_hd__decap_12
Xaccumulator._1634_ accumulator._0411_ accumulator._0654_ accumulator._0396_ VGND
+ VGND VPWR VPWR accumulator._0732_ sky130_fd_sc_hd__o21a_1
Xaccumulator._1703_ accumulator._0800_ VGND VGND VPWR VPWR accumulator._0801_ sky130_fd_sc_hd__inv_2
XFILLER_0_10_321 VPWR VGND VPWR VGND sky130_ef_sc_hd__decap_12
XFILLER_0_10_365 VPWR VGND VPWR VGND sky130_ef_sc_hd__decap_12
Xaccumulator._1565_ accumulator._0629_ accumulator._0662_ accumulator._0455_ VGND
+ VGND VPWR VPWR accumulator._0663_ sky130_fd_sc_hd__mux2_1
Xaccumulator._1496_ net64 accumulator._0412_ accumulator._0435_ VGND VGND VPWR VPWR
+ accumulator._0594_ sky130_fd_sc_hd__or3_1
Xaccumulator._2048_ accumulator._1138_ VGND VGND VPWR VPWR accumulator._0035_ sky130_fd_sc_hd__clkbuf_4
Xaccumulator._2117_ accumulator._0072_ accumulator._0101_ accumulator._0035_ VGND
+ VGND VPWR VPWR accumulator._0102_ sky130_fd_sc_hd__mux2_2
XTAP_TAPCELL_ROW_33_382 VGND VPWR sky130_fd_sc_hd__tapvpwrvgnd_1
XFILLER_0_60_265 VPWR VGND VPWR VGND sky130_ef_sc_hd__decap_12
XFILLER_0_60_232 VGND VGND VPWR VPWR sky130_fd_sc_hd__fill_1
XFILLER_0_45_284 VPWR VGND VPWR VGND sky130_ef_sc_hd__decap_12
XFILLER_0_68_365 VPWR VGND VPWR VGND sky130_ef_sc_hd__decap_12
XFILLER_0_68_321 VPWR VGND VPWR VGND sky130_ef_sc_hd__decap_12
XFILLER_0_51_265 VPWR VGND VPWR VGND sky130_ef_sc_hd__decap_12
XFILLER_0_51_221 VGND VGND VPWR VPWR sky130_fd_sc_hd__decap_3
XFILLER_0_3_329 VGND VGND VPWR VPWR sky130_fd_sc_hd__decap_6
XFILLER_0_22_26 VGND VGND VPWR VPWR sky130_fd_sc_hd__fill_2
XscaleAdd._553_ scaleAdd._215_ scaleAdd._218_ scaleAdd._219_ operator.io_outExp\[4\]
+ VGND VGND VPWR VPWR accumulator.io_inExp\[6\] sky130_fd_sc_hd__a22o_1
XFILLER_0_11_107 VGND VGND VPWR VPWR sky130_fd_sc_hd__decap_4
XscaleAdd._484_ scaleAdd._154_ scaleAdd._155_ operator.io_outExp\[0\] VGND VGND VPWR
+ VPWR scaleAdd._157_ sky130_fd_sc_hd__a21o_1
XFILLER_0_63_55 VGND VGND VPWR VPWR sky130_fd_sc_hd__fill_1
XFILLER_0_59_321 VPWR VGND VPWR VGND sky130_ef_sc_hd__decap_12
XFILLER_0_47_67 VPWR VGND VPWR VGND sky130_ef_sc_hd__decap_12
XTAP_TAPCELL_ROW_39_419 VGND VPWR sky130_fd_sc_hd__tapvpwrvgnd_1
Xaccumulator._1350_ accumulator._0377_ accumulator._0398_ VGND VGND VPWR VPWR accumulator._0448_
+ sky130_fd_sc_hd__xor2_2
Xaccumulator._1281_ accumulator._0316_ accumulator._0322_ VGND VGND VPWR VPWR accumulator._0379_
+ sky130_fd_sc_hd__or2_1
XPHY_EDGE_ROW_10_Right_10 VGND VGND VPWR VPWR sky130_fd_sc_hd__decap_3
XTAP_TAPCELL_ROW_47_474 VGND VPWR sky130_fd_sc_hd__tapvpwrvgnd_1
XFILLER_0_6_101 VGND VGND VPWR VPWR sky130_fd_sc_hd__decap_3
XFILLER_0_19_229 VGND VGND VPWR VPWR sky130_fd_sc_hd__fill_1
XFILLER_0_63_3 VPWR VGND VPWR VGND sky130_ef_sc_hd__decap_12
XFILLER_0_42_210 VGND VGND VPWR VPWR sky130_fd_sc_hd__fill_2
XFILLER_0_27_284 VGND VGND VPWR VPWR sky130_fd_sc_hd__fill_1
XFILLER_0_6_145 VGND VGND VPWR VPWR sky130_fd_sc_hd__fill_1
Xaccumulator._1617_ accumulator._0714_ VGND VGND VPWR VPWR accumulator._0715_ sky130_fd_sc_hd__inv_2
XFILLER_0_10_195 VGND VGND VPWR VPWR sky130_fd_sc_hd__fill_1
Xaccumulator._1479_ accumulator.io_accOut\[8\] accumulator._0470_ accumulator._0574_
+ accumulator._0576_ VGND VGND VPWR VPWR accumulator._0577_ sky130_fd_sc_hd__a31o_1
Xaccumulator._1548_ accumulator._0556_ accumulator._0559_ accumulator._0473_ VGND
+ VGND VPWR VPWR accumulator._0646_ sky130_fd_sc_hd__a21o_1
XFILLER_0_33_287 VGND VGND VPWR VPWR sky130_fd_sc_hd__fill_1
XFILLER_0_17_48 VGND VGND VPWR VPWR sky130_fd_sc_hd__fill_1
XFILLER_0_56_357 VGND VGND VPWR VPWR sky130_fd_sc_hd__fill_1
XTAP_TAPCELL_ROW_44_455 VGND VPWR sky130_fd_sc_hd__tapvpwrvgnd_1
Xinput12 io_inB[5] VGND VGND VPWR VPWR net12 sky130_fd_sc_hd__buf_1
XscaleAdd._536_ scaleAdd._203_ scaleAdd._204_ VGND VGND VPWR VPWR scaleAdd._205_ sky130_fd_sc_hd__and2_1
Xinput23 io_inScaleB[5] VGND VGND VPWR VPWR net23 sky130_fd_sc_hd__buf_1
XFILLER_0_24_221 VPWR VGND VPWR VGND sky130_ef_sc_hd__decap_12
XFILLER_0_58_99 VGND VGND VPWR VPWR sky130_fd_sc_hd__decap_6
Xaccumulator._1402_ accumulator.io_accOut\[13\] accumulator._0499_ accumulator._0347_
+ VGND VGND VPWR VPWR accumulator._0500_ sky130_fd_sc_hd__mux2_1
XscaleAdd._398_ scaleAdd._064_ scaleAdd._077_ VGND VGND VPWR VPWR scaleAdd._078_ sky130_fd_sc_hd__xnor2_2
XscaleAdd._467_ scaleAdd._106_ scaleAdd._127_ VGND VGND VPWR VPWR scaleAdd._144_ sky130_fd_sc_hd__or2_1
Xaccumulator._1264_ accumulator._0361_ VGND VGND VPWR VPWR accumulator._0362_ sky130_fd_sc_hd__clkbuf_2
Xaccumulator._1333_ accumulator._0414_ accumulator._0416_ accumulator._0417_ accumulator._0430_
+ VGND VGND VPWR VPWR accumulator._0431_ sky130_fd_sc_hd__a211o_1
XFILLER_0_47_335 VGND VGND VPWR VPWR sky130_fd_sc_hd__fill_1
XFILLER_0_15_221 VGND VGND VPWR VPWR sky130_fd_sc_hd__decap_3
Xaccumulator._1195_ accumulator.io_inExp\[7\] accumulator._0285_ VGND VGND VPWR VPWR
+ accumulator._0295_ sky130_fd_sc_hd__nand2_1
XFILLER_0_2_181 VGND VGND VPWR VPWR sky130_fd_sc_hd__decap_6
XTAP_TAPCELL_ROW_41_436 VGND VPWR sky130_fd_sc_hd__tapvpwrvgnd_1
XFILLER_0_65_176 VGND VGND VPWR VPWR sky130_fd_sc_hd__decap_4
XFILLER_0_61_393 VPWR VGND VPWR VGND sky130_ef_sc_hd__decap_12
XFILLER_0_53_349 VGND VGND VPWR VPWR sky130_fd_sc_hd__decap_6
XFILLER_0_28_47 VGND VGND VPWR VPWR sky130_fd_sc_hd__fill_2
XscaleAdd._321_ scaleAdd._263_ scaleAdd._003_ VGND VGND VPWR VPWR scaleAdd._004_ sky130_fd_sc_hd__xor2_1
XTAP_TAPCELL_ROW_6_191 VGND VPWR sky130_fd_sc_hd__tapvpwrvgnd_1
XFILLER_0_60_89 VGND VGND VPWR VPWR sky130_fd_sc_hd__fill_1
XFILLER_0_56_187 VGND VGND VPWR VPWR sky130_fd_sc_hd__decap_4
XFILLER_0_44_338 VGND VGND VPWR VPWR sky130_fd_sc_hd__decap_3
XFILLER_0_37_390 VGND VGND VPWR VPWR sky130_fd_sc_hd__fill_2
XFILLER_0_29_357 VGND VGND VPWR VPWR sky130_fd_sc_hd__decap_8
XFILLER_0_29_335 VGND VGND VPWR VPWR sky130_fd_sc_hd__fill_1
Xaccumulator._1951_ accumulator._1046_ accumulator._1048_ VGND VGND VPWR VPWR accumulator._1049_
+ sky130_fd_sc_hd__nand2_1
Xaccumulator._1882_ accumulator._0815_ accumulator._0978_ accumulator._0974_ accumulator._0979_
+ VGND VGND VPWR VPWR accumulator._0980_ sky130_fd_sc_hd__a31o_1
XscaleAdd._519_ scaleAdd._173_ scaleAdd._183_ scaleAdd._187_ VGND VGND VPWR VPWR scaleAdd._189_
+ sky130_fd_sc_hd__nor3_1
XFILLER_0_8_79 VGND VGND VPWR VPWR sky130_fd_sc_hd__decap_4
XFILLER_0_12_268 VPWR VGND VPWR VGND sky130_ef_sc_hd__decap_12
Xaccumulator._2296_ clknet_2_2__leaf_clock accumulator._0003_ VGND VGND VPWR VPWR
+ accumulator.io_accOut\[1\] sky130_fd_sc_hd__dfxtp_1
Xaccumulator._1247_ accumulator._0346_ VGND VGND VPWR VPWR accumulator._0347_ sky130_fd_sc_hd__clkbuf_4
Xaccumulator._1178_ accumulator.io_inExp\[3\] accumulator._0276_ VGND VGND VPWR VPWR
+ accumulator._0278_ sky130_fd_sc_hd__nand2_1
Xaccumulator._1316_ accumulator._0171_ VGND VGND VPWR VPWR accumulator._0414_ sky130_fd_sc_hd__inv_2
XTAP_TAPCELL_ROW_3_172 VGND VPWR sky130_fd_sc_hd__tapvpwrvgnd_1
XFILLER_0_14_27 VGND VGND VPWR VPWR sky130_fd_sc_hd__fill_1
XFILLER_0_53_124 VGND VGND VPWR VPWR sky130_fd_sc_hd__decap_6
XFILLER_0_38_187 VGND VGND VPWR VPWR sky130_fd_sc_hd__decap_8
XFILLER_0_38_154 VGND VGND VPWR VPWR sky130_fd_sc_hd__fill_1
XFILLER_0_30_26 VGND VGND VPWR VPWR sky130_fd_sc_hd__fill_2
XFILLER_0_34_393 VGND VGND VPWR VPWR sky130_fd_sc_hd__decap_8
XFILLER_0_1_405 VGND VGND VPWR VPWR sky130_fd_sc_hd__decap_4
XscaleAdd._304_ scaleAdd._221_ operator.io_outMant\[5\] scaleAdd._253_ VGND VGND VPWR
+ VPWR scaleAdd._254_ sky130_fd_sc_hd__a21oi_1
Xaccumulator._2150_ accumulator._0134_ accumulator._0113_ accumulator._1127_ VGND
+ VGND VPWR VPWR accumulator._0135_ sky130_fd_sc_hd__mux2_2
XTAP_TAPCELL_ROW_52_509 VGND VPWR sky130_fd_sc_hd__tapvpwrvgnd_1
Xaccumulator._2081_ accumulator._0065_ accumulator._0061_ accumulator._0067_ VGND
+ VGND VPWR VPWR accumulator._0068_ sky130_fd_sc_hd__a21o_1
XFILLER_0_29_110 VGND VGND VPWR VPWR sky130_fd_sc_hd__fill_2
XPHY_EDGE_ROW_8_Right_8 VGND VGND VPWR VPWR sky130_fd_sc_hd__decap_3
XFILLER_0_12_9 VGND VGND VPWR VPWR sky130_fd_sc_hd__decap_3
XFILLER_0_44_168 VGND VGND VPWR VPWR sky130_fd_sc_hd__fill_1
Xaccumulator._1934_ accumulator._1031_ VGND VGND VPWR VPWR accumulator._1032_ sky130_fd_sc_hd__buf_2
XFILLER_0_40_330 VPWR VGND VPWR VGND sky130_ef_sc_hd__decap_12
XFILLER_0_29_198 VPWR VGND VPWR VGND sky130_ef_sc_hd__decap_12
XFILLER_0_4_221 VPWR VGND VPWR VGND sky130_ef_sc_hd__decap_12
XFILLER_0_17_316 VPWR VGND VPWR VGND sky130_ef_sc_hd__decap_12
Xaccumulator._1865_ accumulator._0365_ accumulator._0608_ accumulator._0707_ accumulator._0962_
+ VGND VGND VPWR VPWR accumulator._0963_ sky130_fd_sc_hd__a31oi_2
Xaccumulator._1796_ accumulator._0779_ accumulator._0793_ accumulator._0893_ VGND
+ VGND VPWR VPWR accumulator._0894_ sky130_fd_sc_hd__nand3b_1
XPHY_EDGE_ROW_39_Right_39 VGND VGND VPWR VPWR sky130_fd_sc_hd__decap_3
XFILLER_0_40_385 VPWR VGND VPWR VGND sky130_ef_sc_hd__decap_12
XTAP_TAPCELL_ROW_9_209 VGND VPWR sky130_fd_sc_hd__tapvpwrvgnd_1
XTAP_TAPCELL_ROW_68_631 VGND VPWR sky130_fd_sc_hd__tapvpwrvgnd_1
XTAP_TAPCELL_ROW_0_142 VGND VPWR sky130_fd_sc_hd__tapvpwrvgnd_1
XFILLER_0_67_238 VGND VGND VPWR VPWR sky130_fd_sc_hd__decap_8
XPHY_EDGE_ROW_48_Right_48 VGND VGND VPWR VPWR sky130_fd_sc_hd__decap_3
XFILLER_0_0_91 VPWR VGND VPWR VGND sky130_ef_sc_hd__decap_12
Xaccumulator._2279_ accumulator._0256_ accumulator._0260_ VGND VGND VPWR VPWR accumulator._0261_
+ sky130_fd_sc_hd__xor2_1
XPHY_EDGE_ROW_57_Right_57 VGND VGND VPWR VPWR sky130_fd_sc_hd__decap_3
XFILLER_0_50_149 VGND VGND VPWR VPWR sky130_fd_sc_hd__fill_2
XPHY_EDGE_ROW_66_Right_66 VGND VGND VPWR VPWR sky130_fd_sc_hd__decap_3
XFILLER_0_26_146 VPWR VGND VPWR VGND sky130_ef_sc_hd__decap_12
XTAP_TAPCELL_ROW_14_244 VGND VPWR sky130_fd_sc_hd__tapvpwrvgnd_1
Xaccumulator._1650_ net88 accumulator._0502_ accumulator._0449_ accumulator._0393_
+ VGND VGND VPWR VPWR accumulator._0748_ sky130_fd_sc_hd__and4b_1
Xaccumulator._1581_ accumulator._0413_ accumulator._0662_ accumulator._0678_ VGND
+ VGND VPWR VPWR accumulator._0679_ sky130_fd_sc_hd__o21a_1
XFILLER_0_22_363 VGND VGND VPWR VPWR sky130_fd_sc_hd__fill_1
XFILLER_0_1_279 VGND VGND VPWR VPWR sky130_fd_sc_hd__fill_1
XFILLER_0_66_77 VGND VGND VPWR VPWR sky130_fd_sc_hd__decap_6
XTAP_TAPCELL_ROW_65_601 VGND VPWR sky130_fd_sc_hd__tapvpwrvgnd_1
Xaccumulator._2202_ accumulator._0357_ accumulator._0057_ VGND VGND VPWR VPWR accumulator._0185_
+ sky130_fd_sc_hd__nand2_1
Xaccumulator._2064_ accumulator._1074_ accumulator._1076_ accumulator._1124_ VGND
+ VGND VPWR VPWR accumulator._0050_ sky130_fd_sc_hd__mux2_2
Xaccumulator._2133_ accumulator.io_accOut\[11\] accumulator._0350_ VGND VGND VPWR
+ VPWR accumulator._0118_ sky130_fd_sc_hd__nand2_1
XFILLER_0_9_335 VGND VGND VPWR VPWR sky130_fd_sc_hd__fill_1
XPHY_EDGE_ROW_17_Left_86 VGND VGND VPWR VPWR sky130_fd_sc_hd__decap_3
XFILLER_0_17_113 VPWR VGND VPWR VGND sky130_ef_sc_hd__decap_12
Xaccumulator._1917_ accumulator._1014_ accumulator._0993_ VGND VGND VPWR VPWR accumulator._1015_
+ sky130_fd_sc_hd__or2_1
XFILLER_0_32_116 VGND VGND VPWR VPWR sky130_fd_sc_hd__fill_1
Xoperator._104_ operator._002_ net11 VGND VGND VPWR VPWR operator._040_ sky130_fd_sc_hd__or2_4
XFILLER_0_13_385 VGND VGND VPWR VPWR sky130_fd_sc_hd__decap_6
Xaccumulator._1848_ accumulator._0660_ accumulator._0945_ VGND VGND VPWR VPWR accumulator._0946_
+ sky130_fd_sc_hd__xor2_4
Xaccumulator._1779_ accumulator._0788_ accumulator._0789_ VGND VGND VPWR VPWR accumulator._0877_
+ sky130_fd_sc_hd__nand2_1
XTAP_TAPCELL_ROW_28_347 VGND VPWR sky130_fd_sc_hd__tapvpwrvgnd_1
XFILLER_0_63_263 VPWR VGND VPWR VGND sky130_ef_sc_hd__decap_12
XFILLER_0_63_230 VGND VGND VPWR VPWR sky130_fd_sc_hd__decap_6
XFILLER_0_48_271 VPWR VGND VPWR VGND sky130_ef_sc_hd__decap_12
XFILLER_0_23_127 VGND VGND VPWR VPWR sky130_fd_sc_hd__decap_6
XFILLER_0_23_116 VGND VGND VPWR VPWR sky130_fd_sc_hd__decap_4
XTAP_TAPCELL_ROW_11_225 VGND VPWR sky130_fd_sc_hd__tapvpwrvgnd_1
XFILLER_0_31_182 VGND VGND VPWR VPWR sky130_fd_sc_hd__fill_2
XFILLER_0_31_160 VGND VGND VPWR VPWR sky130_fd_sc_hd__decap_3
XFILLER_0_14_138 VGND VGND VPWR VPWR sky130_fd_sc_hd__fill_2
Xaccumulator._1633_ accumulator._0450_ accumulator._0641_ accumulator._0644_ accumulator._0396_
+ VGND VGND VPWR VPWR accumulator._0731_ sky130_fd_sc_hd__a211oi_2
Xaccumulator._1702_ accumulator._0797_ accumulator._0798_ VGND VGND VPWR VPWR accumulator._0800_
+ sky130_fd_sc_hd__and2_1
Xaccumulator._1564_ accumulator.io_accOut\[2\] net65 accumulator._0575_ VGND VGND
+ VPWR VPWR accumulator._0662_ sky130_fd_sc_hd__and3_1
XFILLER_0_10_333 VPWR VGND VPWR VGND sky130_ef_sc_hd__decap_12
XFILLER_0_10_377 VPWR VGND VPWR VGND sky130_ef_sc_hd__decap_12
Xaccumulator._1495_ accumulator._0347_ accumulator._0412_ accumulator._0435_ VGND
+ VGND VPWR VPWR accumulator._0593_ sky130_fd_sc_hd__o21ai_1
Xaccumulator._2116_ accumulator._0100_ accumulator._0084_ accumulator._0047_ VGND
+ VGND VPWR VPWR accumulator._0101_ sky130_fd_sc_hd__mux2_2
Xaccumulator._2047_ accumulator._1143_ accumulator._1144_ accumulator._1127_ VGND
+ VGND VPWR VPWR accumulator._1145_ sky130_fd_sc_hd__mux2_4
XFILLER_0_45_296 VPWR VGND VPWR VGND sky130_ef_sc_hd__decap_12
XFILLER_0_45_252 VGND VGND VPWR VPWR sky130_fd_sc_hd__decap_6
XFILLER_0_60_277 VGND VGND VPWR VPWR sky130_fd_sc_hd__decap_8
XFILLER_0_5_393 VPWR VGND VPWR VGND sky130_ef_sc_hd__decap_12
XFILLER_0_68_377 VPWR VGND VPWR VGND sky130_ef_sc_hd__decap_12
XFILLER_0_68_333 VGND VGND VPWR VPWR sky130_fd_sc_hd__decap_3
XFILLER_0_22_38 VPWR VGND VPWR VGND sky130_ef_sc_hd__decap_12
XFILLER_0_51_277 VGND VGND VPWR VPWR sky130_fd_sc_hd__decap_3
XFILLER_0_51_233 VGND VGND VPWR VPWR sky130_fd_sc_hd__fill_2
XscaleAdd._552_ scaleAdd._207_ scaleAdd._209_ scaleAdd._214_ scaleAdd._218_ VGND VGND
+ VPWR VPWR scaleAdd._219_ sky130_fd_sc_hd__a31o_1
XFILLER_0_47_79 VPWR VGND VPWR VGND sky130_ef_sc_hd__decap_12
XscaleAdd._483_ operator.io_outExp\[0\] scaleAdd._154_ scaleAdd._155_ VGND VGND VPWR
+ VPWR scaleAdd._156_ sky130_fd_sc_hd__nand3_1
XFILLER_0_63_78 VGND VGND VPWR VPWR sky130_fd_sc_hd__fill_1
XFILLER_0_59_333 VGND VGND VPWR VPWR sky130_fd_sc_hd__decap_3
XTAP_TAPCELL_ROW_47_475 VGND VPWR sky130_fd_sc_hd__tapvpwrvgnd_1
Xaccumulator._1280_ accumulator._0329_ accumulator._0328_ VGND VGND VPWR VPWR accumulator._0378_
+ sky130_fd_sc_hd__nand2_1
XFILLER_0_2_15 VPWR VGND VPWR VGND sky130_ef_sc_hd__decap_12
XFILLER_0_42_222 VPWR VGND VPWR VGND sky130_ef_sc_hd__decap_12
XFILLER_0_12_60 VPWR VGND VPWR VGND sky130_ef_sc_hd__decap_12
XFILLER_0_56_3 VPWR VGND VPWR VGND sky130_ef_sc_hd__decap_12
XFILLER_0_42_244 VGND VGND VPWR VPWR sky130_fd_sc_hd__fill_1
XPHY_EDGE_ROW_34_Left_103 VGND VGND VPWR VPWR sky130_fd_sc_hd__decap_3
XFILLER_0_2_363 VGND VGND VPWR VPWR sky130_fd_sc_hd__fill_1
XFILLER_0_10_141 VPWR VGND VPWR VGND sky130_ef_sc_hd__decap_12
XFILLER_0_12_93 VGND VGND VPWR VPWR sky130_fd_sc_hd__fill_2
Xaccumulator._1616_ accumulator._0712_ accumulator._0713_ VGND VGND VPWR VPWR accumulator._0714_
+ sky130_fd_sc_hd__xor2_1
Xaccumulator._1547_ accumulator._0450_ accumulator._0641_ accumulator._0644_ accumulator._0447_
+ VGND VGND VPWR VPWR accumulator._0645_ sky130_fd_sc_hd__a211o_1
XPHY_EDGE_ROW_43_Left_112 VGND VGND VPWR VPWR sky130_fd_sc_hd__decap_3
Xaccumulator._1478_ accumulator.io_accOut\[7\] net65 accumulator._0412_ accumulator._0575_
+ VGND VGND VPWR VPWR accumulator._0576_ sky130_fd_sc_hd__and4_1
XFILLER_0_33_233 VGND VGND VPWR VPWR sky130_fd_sc_hd__fill_2
XFILLER_0_33_222 VGND VGND VPWR VPWR sky130_fd_sc_hd__fill_2
XPHY_EDGE_ROW_52_Left_121 VGND VGND VPWR VPWR sky130_fd_sc_hd__decap_3
XPHY_EDGE_ROW_61_Left_130 VGND VGND VPWR VPWR sky130_fd_sc_hd__decap_3
XFILLER_0_33_15 VPWR VGND VPWR VGND sky130_ef_sc_hd__decap_12
XFILLER_0_68_141 VPWR VGND VPWR VGND sky130_ef_sc_hd__decap_12
XTAP_TAPCELL_ROW_44_456 VGND VPWR sky130_fd_sc_hd__tapvpwrvgnd_1
Xinput13 io_inScaleA[0] VGND VGND VPWR VPWR net13 sky130_fd_sc_hd__clkbuf_4
Xinput24 io_inScaleB[6] VGND VGND VPWR VPWR net24 sky130_fd_sc_hd__buf_1
XscaleAdd._535_ scaleAdd._186_ scaleAdd._188_ scaleAdd._202_ VGND VGND VPWR VPWR scaleAdd._204_
+ sky130_fd_sc_hd__or3_1
XFILLER_0_24_233 VGND VGND VPWR VPWR sky130_fd_sc_hd__decap_8
XscaleAdd._466_ scaleAdd._106_ scaleAdd._127_ scaleAdd._142_ net81 scaleAdd._128_
+ VGND VGND VPWR VPWR scaleAdd._143_ sky130_fd_sc_hd__o2111ai_2
Xaccumulator._1401_ accumulator._0306_ accumulator._0461_ VGND VGND VPWR VPWR accumulator._0499_
+ sky130_fd_sc_hd__and2_1
XscaleAdd._397_ scaleAdd._068_ scaleAdd._076_ VGND VGND VPWR VPWR scaleAdd._077_ sky130_fd_sc_hd__xnor2_1
Xaccumulator._1263_ net26 net28 VGND VGND VPWR VPWR accumulator._0361_ sky130_fd_sc_hd__or2_1
Xaccumulator._1332_ accumulator._0306_ accumulator._0424_ accumulator._0428_ accumulator._0429_
+ VGND VGND VPWR VPWR accumulator._0430_ sky130_fd_sc_hd__a2bb2o_1
Xaccumulator._1194_ accumulator._0292_ accumulator._0289_ net68 accumulator._0293_
+ accumulator._0285_ VGND VGND VPWR VPWR accumulator._0294_ sky130_fd_sc_hd__o32a_4
XFILLER_0_2_193 VGND VGND VPWR VPWR sky130_fd_sc_hd__decap_3
XFILLER_0_3_91 VGND VGND VPWR VPWR sky130_fd_sc_hd__fill_1
XFILLER_0_65_100 VGND VGND VPWR VPWR sky130_fd_sc_hd__fill_1
XTAP_TAPCELL_ROW_41_437 VGND VPWR sky130_fd_sc_hd__tapvpwrvgnd_1
XFILLER_0_46_391 VGND VGND VPWR VPWR sky130_fd_sc_hd__fill_1
XPHY_EDGE_ROW_5_Left_74 VGND VGND VPWR VPWR sky130_fd_sc_hd__decap_3
XscaleAdd._320_ scaleAdd._001_ scaleAdd._002_ VGND VGND VPWR VPWR scaleAdd._003_ sky130_fd_sc_hd__xor2_1
XFILLER_0_21_225 VGND VGND VPWR VPWR sky130_fd_sc_hd__fill_2
XFILLER_0_21_269 VGND VGND VPWR VPWR sky130_fd_sc_hd__decap_8
XFILLER_0_28_15 VPWR VGND VPWR VGND sky130_ef_sc_hd__decap_12
XTAP_TAPCELL_ROW_6_192 VGND VPWR sky130_fd_sc_hd__tapvpwrvgnd_1
Xaccumulator._1950_ accumulator._0933_ accumulator._1047_ VGND VGND VPWR VPWR accumulator._1048_
+ sky130_fd_sc_hd__xnor2_1
XFILLER_0_12_203 VGND VGND VPWR VPWR sky130_fd_sc_hd__fill_1
Xaccumulator._1881_ accumulator._0815_ accumulator._0536_ accumulator._0824_ VGND
+ VGND VPWR VPWR accumulator._0979_ sky130_fd_sc_hd__and3_1
XscaleAdd._518_ scaleAdd._173_ scaleAdd._183_ scaleAdd._187_ VGND VGND VPWR VPWR scaleAdd._188_
+ sky130_fd_sc_hd__o21a_1
XscaleAdd._449_ scaleAdd._125_ scaleAdd._126_ VGND VGND VPWR VPWR accumulator.io_inMant\[11\]
+ sky130_fd_sc_hd__xnor2_2
XFILLER_0_20_280 VGND VGND VPWR VPWR sky130_fd_sc_hd__fill_1
Xaccumulator._1315_ accumulator._0412_ VGND VGND VPWR VPWR accumulator._0413_ sky130_fd_sc_hd__buf_2
Xaccumulator._2295_ clknet_2_2__leaf_clock accumulator._0002_ VGND VGND VPWR VPWR
+ accumulator.io_accOut\[0\] sky130_fd_sc_hd__dfxtp_1
Xaccumulator._1246_ accumulator._0345_ accumulator._0343_ VGND VGND VPWR VPWR accumulator._0346_
+ sky130_fd_sc_hd__xnor2_4
Xaccumulator._1177_ accumulator._0276_ accumulator.io_inExp\[3\] VGND VGND VPWR VPWR
+ accumulator._0277_ sky130_fd_sc_hd__or2_4
XFILLER_0_53_169 VGND VGND VPWR VPWR sky130_fd_sc_hd__decap_4
XscaleAdd._303_ scaleAdd._251_ scaleAdd._252_ VGND VGND VPWR VPWR scaleAdd._253_ sky130_fd_sc_hd__nor2_1
XFILLER_0_55_57 VGND VGND VPWR VPWR sky130_fd_sc_hd__fill_2
XTAP_TAPCELL_ROW_60_565 VGND VPWR sky130_fd_sc_hd__tapvpwrvgnd_1
Xaccumulator._2080_ accumulator._0061_ accumulator._0066_ VGND VGND VPWR VPWR accumulator._0067_
+ sky130_fd_sc_hd__nor2_1
XFILLER_0_29_144 VPWR VGND VPWR VGND sky130_ef_sc_hd__decap_12
Xoperator._120_ operator._053_ VGND VGND VPWR VPWR operator.io_outMant\[6\] sky130_fd_sc_hd__clkbuf_2
XTAP_TAPCELL_ROW_17_264 VGND VPWR sky130_fd_sc_hd__tapvpwrvgnd_1
XFILLER_0_17_328 VGND VGND VPWR VPWR sky130_fd_sc_hd__decap_8
Xaccumulator._1864_ accumulator._0856_ accumulator._0858_ accumulator._0862_ accumulator._0815_
+ VGND VGND VPWR VPWR accumulator._0962_ sky130_fd_sc_hd__o211a_1
XFILLER_0_40_342 VPWR VGND VPWR VGND sky130_ef_sc_hd__decap_12
Xaccumulator._1933_ accumulator._0357_ accumulator._1030_ VGND VGND VPWR VPWR accumulator._1031_
+ sky130_fd_sc_hd__nand2_1
XFILLER_0_32_309 VGND VGND VPWR VPWR sky130_fd_sc_hd__decap_6
XFILLER_0_4_233 VGND VGND VPWR VPWR sky130_fd_sc_hd__fill_1
XTAP_TAPCELL_ROW_68_621 VGND VPWR sky130_fd_sc_hd__tapvpwrvgnd_1
Xaccumulator._1795_ accumulator._0817_ accumulator._0807_ accumulator._0410_ VGND
+ VGND VPWR VPWR accumulator._0893_ sky130_fd_sc_hd__and3_1
XFILLER_0_40_397 VGND VGND VPWR VPWR sky130_fd_sc_hd__decap_8
XTAP_TAPCELL_ROW_68_632 VGND VPWR sky130_fd_sc_hd__tapvpwrvgnd_1
XTAP_TAPCELL_ROW_0_143 VGND VPWR sky130_fd_sc_hd__tapvpwrvgnd_1
Xaccumulator._2278_ accumulator.io_accOut\[29\] accumulator._0258_ accumulator._0356_
+ VGND VGND VPWR VPWR accumulator._0260_ sky130_fd_sc_hd__mux2_1
XFILLER_0_35_169 VPWR VGND VPWR VGND sky130_ef_sc_hd__decap_12
Xaccumulator._1229_ accumulator._0317_ net66 accumulator.io_accOut\[24\] VGND VGND
+ VPWR VPWR accumulator._0329_ sky130_fd_sc_hd__o21ai_1
XFILLER_0_0_81 VGND VGND VPWR VPWR sky130_fd_sc_hd__decap_3
XFILLER_0_50_128 VPWR VGND VPWR VGND sky130_ef_sc_hd__decap_12
XFILLER_0_31_364 VGND VGND VPWR VPWR sky130_fd_sc_hd__fill_2
XFILLER_0_8_3 VGND VGND VPWR VPWR sky130_fd_sc_hd__decap_8
XFILLER_0_41_15 VPWR VGND VPWR VGND sky130_ef_sc_hd__decap_12
XTAP_TAPCELL_ROW_14_245 VGND VPWR sky130_fd_sc_hd__tapvpwrvgnd_1
XFILLER_0_22_342 VGND VGND VPWR VPWR sky130_fd_sc_hd__decap_4
XFILLER_0_14_309 VGND VGND VPWR VPWR sky130_fd_sc_hd__decap_8
Xaccumulator._1580_ accumulator.io_accOut\[1\] accumulator._0354_ accumulator._0575_
+ accumulator._0470_ VGND VGND VPWR VPWR accumulator._0678_ sky130_fd_sc_hd__a31o_1
XFILLER_0_5_15 VGND VGND VPWR VPWR sky130_fd_sc_hd__fill_2
XFILLER_0_1_247 VGND VGND VPWR VPWR sky130_fd_sc_hd__decap_3
XTAP_TAPCELL_ROW_65_602 VGND VPWR sky130_fd_sc_hd__tapvpwrvgnd_1
Xaccumulator._2132_ accumulator._0085_ accumulator._0116_ accumulator._0035_ VGND
+ VGND VPWR VPWR accumulator._0117_ sky130_fd_sc_hd__mux2_4
Xaccumulator._2201_ accumulator._0068_ VGND VGND VPWR VPWR accumulator._0184_ sky130_fd_sc_hd__inv_2
XFILLER_0_60_404 VGND VGND VPWR VPWR sky130_fd_sc_hd__decap_4
XFILLER_0_57_261 VGND VGND VPWR VPWR sky130_fd_sc_hd__decap_6
Xaccumulator._2063_ accumulator._0047_ accumulator._1144_ accumulator._0048_ VGND
+ VGND VPWR VPWR accumulator._0049_ sky130_fd_sc_hd__o21ai_2
Xoperator._103_ operator._027_ operator._039_ VGND VGND VPWR VPWR operator.io_outMant\[3\]
+ sky130_fd_sc_hd__xnor2_4
XFILLER_0_17_125 VGND VGND VPWR VPWR sky130_fd_sc_hd__decap_6
XFILLER_0_17_169 VGND VGND VPWR VPWR sky130_fd_sc_hd__decap_8
Xaccumulator._1847_ accumulator._0815_ accumulator._0828_ accumulator._0943_ accumulator._0944_
+ VGND VGND VPWR VPWR accumulator._0945_ sky130_fd_sc_hd__a31o_1
Xaccumulator._1916_ accumulator._0891_ accumulator._0900_ VGND VGND VPWR VPWR accumulator._1014_
+ sky130_fd_sc_hd__nor2_4
XFILLER_0_40_150 VGND VGND VPWR VPWR sky130_fd_sc_hd__decap_8
XFILLER_0_32_139 VGND VGND VPWR VPWR sky130_fd_sc_hd__fill_1
XFILLER_0_13_331 VGND VGND VPWR VPWR sky130_fd_sc_hd__decap_4
Xaccumulator._1778_ accumulator._0778_ accumulator._0875_ accumulator._0787_ VGND
+ VGND VPWR VPWR accumulator._0876_ sky130_fd_sc_hd__or3_4
XFILLER_0_63_275 VGND VGND VPWR VPWR sky130_fd_sc_hd__decap_4
XFILLER_0_48_283 VGND VGND VPWR VPWR sky130_fd_sc_hd__fill_1
XTAP_TAPCELL_ROW_11_226 VGND VPWR sky130_fd_sc_hd__tapvpwrvgnd_1
XFILLER_0_36_15 VPWR VGND VPWR VGND sky130_ef_sc_hd__decap_12
XFILLER_0_54_220 VPWR VGND VPWR VGND sky130_ef_sc_hd__decap_12
Xaccumulator._1701_ accumulator._0797_ accumulator._0798_ VGND VGND VPWR VPWR accumulator._0799_
+ sky130_fd_sc_hd__or2_1
Xaccumulator._1632_ accumulator._0566_ accumulator._0729_ VGND VGND VPWR VPWR accumulator._0730_
+ sky130_fd_sc_hd__and2_1
Xaccumulator._1494_ accumulator._0588_ accumulator._0591_ accumulator._0447_ VGND
+ VGND VPWR VPWR accumulator._0592_ sky130_fd_sc_hd__a21oi_1
Xaccumulator._1563_ accumulator._0553_ accumulator._0561_ accumulator._0446_ VGND
+ VGND VPWR VPWR accumulator._0661_ sky130_fd_sc_hd__a21o_1
XFILLER_0_10_345 VPWR VGND VPWR VGND sky130_ef_sc_hd__decap_12
XFILLER_0_10_389 VPWR VGND VPWR VGND sky130_ef_sc_hd__decap_12
Xaccumulator._2115_ accumulator._1098_ accumulator._0099_ accumulator._1120_ VGND
+ VGND VPWR VPWR accumulator._0100_ sky130_fd_sc_hd__mux2_1
XFILLER_0_26_81 VGND VGND VPWR VPWR sky130_fd_sc_hd__decap_3
XFILLER_0_9_111 VGND VGND VPWR VPWR sky130_fd_sc_hd__fill_1
XFILLER_0_18_401 VGND VGND VPWR VPWR sky130_fd_sc_hd__decap_8
XFILLER_0_60_212 VPWR VGND VPWR VGND sky130_ef_sc_hd__decap_12
Xaccumulator._2046_ accumulator._1069_ accumulator._1064_ net94 VGND VGND VPWR VPWR
+ accumulator._1144_ sky130_fd_sc_hd__mux2_4
XFILLER_0_45_264 VPWR VGND VPWR VGND sky130_ef_sc_hd__decap_12
XFILLER_0_33_404 VGND VGND VPWR VPWR sky130_fd_sc_hd__decap_4
XFILLER_0_5_361 VPWR VGND VPWR VGND sky130_ef_sc_hd__decap_12
XFILLER_0_9_177 VGND VGND VPWR VPWR sky130_fd_sc_hd__decap_6
XFILLER_0_68_389 VGND VGND VPWR VPWR sky130_fd_sc_hd__decap_3
XFILLER_0_36_253 VGND VGND VPWR VPWR sky130_fd_sc_hd__decap_8
XscaleAdd._551_ scaleAdd._197_ scaleAdd._200_ scaleAdd._203_ VGND VGND VPWR VPWR scaleAdd._218_
+ sky130_fd_sc_hd__and3_1
XscaleAdd._482_ net16 net21 VGND VGND VPWR VPWR scaleAdd._155_ sky130_fd_sc_hd__or2_1
XTAP_TAPCELL_ROW_47_476 VGND VPWR sky130_fd_sc_hd__tapvpwrvgnd_1
XFILLER_0_2_27 VGND VGND VPWR VPWR sky130_fd_sc_hd__fill_1
XFILLER_0_42_234 VGND VGND VPWR VPWR sky130_fd_sc_hd__decap_3
XFILLER_0_27_297 VGND VGND VPWR VPWR sky130_fd_sc_hd__decap_3
XFILLER_0_27_220 VGND VGND VPWR VPWR sky130_fd_sc_hd__decap_4
XFILLER_0_6_169 VGND VGND VPWR VPWR sky130_fd_sc_hd__fill_2
XFILLER_0_12_72 VPWR VGND VPWR VGND sky130_ef_sc_hd__decap_12
XFILLER_0_10_153 VPWR VGND VPWR VGND sky130_ef_sc_hd__decap_12
Xaccumulator._1615_ accumulator.io_accOut\[8\] accumulator._0349_ VGND VGND VPWR VPWR
+ accumulator._0713_ sky130_fd_sc_hd__nand2_1
Xaccumulator._1546_ accumulator._0512_ accumulator._0642_ accumulator._0643_ VGND
+ VGND VPWR VPWR accumulator._0644_ sky130_fd_sc_hd__and3_1
XFILLER_0_49_3 VPWR VGND VPWR VGND sky130_ef_sc_hd__decap_12
Xaccumulator._1477_ accumulator._0452_ VGND VGND VPWR VPWR accumulator._0575_ sky130_fd_sc_hd__clkbuf_2
XFILLER_0_10_197 VPWR VGND VPWR VGND sky130_ef_sc_hd__decap_12
XFILLER_0_65_348 VPWR VGND VPWR VGND sky130_ef_sc_hd__decap_12
XFILLER_0_65_337 VGND VGND VPWR VPWR sky130_fd_sc_hd__decap_4
Xaccumulator._2029_ accumulator._1122_ accumulator._1125_ accumulator._1127_ VGND
+ VGND VPWR VPWR accumulator._1128_ sky130_fd_sc_hd__mux2_4
XFILLER_0_18_253 VGND VGND VPWR VPWR sky130_fd_sc_hd__decap_8
XFILLER_0_33_278 VGND VGND VPWR VPWR sky130_fd_sc_hd__fill_2
XFILLER_0_68_153 VPWR VGND VPWR VGND sky130_ef_sc_hd__decap_12
XFILLER_0_33_27 VPWR VGND VPWR VGND sky130_ef_sc_hd__decap_12
XFILLER_0_68_197 VPWR VGND VPWR VGND sky130_ef_sc_hd__decap_12
XTAP_TAPCELL_ROW_44_457 VGND VPWR sky130_fd_sc_hd__tapvpwrvgnd_1
Xinput25 io_inScaleB[7] VGND VGND VPWR VPWR net25 sky130_fd_sc_hd__clkbuf_1
XFILLER_0_3_106 VGND VGND VPWR VPWR sky130_fd_sc_hd__decap_3
Xinput14 io_inScaleA[1] VGND VGND VPWR VPWR net14 sky130_fd_sc_hd__buf_1
XscaleAdd._534_ scaleAdd._186_ scaleAdd._188_ scaleAdd._202_ VGND VGND VPWR VPWR scaleAdd._203_
+ sky130_fd_sc_hd__o21ai_1
XscaleAdd._465_ scaleAdd._129_ scaleAdd._141_ VGND VGND VPWR VPWR scaleAdd._142_ sky130_fd_sc_hd__xor2_2
Xaccumulator._1400_ accumulator._0475_ accumulator._0497_ accumulator._0413_ VGND
+ VGND VPWR VPWR accumulator._0498_ sky130_fd_sc_hd__a21o_1
Xaccumulator._1331_ net83 accumulator._0044_ accumulator._0074_ VGND VGND VPWR VPWR
+ accumulator._0429_ sky130_fd_sc_hd__o21ai_2
XscaleAdd._396_ scaleAdd._069_ scaleAdd._075_ VGND VGND VPWR VPWR scaleAdd._076_ sky130_fd_sc_hd__xnor2_2
Xaccumulator._1262_ accumulator._0360_ VGND VGND VPWR VPWR accumulator._0001_ sky130_fd_sc_hd__clkbuf_1
Xaccumulator._1193_ accumulator.io_inExp\[6\] accumulator.io_inExp\[5\] accumulator.io_inExp\[7\]
+ VGND VGND VPWR VPWR accumulator._0293_ sky130_fd_sc_hd__o21ai_1
XFILLER_0_15_234 VGND VGND VPWR VPWR sky130_fd_sc_hd__decap_8
XPHY_EDGE_ROW_21_Left_90 VGND VGND VPWR VPWR sky130_fd_sc_hd__decap_3
XFILLER_0_30_248 VGND VGND VPWR VPWR sky130_fd_sc_hd__fill_1
Xaccumulator._1529_ accumulator._0446_ accumulator._0511_ accumulator._0532_ VGND
+ VGND VPWR VPWR accumulator._0627_ sky130_fd_sc_hd__nor3_1
XFILLER_0_3_81 VGND VGND VPWR VPWR sky130_fd_sc_hd__decap_4
XFILLER_0_65_156 VPWR VGND VPWR VGND sky130_ef_sc_hd__decap_12
XFILLER_0_65_145 VGND VGND VPWR VPWR sky130_fd_sc_hd__decap_6
XTAP_TAPCELL_ROW_41_438 VGND VPWR sky130_fd_sc_hd__tapvpwrvgnd_1
XFILLER_0_61_351 VPWR VGND VPWR VGND sky130_ef_sc_hd__decap_12
XFILLER_0_44_15 VPWR VGND VPWR VGND sky130_ef_sc_hd__decap_12
XFILLER_0_28_27 VGND VGND VPWR VPWR sky130_fd_sc_hd__fill_1
XTAP_TAPCELL_ROW_6_193 VGND VPWR sky130_fd_sc_hd__tapvpwrvgnd_1
XFILLER_0_56_145 VGND VGND VPWR VPWR sky130_fd_sc_hd__fill_2
XFILLER_0_56_123 VGND VGND VPWR VPWR sky130_fd_sc_hd__fill_1
XFILLER_0_29_315 VPWR VGND VPWR VGND sky130_ef_sc_hd__decap_12
Xaccumulator._1880_ accumulator._0727_ accumulator._0724_ VGND VGND VPWR VPWR accumulator._0978_
+ sky130_fd_sc_hd__and2_1
XFILLER_0_37_381 VGND VGND VPWR VPWR sky130_fd_sc_hd__fill_2
XFILLER_0_8_26 VGND VGND VPWR VPWR sky130_fd_sc_hd__fill_2
XFILLER_0_8_37 VGND VGND VPWR VPWR sky130_fd_sc_hd__fill_2
XscaleAdd._517_ scaleAdd._185_ scaleAdd._186_ VGND VGND VPWR VPWR scaleAdd._187_ sky130_fd_sc_hd__nor2_1
XscaleAdd._379_ scaleAdd._029_ scaleAdd._032_ scaleAdd._054_ VGND VGND VPWR VPWR scaleAdd._059_
+ sky130_fd_sc_hd__a21o_1
XscaleAdd._448_ scaleAdd._103_ scaleAdd._106_ scaleAdd._102_ VGND VGND VPWR VPWR scaleAdd._126_
+ sky130_fd_sc_hd__a21oi_1
X_19_ accumulator.io_accOut\[19\] VGND VGND VPWR VPWR net39 sky130_fd_sc_hd__clkbuf_1
Xaccumulator._2294_ clknet_2_1__leaf_clock accumulator._0001_ VGND VGND VPWR VPWR
+ accumulator.state\[1\] sky130_fd_sc_hd__dfxtp_1
Xaccumulator._1314_ net75 accumulator._0380_ VGND VGND VPWR VPWR accumulator._0412_
+ sky130_fd_sc_hd__and2_1
Xaccumulator._1245_ accumulator.io_accOut\[30\] accumulator._0344_ VGND VGND VPWR
+ VPWR accumulator._0345_ sky130_fd_sc_hd__xnor2_4
XFILLER_0_18_82 VGND VGND VPWR VPWR sky130_fd_sc_hd__fill_2
XFILLER_0_47_167 VGND VGND VPWR VPWR sky130_fd_sc_hd__fill_1
XFILLER_0_47_134 VPWR VGND VPWR VGND sky130_ef_sc_hd__decap_12
XFILLER_0_47_101 VGND VGND VPWR VPWR sky130_fd_sc_hd__decap_8
Xclone39 accumulator._1119_ VGND VGND VPWR VPWR net102 sky130_fd_sc_hd__clkbuf_16
XFILLER_0_28_392 VGND VGND VPWR VPWR sky130_fd_sc_hd__fill_1
Xaccumulator._1176_ accumulator._0064_ net82 VGND VGND VPWR VPWR accumulator._0276_
+ sky130_fd_sc_hd__nor2_8
XFILLER_0_11_281 VPWR VGND VPWR VGND sky130_ef_sc_hd__decap_12
XFILLER_0_26_318 VGND VGND VPWR VPWR sky130_fd_sc_hd__decap_8
XFILLER_0_39_15 VPWR VGND VPWR VGND sky130_ef_sc_hd__decap_12
XscaleAdd._302_ operator.io_outMant\[1\] scaleAdd._239_ scaleAdd._250_ VGND VGND VPWR
+ VPWR scaleAdd._252_ sky130_fd_sc_hd__a21oi_1
XTAP_TAPCELL_ROW_60_566 VGND VPWR sky130_fd_sc_hd__tapvpwrvgnd_1
XFILLER_0_44_115 VGND VGND VPWR VPWR sky130_fd_sc_hd__fill_1
XFILLER_0_29_156 VGND VGND VPWR VPWR sky130_fd_sc_hd__decap_4
XFILLER_0_29_134 VGND VGND VPWR VPWR sky130_fd_sc_hd__fill_1
XTAP_TAPCELL_ROW_17_265 VGND VPWR sky130_fd_sc_hd__tapvpwrvgnd_1
Xaccumulator._1863_ accumulator._0860_ accumulator._0960_ VGND VGND VPWR VPWR accumulator._0961_
+ sky130_fd_sc_hd__xnor2_2
Xaccumulator._1932_ accumulator._1009_ accumulator._1024_ accumulator._1029_ VGND
+ VGND VPWR VPWR accumulator._1030_ sky130_fd_sc_hd__or3b_4
XFILLER_0_44_159 VGND VGND VPWR VPWR sky130_fd_sc_hd__fill_2
XFILLER_0_40_354 VGND VGND VPWR VPWR sky130_fd_sc_hd__decap_8
XTAP_TAPCELL_ROW_68_633 VGND VPWR sky130_fd_sc_hd__tapvpwrvgnd_1
XTAP_TAPCELL_ROW_68_622 VGND VPWR sky130_fd_sc_hd__tapvpwrvgnd_1
Xaccumulator._1794_ accumulator._0367_ accumulator._0813_ accumulator._0891_ VGND
+ VGND VPWR VPWR accumulator._0892_ sky130_fd_sc_hd__a21o_1
XFILLER_0_67_207 VGND VGND VPWR VPWR sky130_fd_sc_hd__decap_3
Xaccumulator._1228_ accumulator.io_accOut\[24\] accumulator._0317_ accumulator._0321_
+ VGND VGND VPWR VPWR accumulator._0328_ sky130_fd_sc_hd__or3_4
XTAP_TAPCELL_ROW_0_144 VGND VPWR sky130_fd_sc_hd__tapvpwrvgnd_1
Xaccumulator._2277_ accumulator._0299_ VGND VGND VPWR VPWR accumulator._0258_ sky130_fd_sc_hd__inv_2
XFILLER_0_35_148 VGND VGND VPWR VPWR sky130_fd_sc_hd__decap_6
XFILLER_0_35_137 VGND VGND VPWR VPWR sky130_fd_sc_hd__decap_4
Xaccumulator._1159_ accumulator.io_inMant\[8\] accumulator.io_inMant\[7\] VGND VGND
+ VPWR VPWR accumulator._0142_ sky130_fd_sc_hd__nor2_1
XFILLER_0_16_351 VGND VGND VPWR VPWR sky130_fd_sc_hd__fill_1
XFILLER_0_43_181 VGND VGND VPWR VPWR sky130_fd_sc_hd__decap_8
XFILLER_0_31_343 VGND VGND VPWR VPWR sky130_fd_sc_hd__fill_1
XFILLER_0_25_39 VPWR VGND VPWR VGND sky130_ef_sc_hd__decap_12
XFILLER_0_58_229 VPWR VGND VPWR VGND sky130_ef_sc_hd__decap_12
XFILLER_0_41_27 VPWR VGND VPWR VGND sky130_ef_sc_hd__decap_12
XTAP_TAPCELL_ROW_14_246 VGND VPWR sky130_fd_sc_hd__tapvpwrvgnd_1
XFILLER_0_1_204 VGND VGND VPWR VPWR sky130_fd_sc_hd__fill_1
XTAP_TAPCELL_ROW_65_603 VGND VPWR sky130_fd_sc_hd__tapvpwrvgnd_1
Xaccumulator._2062_ accumulator._1141_ accumulator._0047_ VGND VGND VPWR VPWR accumulator._0048_
+ sky130_fd_sc_hd__or2b_1
Xaccumulator._2131_ accumulator._0115_ VGND VGND VPWR VPWR accumulator._0116_ sky130_fd_sc_hd__inv_2
Xaccumulator._2200_ accumulator._0180_ accumulator._0182_ accumulator._0183_ VGND
+ VGND VPWR VPWR accumulator._0021_ sky130_fd_sc_hd__a21oi_1
XFILLER_0_45_402 VGND VGND VPWR VPWR sky130_fd_sc_hd__decap_3
Xoperator._102_ operator._037_ operator._038_ VGND VGND VPWR VPWR operator._039_ sky130_fd_sc_hd__and2b_1
XFILLER_0_9_337 VPWR VGND VPWR VGND sky130_ef_sc_hd__decap_12
XFILLER_0_17_148 VGND VGND VPWR VPWR sky130_fd_sc_hd__decap_3
XFILLER_0_17_159 VGND VGND VPWR VPWR sky130_fd_sc_hd__fill_1
Xaccumulator._1777_ accumulator._0827_ accumulator._0869_ accumulator._0868_ accumulator._0867_
+ accumulator._0874_ VGND VGND VPWR VPWR accumulator._0875_ sky130_fd_sc_hd__o41a_1
Xaccumulator._1846_ accumulator._0365_ accumulator._0638_ accumulator._0704_ VGND
+ VGND VPWR VPWR accumulator._0944_ sky130_fd_sc_hd__and3_1
Xaccumulator._1915_ accumulator._1001_ accumulator._1012_ VGND VGND VPWR VPWR accumulator._1013_
+ sky130_fd_sc_hd__xnor2_2
XFILLER_0_40_195 VGND VGND VPWR VPWR sky130_fd_sc_hd__fill_1
XFILLER_0_0_281 VPWR VGND VPWR VGND sky130_ef_sc_hd__decap_12
XTAP_TAPCELL_ROW_11_227 VGND VPWR sky130_fd_sc_hd__tapvpwrvgnd_1
XFILLER_0_16_181 VPWR VGND VPWR VGND sky130_ef_sc_hd__decap_12
XFILLER_0_36_27 VGND VGND VPWR VPWR sky130_fd_sc_hd__fill_1
XFILLER_0_52_15 VPWR VGND VPWR VGND sky130_ef_sc_hd__decap_12
XFILLER_0_54_232 VPWR VGND VPWR VGND sky130_ef_sc_hd__decap_12
Xaccumulator._1631_ accumulator._0717_ accumulator._0723_ accumulator._0724_ accumulator._0725_
+ accumulator._0728_ VGND VGND VPWR VPWR accumulator._0729_ sky130_fd_sc_hd__a2111o_1
Xaccumulator._1700_ accumulator.io_accOut\[21\] accumulator._0468_ accumulator._0355_
+ VGND VGND VPWR VPWR accumulator._0798_ sky130_fd_sc_hd__mux2_1
XFILLER_0_10_357 VGND VGND VPWR VPWR sky130_fd_sc_hd__decap_6
Xaccumulator._1562_ accumulator._0658_ accumulator._0659_ VGND VGND VPWR VPWR accumulator._0660_
+ sky130_fd_sc_hd__or2b_2
Xaccumulator._1493_ accumulator._0589_ accumulator._0590_ accumulator._0400_ VGND
+ VGND VPWR VPWR accumulator._0591_ sky130_fd_sc_hd__a21o_1
Xaccumulator._2114_ accumulator._1084_ VGND VGND VPWR VPWR accumulator._0099_ sky130_fd_sc_hd__inv_2
Xaccumulator._2045_ accumulator._1071_ accumulator._1058_ net94 VGND VGND VPWR VPWR
+ accumulator._1143_ sky130_fd_sc_hd__mux2_4
XFILLER_0_60_246 VGND VGND VPWR VPWR sky130_fd_sc_hd__decap_6
XFILLER_0_60_224 VGND VGND VPWR VPWR sky130_fd_sc_hd__decap_8
XFILLER_0_60_202 VGND VGND VPWR VPWR sky130_fd_sc_hd__decap_4
XFILLER_0_45_276 VGND VGND VPWR VPWR sky130_fd_sc_hd__decap_4
XFILLER_0_5_373 VPWR VGND VPWR VGND sky130_ef_sc_hd__decap_12
Xaccumulator._1829_ accumulator._0585_ accumulator._0709_ accumulator._0716_ VGND
+ VGND VPWR VPWR accumulator._0927_ sky130_fd_sc_hd__o21ai_1
XFILLER_0_13_184 VPWR VGND VPWR VGND sky130_ef_sc_hd__decap_12
XFILLER_0_36_265 VGND VGND VPWR VPWR sky130_fd_sc_hd__decap_4
XFILLER_0_22_18 VGND VGND VPWR VPWR sky130_fd_sc_hd__decap_8
XFILLER_0_22_29 VGND VGND VPWR VPWR sky130_fd_sc_hd__decap_4
XscaleAdd._550_ operator.io_outExp\[4\] scaleAdd._217_ VGND VGND VPWR VPWR accumulator.io_inExp\[5\]
+ sky130_fd_sc_hd__xor2_2
XscaleAdd._481_ net16 net21 VGND VGND VPWR VPWR scaleAdd._154_ sky130_fd_sc_hd__nand2_1
XFILLER_0_47_15 VPWR VGND VPWR VGND sky130_ef_sc_hd__decap_12
XFILLER_0_2_39 VGND VGND VPWR VPWR sky130_fd_sc_hd__decap_4
XFILLER_0_59_379 VPWR VGND VPWR VGND sky130_ef_sc_hd__decap_12
XTAP_TAPCELL_ROW_47_477 VGND VPWR sky130_fd_sc_hd__tapvpwrvgnd_1
XFILLER_0_42_202 VGND VGND VPWR VPWR sky130_fd_sc_hd__fill_1
XTAP_TAPCELL_ROW_30_355 VGND VPWR sky130_fd_sc_hd__tapvpwrvgnd_1
XFILLER_0_2_321 VPWR VGND VPWR VGND sky130_ef_sc_hd__decap_12
XFILLER_0_6_137 VGND VGND VPWR VPWR sky130_fd_sc_hd__decap_3
Xaccumulator._1614_ accumulator._0447_ accumulator._0710_ accumulator._0711_ VGND
+ VGND VPWR VPWR accumulator._0712_ sky130_fd_sc_hd__o21ba_1
XFILLER_0_2_365 VPWR VGND VPWR VGND sky130_ef_sc_hd__decap_12
XFILLER_0_10_165 VPWR VGND VPWR VGND sky130_ef_sc_hd__decap_12
Xaccumulator._1545_ accumulator._0547_ accumulator._0548_ accumulator._0439_ VGND
+ VGND VPWR VPWR accumulator._0643_ sky130_fd_sc_hd__a21o_1
XTAP_TAPCELL_ROW_38_411 VGND VPWR sky130_fd_sc_hd__tapvpwrvgnd_1
Xaccumulator._1476_ accumulator._0347_ accumulator._0404_ VGND VGND VPWR VPWR accumulator._0574_
+ sky130_fd_sc_hd__nor2_1
Xaccumulator._2028_ accumulator._1096_ VGND VGND VPWR VPWR accumulator._1127_ sky130_fd_sc_hd__clkbuf_4
XFILLER_0_68_165 VGND VGND VPWR VPWR sky130_fd_sc_hd__decap_3
XFILLER_0_56_305 VGND VGND VPWR VPWR sky130_fd_sc_hd__decap_3
XTAP_TAPCELL_ROW_44_458 VGND VPWR sky130_fd_sc_hd__tapvpwrvgnd_1
XFILLER_0_33_39 VGND VGND VPWR VPWR sky130_fd_sc_hd__fill_1
Xinput15 io_inScaleA[2] VGND VGND VPWR VPWR net15 sky130_fd_sc_hd__dlymetal6s2s_1
Xinput26 io_resetAcc VGND VGND VPWR VPWR net26 sky130_fd_sc_hd__buf_1
XscaleAdd._533_ scaleAdd._200_ scaleAdd._201_ VGND VGND VPWR VPWR scaleAdd._202_ sky130_fd_sc_hd__and2_1
XscaleAdd._464_ scaleAdd._135_ scaleAdd._139_ scaleAdd._140_ VGND VGND VPWR VPWR scaleAdd._141_
+ sky130_fd_sc_hd__mux2_1
XscaleAdd._395_ scaleAdd._074_ scaleAdd._070_ VGND VGND VPWR VPWR scaleAdd._075_ sky130_fd_sc_hd__xnor2_2
Xaccumulator._1261_ net28 accumulator.state\[0\] VGND VGND VPWR VPWR accumulator._0360_
+ sky130_fd_sc_hd__and2b_1
Xaccumulator._1330_ accumulator._0425_ accumulator._0426_ accumulator._0427_ VGND
+ VGND VPWR VPWR accumulator._0428_ sky130_fd_sc_hd__mux2_1
XFILLER_0_59_198 VGND VGND VPWR VPWR sky130_fd_sc_hd__fill_1
XFILLER_0_59_176 VGND VGND VPWR VPWR sky130_fd_sc_hd__decap_3
XFILLER_0_47_349 VGND VGND VPWR VPWR sky130_fd_sc_hd__fill_1
Xaccumulator._1192_ accumulator._0291_ VGND VGND VPWR VPWR accumulator._0292_ sky130_fd_sc_hd__inv_2
XFILLER_0_61_3 VPWR VGND VPWR VGND sky130_ef_sc_hd__decap_12
XFILLER_0_15_213 VGND VGND VPWR VPWR sky130_fd_sc_hd__decap_8
XFILLER_0_15_279 VGND VGND VPWR VPWR sky130_fd_sc_hd__fill_1
Xaccumulator._1528_ accumulator._0623_ accumulator._0625_ VGND VGND VPWR VPWR accumulator._0626_
+ sky130_fd_sc_hd__or2_1
XFILLER_0_38_305 VGND VGND VPWR VPWR sky130_fd_sc_hd__decap_3
Xaccumulator._1459_ accumulator._0285_ accumulator._0514_ VGND VGND VPWR VPWR accumulator._0557_
+ sky130_fd_sc_hd__nor2_1
XFILLER_0_61_363 VPWR VGND VPWR VGND sky130_ef_sc_hd__decap_12
XTAP_TAPCELL_ROW_57_550 VGND VPWR sky130_fd_sc_hd__tapvpwrvgnd_1
XFILLER_0_44_27 VGND VGND VPWR VPWR sky130_fd_sc_hd__fill_1
XFILLER_0_60_15 VPWR VGND VPWR VGND sky130_ef_sc_hd__decap_12
XFILLER_0_56_157 VPWR VGND VPWR VGND sky130_ef_sc_hd__decap_12
XFILLER_0_29_327 VGND VGND VPWR VPWR sky130_fd_sc_hd__decap_8
XFILLER_0_52_385 VGND VGND VPWR VPWR sky130_fd_sc_hd__decap_3
XscaleAdd._516_ net18 net23 scaleAdd._184_ VGND VGND VPWR VPWR scaleAdd._186_ sky130_fd_sc_hd__and3_1
XFILLER_0_12_249 VGND VGND VPWR VPWR sky130_fd_sc_hd__decap_3
XscaleAdd._447_ scaleAdd._123_ scaleAdd._124_ VGND VGND VPWR VPWR scaleAdd._125_ sky130_fd_sc_hd__nor2_1
XscaleAdd._378_ scaleAdd._056_ net98 VGND VGND VPWR VPWR accumulator.io_inMant\[8\]
+ sky130_fd_sc_hd__xor2_2
XFILLER_0_20_293 VGND VGND VPWR VPWR sky130_fd_sc_hd__decap_4
Xaccumulator._1313_ accumulator._0400_ VGND VGND VPWR VPWR accumulator._0411_ sky130_fd_sc_hd__buf_2
XFILLER_0_47_113 VPWR VGND VPWR VGND sky130_ef_sc_hd__decap_12
X_18_ accumulator.io_accOut\[18\] VGND VGND VPWR VPWR net38 sky130_fd_sc_hd__buf_1
Xaccumulator._2293_ clknet_2_2__leaf_clock accumulator._0000_ VGND VGND VPWR VPWR
+ accumulator.io_accOut\[31\] sky130_fd_sc_hd__dfxtp_2
XFILLER_0_34_60 VGND VGND VPWR VPWR sky130_fd_sc_hd__decap_8
XFILLER_0_26_6 VPWR VGND VPWR VGND sky130_ef_sc_hd__decap_12
Xaccumulator._1244_ accumulator._0297_ accumulator._0305_ VGND VGND VPWR VPWR accumulator._0344_
+ sky130_fd_sc_hd__nor2_2
XTAP_TAPCELL_ROW_63_586 VGND VPWR sky130_fd_sc_hd__tapvpwrvgnd_1
XFILLER_0_62_149 VGND VGND VPWR VPWR sky130_fd_sc_hd__decap_3
Xclone29 accumulator._1118_ VGND VGND VPWR VPWR net92 sky130_fd_sc_hd__buf_6
XFILLER_0_47_146 VGND VGND VPWR VPWR sky130_fd_sc_hd__decap_6
XFILLER_0_43_330 VGND VGND VPWR VPWR sky130_fd_sc_hd__decap_6
Xaccumulator._1175_ accumulator._0093_ accumulator._0269_ accumulator._0274_ VGND
+ VGND VPWR VPWR accumulator._0275_ sky130_fd_sc_hd__a21oi_1
XFILLER_0_11_293 VPWR VGND VPWR VGND sky130_ef_sc_hd__decap_12
XFILLER_0_38_179 VGND VGND VPWR VPWR sky130_fd_sc_hd__decap_3
XFILLER_0_30_29 VGND VGND VPWR VPWR sky130_fd_sc_hd__decap_3
XFILLER_0_30_18 VGND VGND VPWR VPWR sky130_fd_sc_hd__decap_8
XFILLER_0_19_393 VPWR VGND VPWR VGND sky130_ef_sc_hd__decap_12
XFILLER_0_55_15 VPWR VGND VPWR VGND sky130_ef_sc_hd__decap_12
XFILLER_0_39_49 VGND VGND VPWR VPWR sky130_fd_sc_hd__fill_1
XFILLER_0_39_27 VPWR VGND VPWR VGND sky130_ef_sc_hd__decap_12
XscaleAdd._301_ operator.io_outMant\[1\] scaleAdd._239_ scaleAdd._250_ VGND VGND VPWR
+ VPWR scaleAdd._251_ sky130_fd_sc_hd__and3_1
XTAP_TAPCELL_ROW_60_567 VGND VPWR sky130_fd_sc_hd__tapvpwrvgnd_1
XTAP_TAPCELL_ROW_17_266 VGND VPWR sky130_fd_sc_hd__tapvpwrvgnd_1
XFILLER_0_17_308 VGND VGND VPWR VPWR sky130_fd_sc_hd__decap_4
Xaccumulator._1862_ accumulator._0815_ accumulator._0709_ accumulator._0929_ VGND
+ VGND VPWR VPWR accumulator._0960_ sky130_fd_sc_hd__o21a_1
Xaccumulator._1931_ accumulator._1026_ accumulator._1028_ VGND VGND VPWR VPWR accumulator._1029_
+ sky130_fd_sc_hd__nor2_1
XFILLER_0_52_182 VGND VGND VPWR VPWR sky130_fd_sc_hd__decap_3
Xaccumulator._1793_ accumulator._0890_ accumulator._0889_ accumulator._0816_ VGND
+ VGND VPWR VPWR accumulator._0891_ sky130_fd_sc_hd__and3_4
XTAP_TAPCELL_ROW_68_634 VGND VPWR sky130_fd_sc_hd__tapvpwrvgnd_1
XTAP_TAPCELL_ROW_68_623 VGND VPWR sky130_fd_sc_hd__tapvpwrvgnd_1
XFILLER_0_24_3 VPWR VGND VPWR VGND sky130_ef_sc_hd__decap_12
Xaccumulator._1227_ accumulator.io_accOut\[23\] accumulator._0321_ accumulator._0316_
+ VGND VGND VPWR VPWR accumulator._0327_ sky130_fd_sc_hd__or3_4
XTAP_TAPCELL_ROW_0_145 VGND VPWR sky130_fd_sc_hd__tapvpwrvgnd_1
Xaccumulator._1158_ accumulator.io_inMant\[2\] accumulator.io_inMant\[1\] accumulator._0122_
+ VGND VGND VPWR VPWR accumulator._0132_ sky130_fd_sc_hd__o21a_1
Xaccumulator._2276_ accumulator._0252_ accumulator._0248_ accumulator._0256_ accumulator._0237_
+ VGND VGND VPWR VPWR accumulator._0257_ sky130_fd_sc_hd__a22o_1
XFILLER_0_16_363 VGND VGND VPWR VPWR sky130_fd_sc_hd__fill_1
XFILLER_0_16_385 VPWR VGND VPWR VGND sky130_ef_sc_hd__decap_12
XPHY_EDGE_ROW_17_Right_17 VGND VGND VPWR VPWR sky130_fd_sc_hd__decap_3
XPHY_EDGE_ROW_26_Right_26 VGND VGND VPWR VPWR sky130_fd_sc_hd__decap_3
XTAP_TAPCELL_ROW_8_201 VGND VPWR sky130_fd_sc_hd__tapvpwrvgnd_1
XFILLER_0_25_18 VGND VGND VPWR VPWR sky130_fd_sc_hd__decap_6
XFILLER_0_54_403 VGND VGND VPWR VPWR sky130_fd_sc_hd__fill_2
XFILLER_0_41_39 VGND VGND VPWR VPWR sky130_fd_sc_hd__decap_4
XPHY_EDGE_ROW_35_Right_35 VGND VGND VPWR VPWR sky130_fd_sc_hd__decap_3
XTAP_TAPCELL_ROW_14_247 VGND VPWR sky130_fd_sc_hd__tapvpwrvgnd_1
XFILLER_0_41_119 VGND VGND VPWR VPWR sky130_fd_sc_hd__decap_6
XFILLER_0_22_399 VGND VGND VPWR VPWR sky130_fd_sc_hd__decap_6
XFILLER_0_1_216 VGND VGND VPWR VPWR sky130_fd_sc_hd__fill_1
XTAP_TAPCELL_ROW_65_604 VGND VPWR sky130_fd_sc_hd__tapvpwrvgnd_1
XPHY_EDGE_ROW_44_Right_44 VGND VGND VPWR VPWR sky130_fd_sc_hd__decap_3
Xaccumulator._2061_ accumulator._1127_ VGND VGND VPWR VPWR accumulator._0047_ sky130_fd_sc_hd__clkbuf_4
XPHY_EDGE_ROW_53_Right_53 VGND VGND VPWR VPWR sky130_fd_sc_hd__decap_3
Xaccumulator._2130_ accumulator._1097_ accumulator._0100_ accumulator._0114_ VGND
+ VGND VPWR VPWR accumulator._0115_ sky130_fd_sc_hd__a21oi_1
XFILLER_0_9_305 VPWR VGND VPWR VGND sky130_ef_sc_hd__decap_12
XFILLER_0_9_349 VPWR VGND VPWR VGND sky130_ef_sc_hd__decap_12
XFILLER_0_57_285 VGND VGND VPWR VPWR sky130_fd_sc_hd__fill_1
Xaccumulator._1914_ accumulator._0903_ accumulator._0997_ VGND VGND VPWR VPWR accumulator._1012_
+ sky130_fd_sc_hd__nand2_1
XFILLER_0_31_94 VGND VGND VPWR VPWR sky130_fd_sc_hd__decap_8
Xoperator._101_ operator._036_ operator._034_ VGND VGND VPWR VPWR operator._038_ sky130_fd_sc_hd__or2b_4
XPHY_EDGE_ROW_62_Right_62 VGND VGND VPWR VPWR sky130_fd_sc_hd__decap_3
Xaccumulator._1776_ accumulator._0770_ accumulator._0873_ VGND VGND VPWR VPWR accumulator._0874_
+ sky130_fd_sc_hd__or2b_1
Xaccumulator._1845_ accumulator._0833_ accumulator._0853_ accumulator._0854_ VGND
+ VGND VPWR VPWR accumulator._0943_ sky130_fd_sc_hd__a21o_1
XFILLER_0_40_174 VGND VGND VPWR VPWR sky130_fd_sc_hd__decap_4
XFILLER_0_0_293 VGND VGND VPWR VPWR sky130_fd_sc_hd__decap_8
XTAP_TAPCELL_ROW_11_228 VGND VPWR sky130_fd_sc_hd__tapvpwrvgnd_1
Xaccumulator._2259_ accumulator._0238_ accumulator._0240_ VGND VGND VPWR VPWR accumulator._0241_
+ sky130_fd_sc_hd__nand2_1
XFILLER_0_51_406 VGND VGND VPWR VPWR sky130_fd_sc_hd__decap_3
XFILLER_0_31_152 VGND VGND VPWR VPWR sky130_fd_sc_hd__decap_8
XFILLER_0_16_193 VGND VGND VPWR VPWR sky130_fd_sc_hd__decap_3
XFILLER_0_52_27 VGND VGND VPWR VPWR sky130_fd_sc_hd__fill_1
XFILLER_0_54_244 VGND VGND VPWR VPWR sky130_fd_sc_hd__fill_1
XFILLER_0_39_263 VGND VGND VPWR VPWR sky130_fd_sc_hd__fill_1
Xaccumulator._1630_ accumulator._0726_ accumulator._0727_ VGND VGND VPWR VPWR accumulator._0728_
+ sky130_fd_sc_hd__nor2b_1
Xaccumulator._1561_ accumulator._0656_ accumulator._0657_ VGND VGND VPWR VPWR accumulator._0659_
+ sky130_fd_sc_hd__nand2_1
XFILLER_0_22_141 VGND VGND VPWR VPWR sky130_fd_sc_hd__fill_2
Xaccumulator._1492_ accumulator._0498_ accumulator._0501_ accumulator._0439_ VGND
+ VGND VPWR VPWR accumulator._0590_ sky130_fd_sc_hd__a21o_1
Xaccumulator._2044_ accumulator._1097_ accumulator._1141_ VGND VGND VPWR VPWR accumulator._1142_
+ sky130_fd_sc_hd__or2_4
XFILLER_0_45_200 VGND VGND VPWR VPWR sky130_fd_sc_hd__decap_8
Xaccumulator._2113_ accumulator._0094_ accumulator._0098_ accumulator._0362_ VGND
+ VGND VPWR VPWR accumulator._0010_ sky130_fd_sc_hd__a21oi_1
XFILLER_0_9_113 VGND VGND VPWR VPWR sky130_fd_sc_hd__decap_3
XFILLER_0_5_385 VGND VGND VPWR VPWR sky130_fd_sc_hd__decap_6
XFILLER_0_13_141 VGND VGND VPWR VPWR sky130_fd_sc_hd__fill_1
XFILLER_0_13_152 VPWR VGND VPWR VGND sky130_ef_sc_hd__decap_12
Xaccumulator._1828_ accumulator._0745_ accumulator._0925_ VGND VGND VPWR VPWR accumulator._0926_
+ sky130_fd_sc_hd__xor2_2
Xaccumulator._1759_ accumulator._0606_ accumulator._0607_ VGND VGND VPWR VPWR accumulator._0857_
+ sky130_fd_sc_hd__and2_1
XFILLER_0_13_196 VPWR VGND VPWR VGND sky130_ef_sc_hd__decap_12
XFILLER_0_51_225 VGND VGND VPWR VPWR sky130_fd_sc_hd__decap_8
XFILLER_0_36_288 VGND VGND VPWR VPWR sky130_fd_sc_hd__fill_1
XFILLER_0_36_222 VGND VGND VPWR VPWR sky130_fd_sc_hd__fill_1
XFILLER_0_47_27 VPWR VGND VPWR VGND sky130_ef_sc_hd__decap_12
XscaleAdd._480_ scaleAdd._221_ operator.io_outMant\[2\] scaleAdd._226_ net63 VGND
+ VGND VPWR VPWR accumulator.io_inMant\[2\] sky130_fd_sc_hd__a22o_1
XFILLER_0_63_15 VPWR VGND VPWR VGND sky130_ef_sc_hd__decap_12
XFILLER_0_2_29 VGND VGND VPWR VPWR sky130_fd_sc_hd__decap_3
XFILLER_0_67_391 VGND VGND VPWR VPWR sky130_fd_sc_hd__fill_1
XTAP_TAPCELL_ROW_47_478 VGND VPWR sky130_fd_sc_hd__tapvpwrvgnd_1
XTAP_TAPCELL_ROW_30_356 VGND VPWR sky130_fd_sc_hd__tapvpwrvgnd_1
XFILLER_0_2_333 VPWR VGND VPWR VGND sky130_ef_sc_hd__decap_12
XFILLER_0_6_149 VPWR VGND VPWR VGND sky130_ef_sc_hd__decap_12
XFILLER_0_12_85 VGND VGND VPWR VPWR sky130_fd_sc_hd__decap_8
XFILLER_0_50_291 VPWR VGND VPWR VGND sky130_ef_sc_hd__decap_12
Xaccumulator._1613_ accumulator._0447_ accumulator._0686_ accumulator._0687_ accumulator._0389_
+ VGND VGND VPWR VPWR accumulator._0711_ sky130_fd_sc_hd__a31o_1
Xaccumulator._1544_ accumulator._0539_ accumulator._0540_ accumulator._0473_ VGND
+ VGND VPWR VPWR accumulator._0642_ sky130_fd_sc_hd__a21o_1
XFILLER_0_2_377 VPWR VGND VPWR VGND sky130_ef_sc_hd__decap_12
XFILLER_0_10_111 VPWR VGND VPWR VGND sky130_ef_sc_hd__decap_12
XFILLER_0_10_177 VGND VGND VPWR VPWR sky130_fd_sc_hd__decap_6
XTAP_TAPCELL_ROW_38_412 VGND VPWR sky130_fd_sc_hd__tapvpwrvgnd_1
Xaccumulator._1475_ accumulator._0470_ accumulator._0453_ accumulator._0558_ VGND
+ VGND VPWR VPWR accumulator._0573_ sky130_fd_sc_hd__and3_1
Xaccumulator._2027_ accumulator._1123_ accumulator._1069_ accumulator._1124_ VGND
+ VGND VPWR VPWR accumulator._1125_ sky130_fd_sc_hd__mux2_1
XFILLER_0_33_225 VGND VGND VPWR VPWR sky130_fd_sc_hd__decap_8
XFILLER_0_18_211 VGND VGND VPWR VPWR sky130_fd_sc_hd__decap_4
XFILLER_0_18_266 VGND VGND VPWR VPWR sky130_fd_sc_hd__decap_4
XFILLER_0_49_391 VGND VGND VPWR VPWR sky130_fd_sc_hd__fill_1
XTAP_TAPCELL_ROW_44_459 VGND VPWR sky130_fd_sc_hd__tapvpwrvgnd_1
XscaleAdd._532_ net19 net24 scaleAdd._197_ scaleAdd._198_ VGND VGND VPWR VPWR scaleAdd._201_
+ sky130_fd_sc_hd__a22o_1
Xinput27 io_start VGND VGND VPWR VPWR net27 sky130_fd_sc_hd__clkbuf_1
Xinput16 io_inScaleA[3] VGND VGND VPWR VPWR net16 sky130_fd_sc_hd__buf_1
XFILLER_0_58_59 VGND VGND VPWR VPWR sky130_fd_sc_hd__fill_1
XFILLER_0_58_15 VPWR VGND VPWR VGND sky130_ef_sc_hd__decap_12
XscaleAdd._463_ scaleAdd._115_ scaleAdd._116_ VGND VGND VPWR VPWR scaleAdd._140_ sky130_fd_sc_hd__or2_1
XscaleAdd._394_ scaleAdd._072_ scaleAdd._073_ VGND VGND VPWR VPWR scaleAdd._074_ sky130_fd_sc_hd__and2b_1
XFILLER_0_59_111 VGND VGND VPWR VPWR sky130_fd_sc_hd__fill_1
Xaccumulator._1260_ accumulator.io_inSign accumulator._0349_ accumulator._0351_ accumulator._0352_
+ accumulator._0359_ VGND VGND VPWR VPWR accumulator._0000_ sky130_fd_sc_hd__o311a_1
Xaccumulator._1191_ accumulator.io_inExp\[7\] accumulator._0290_ VGND VGND VPWR VPWR
+ accumulator._0291_ sky130_fd_sc_hd__xnor2_1
XFILLER_0_62_309 VGND VGND VPWR VPWR sky130_fd_sc_hd__decap_3
XFILLER_0_23_62 VGND VGND VPWR VPWR sky130_fd_sc_hd__fill_2
XFILLER_0_23_51 VGND VGND VPWR VPWR sky130_fd_sc_hd__fill_2
XFILLER_0_2_141 VPWR VGND VPWR VGND sky130_ef_sc_hd__decap_12
Xaccumulator._1527_ accumulator._0622_ accumulator._0624_ VGND VGND VPWR VPWR accumulator._0625_
+ sky130_fd_sc_hd__and2b_1
XFILLER_0_54_3 VPWR VGND VPWR VGND sky130_ef_sc_hd__decap_12
XFILLER_0_38_339 VGND VGND VPWR VPWR sky130_fd_sc_hd__fill_1
Xaccumulator._1458_ net70 accumulator._0508_ accumulator._0455_ VGND VGND VPWR VPWR
+ accumulator._0556_ sky130_fd_sc_hd__a21o_1
Xaccumulator._1389_ accumulator._0273_ accumulator._0485_ accumulator._0486_ VGND
+ VGND VPWR VPWR accumulator._0487_ sky130_fd_sc_hd__o21a_1
XFILLER_0_61_375 VPWR VGND VPWR VGND sky130_ef_sc_hd__decap_12
XFILLER_0_61_342 VGND VGND VPWR VPWR sky130_fd_sc_hd__fill_1
XFILLER_0_61_331 VGND VGND VPWR VPWR sky130_fd_sc_hd__decap_4
XFILLER_0_46_361 VGND VGND VPWR VPWR sky130_fd_sc_hd__decap_3
XFILLER_0_60_27 VGND VGND VPWR VPWR sky130_fd_sc_hd__fill_1
XFILLER_0_44_309 VGND VGND VPWR VPWR sky130_fd_sc_hd__decap_6
XscaleAdd._515_ net18 net23 scaleAdd._184_ VGND VGND VPWR VPWR scaleAdd._185_ sky130_fd_sc_hd__a21oi_1
XFILLER_0_8_17 VGND VGND VPWR VPWR sky130_fd_sc_hd__decap_3
XFILLER_0_12_217 VPWR VGND VPWR VGND sky130_ef_sc_hd__decap_12
XscaleAdd._446_ scaleAdd._121_ scaleAdd._100_ scaleAdd._086_ VGND VGND VPWR VPWR scaleAdd._124_
+ sky130_fd_sc_hd__and3_1
XscaleAdd._377_ scaleAdd._057_ scaleAdd._038_ scaleAdd._036_ VGND VGND VPWR VPWR scaleAdd._058_
+ sky130_fd_sc_hd__a21o_1
XTAP_TAPCELL_ROW_63_587 VGND VPWR sky130_fd_sc_hd__tapvpwrvgnd_1
Xaccumulator._1312_ accumulator._0371_ accumulator._0409_ VGND VGND VPWR VPWR accumulator._0410_
+ sky130_fd_sc_hd__nor2b_2
X_17_ accumulator.io_accOut\[17\] VGND VGND VPWR VPWR net37 sky130_fd_sc_hd__buf_1
XFILLER_0_34_83 VGND VGND VPWR VPWR sky130_fd_sc_hd__fill_1
Xaccumulator._2292_ net111 net27 accumulator._0351_ accumulator._0272_ VGND VGND VPWR
+ VPWR accumulator._0033_ sky130_fd_sc_hd__o211a_1
Xaccumulator._1174_ accumulator.io_inExp\[2\] accumulator._0273_ VGND VGND VPWR VPWR
+ accumulator._0274_ sky130_fd_sc_hd__and2_1
Xaccumulator._1243_ accumulator._0300_ accumulator._0341_ accumulator._0342_ VGND
+ VGND VPWR VPWR accumulator._0343_ sky130_fd_sc_hd__a21o_4
XFILLER_0_19_6 VPWR VGND VPWR VGND sky130_ef_sc_hd__decap_12
XFILLER_0_62_139 VGND VGND VPWR VPWR sky130_fd_sc_hd__fill_1
Xclone1 accumulator._0345_ accumulator._0343_ VGND VGND VPWR VPWR net64 sky130_fd_sc_hd__xnor2_2
XFILLER_0_66_401 VGND VGND VPWR VPWR sky130_fd_sc_hd__decap_8
XFILLER_0_26_309 VGND VGND VPWR VPWR sky130_fd_sc_hd__decap_3
XPHY_EDGE_ROW_9_Left_78 VGND VGND VPWR VPWR sky130_fd_sc_hd__decap_3
XFILLER_0_39_39 VGND VGND VPWR VPWR sky130_fd_sc_hd__decap_4
XscaleAdd._300_ net13 operator.io_outMant\[2\] scaleAdd._224_ scaleAdd._226_ operator.io_outMant\[3\]
+ VGND VGND VPWR VPWR scaleAdd._250_ sky130_fd_sc_hd__a32o_1
XFILLER_0_55_27 VPWR VGND VPWR VGND sky130_ef_sc_hd__decap_12
XTAP_TAPCELL_ROW_17_267 VGND VPWR sky130_fd_sc_hd__tapvpwrvgnd_1
XTAP_TAPCELL_ROW_60_568 VGND VPWR sky130_fd_sc_hd__tapvpwrvgnd_1
Xaccumulator._1930_ accumulator._1004_ accumulator._1027_ VGND VGND VPWR VPWR accumulator._1028_
+ sky130_fd_sc_hd__xnor2_2
XFILLER_0_44_139 VGND VGND VPWR VPWR sky130_fd_sc_hd__fill_1
XFILLER_0_4_247 VGND VGND VPWR VPWR sky130_fd_sc_hd__decap_4
XFILLER_0_20_52 VGND VGND VPWR VPWR sky130_fd_sc_hd__decap_3
Xaccumulator._1861_ accumulator._0942_ accumulator._0946_ accumulator._0949_ accumulator._0958_
+ VGND VGND VPWR VPWR accumulator._0959_ sky130_fd_sc_hd__or4b_4
XFILLER_0_52_194 VGND VGND VPWR VPWR sky130_fd_sc_hd__fill_2
Xaccumulator._1792_ accumulator._0884_ accumulator._0887_ accumulator._0886_ accumulator._0410_
+ accumulator._0885_ VGND VGND VPWR VPWR accumulator._0890_ sky130_fd_sc_hd__a311o_1
XscaleAdd._429_ scaleAdd._067_ scaleAdd._098_ scaleAdd._097_ VGND VGND VPWR VPWR scaleAdd._107_
+ sky130_fd_sc_hd__o21bai_2
XFILLER_0_20_85 VGND VGND VPWR VPWR sky130_fd_sc_hd__decap_8
XTAP_TAPCELL_ROW_68_624 VGND VPWR sky130_fd_sc_hd__tapvpwrvgnd_1
XFILLER_0_61_81 VGND VGND VPWR VPWR sky130_fd_sc_hd__decap_4
XTAP_TAPCELL_ROW_51_502 VGND VPWR sky130_fd_sc_hd__tapvpwrvgnd_1
XFILLER_0_35_128 VGND VGND VPWR VPWR sky130_fd_sc_hd__fill_2
Xaccumulator._1226_ accumulator.io_accOut\[25\] accumulator._0325_ VGND VGND VPWR
+ VPWR accumulator._0326_ sky130_fd_sc_hd__xnor2_4
XTAP_TAPCELL_ROW_0_146 VGND VPWR sky130_fd_sc_hd__tapvpwrvgnd_1
Xaccumulator._2275_ accumulator._0057_ accumulator._0251_ VGND VGND VPWR VPWR accumulator._0256_
+ sky130_fd_sc_hd__nor2_1
Xaccumulator._1157_ accumulator.io_inMant\[4\] accumulator.io_inMant\[3\] VGND VGND
+ VPWR VPWR accumulator._0122_ sky130_fd_sc_hd__nor2_1
XFILLER_0_31_378 VGND VGND VPWR VPWR sky130_fd_sc_hd__fill_1
XFILLER_0_31_356 VGND VGND VPWR VPWR sky130_fd_sc_hd__decap_8
XFILLER_0_31_334 VGND VGND VPWR VPWR sky130_fd_sc_hd__fill_2
XFILLER_0_28_180 VGND VGND VPWR VPWR sky130_fd_sc_hd__fill_2
XTAP_TAPCELL_ROW_8_202 VGND VPWR sky130_fd_sc_hd__tapvpwrvgnd_1
XFILLER_0_16_397 VGND VGND VPWR VPWR sky130_fd_sc_hd__decap_8
XFILLER_0_31_389 VGND VGND VPWR VPWR sky130_fd_sc_hd__decap_3
XFILLER_0_26_139 VGND VGND VPWR VPWR sky130_fd_sc_hd__fill_1
XTAP_TAPCELL_ROW_14_248 VGND VPWR sky130_fd_sc_hd__tapvpwrvgnd_1
XFILLER_0_66_15 VPWR VGND VPWR VGND sky130_ef_sc_hd__decap_12
XTAP_TAPCELL_ROW_65_605 VGND VPWR sky130_fd_sc_hd__tapvpwrvgnd_1
XPHY_EDGE_ROW_59_Left_128 VGND VGND VPWR VPWR sky130_fd_sc_hd__decap_3
Xaccumulator._2060_ accumulator._1138_ VGND VGND VPWR VPWR accumulator._0046_ sky130_fd_sc_hd__buf_2
Xoperator._100_ operator._034_ operator._036_ VGND VGND VPWR VPWR operator._037_ sky130_fd_sc_hd__and2b_1
XFILLER_0_9_317 VPWR VGND VPWR VGND sky130_ef_sc_hd__decap_12
XFILLER_0_15_30 VPWR VGND VPWR VGND sky130_ef_sc_hd__decap_12
XPHY_EDGE_ROW_68_Left_137 VGND VGND VPWR VPWR sky130_fd_sc_hd__decap_3
Xaccumulator._1913_ accumulator._1010_ accumulator._0911_ VGND VGND VPWR VPWR accumulator._1011_
+ sky130_fd_sc_hd__xnor2_4
Xaccumulator._1775_ accumulator._0758_ accumulator._0871_ accumulator._0872_ accumulator._0771_
+ VGND VGND VPWR VPWR accumulator._0873_ sky130_fd_sc_hd__o211ai_1
Xaccumulator._1844_ accumulator._0940_ accumulator._0941_ VGND VGND VPWR VPWR accumulator._0942_
+ sky130_fd_sc_hd__nor2_2
XFILLER_0_56_81 VGND VGND VPWR VPWR sky130_fd_sc_hd__decap_3
Xaccumulator._2258_ accumulator._0057_ accumulator._0237_ VGND VGND VPWR VPWR accumulator._0240_
+ sky130_fd_sc_hd__nand2_1
XFILLER_0_63_223 VGND VGND VPWR VPWR sky130_fd_sc_hd__fill_1
XFILLER_0_48_253 VPWR VGND VPWR VGND sky130_ef_sc_hd__decap_12
Xaccumulator._2189_ accumulator._0141_ accumulator._0172_ accumulator._0035_ VGND
+ VGND VPWR VPWR accumulator._0173_ sky130_fd_sc_hd__mux2_1
Xaccumulator._1209_ accumulator._0284_ accumulator._0308_ VGND VGND VPWR VPWR accumulator._0309_
+ sky130_fd_sc_hd__xor2_1
XFILLER_0_6_3 VGND VGND VPWR VPWR sky130_fd_sc_hd__fill_1
XFILLER_0_16_161 VGND VGND VPWR VPWR sky130_fd_sc_hd__decap_3
XFILLER_0_36_29 VPWR VGND VPWR VGND sky130_ef_sc_hd__decap_12
XFILLER_0_54_201 VPWR VGND VPWR VGND sky130_ef_sc_hd__decap_12
XFILLER_0_39_220 VGND VGND VPWR VPWR sky130_fd_sc_hd__decap_4
XTAP_TAPCELL_ROW_27_340 VGND VPWR sky130_fd_sc_hd__tapvpwrvgnd_1
XFILLER_0_22_153 VGND VGND VPWR VPWR sky130_fd_sc_hd__fill_1
XFILLER_0_6_309 VPWR VGND VPWR VGND sky130_ef_sc_hd__decap_12
Xaccumulator._1560_ accumulator._0656_ accumulator._0657_ VGND VGND VPWR VPWR accumulator._0658_
+ sky130_fd_sc_hd__nor2_1
Xaccumulator._2112_ accumulator._1139_ accumulator._0089_ accumulator._0097_ accumulator._1032_
+ VGND VGND VPWR VPWR accumulator._0098_ sky130_fd_sc_hd__o22a_1
Xaccumulator._1491_ accumulator._0527_ accumulator._0530_ accumulator._0473_ VGND
+ VGND VPWR VPWR accumulator._0589_ sky130_fd_sc_hd__a21o_1
XFILLER_0_26_73 VGND VGND VPWR VPWR sky130_fd_sc_hd__decap_8
Xaccumulator._2043_ accumulator._1033_ accumulator._1123_ accumulator._1124_ VGND
+ VGND VPWR VPWR accumulator._1141_ sky130_fd_sc_hd__mux2_2
XFILLER_0_42_83 VGND VGND VPWR VPWR sky130_fd_sc_hd__fill_1
XFILLER_0_42_50 VGND VGND VPWR VPWR sky130_fd_sc_hd__decap_3
XTAP_TAPCELL_ROW_33_376 VGND VPWR sky130_fd_sc_hd__tapvpwrvgnd_1
XFILLER_0_9_136 VPWR VGND VPWR VGND sky130_ef_sc_hd__decap_12
Xaccumulator._1827_ accumulator._0366_ accumulator._0764_ accumulator._0923_ accumulator._0924_
+ VGND VGND VPWR VPWR accumulator._0925_ sky130_fd_sc_hd__a31oi_2
XFILLER_0_13_164 VGND VGND VPWR VPWR sky130_fd_sc_hd__decap_4
Xaccumulator._1758_ accumulator._0853_ accumulator._0833_ accumulator._0829_ accumulator._0855_
+ VGND VGND VPWR VPWR accumulator._0856_ sky130_fd_sc_hd__a31o_4
Xaccumulator._1689_ accumulator._0785_ accumulator._0786_ VGND VGND VPWR VPWR accumulator._0787_
+ sky130_fd_sc_hd__nand2b_2
XFILLER_0_6_72 VGND VGND VPWR VPWR sky130_fd_sc_hd__fill_1
XFILLER_0_68_337 VPWR VGND VPWR VGND sky130_ef_sc_hd__decap_12
XFILLER_0_36_278 VGND VGND VPWR VPWR sky130_fd_sc_hd__fill_1
XFILLER_0_47_39 VPWR VGND VPWR VGND sky130_ef_sc_hd__decap_12
XFILLER_0_63_27 VPWR VGND VPWR VGND sky130_ef_sc_hd__decap_12
XFILLER_0_59_337 VGND VGND VPWR VPWR sky130_fd_sc_hd__decap_8
XTAP_TAPCELL_ROW_47_479 VGND VPWR sky130_fd_sc_hd__tapvpwrvgnd_1
XFILLER_0_27_256 VGND VGND VPWR VPWR sky130_fd_sc_hd__fill_2
XFILLER_0_6_117 VPWR VGND VPWR VGND sky130_ef_sc_hd__decap_12
XTAP_TAPCELL_ROW_30_357 VGND VPWR sky130_fd_sc_hd__tapvpwrvgnd_1
XFILLER_0_2_389 VPWR VGND VPWR VGND sky130_ef_sc_hd__decap_12
XFILLER_0_2_345 VPWR VGND VPWR VGND sky130_ef_sc_hd__decap_12
XFILLER_0_10_123 VPWR VGND VPWR VGND sky130_ef_sc_hd__decap_12
Xaccumulator._1612_ accumulator._0411_ accumulator._0654_ accumulator._0696_ VGND
+ VGND VPWR VPWR accumulator._0710_ sky130_fd_sc_hd__a21oi_1
Xaccumulator._1543_ accumulator._0639_ accumulator._0640_ VGND VGND VPWR VPWR accumulator._0641_
+ sky130_fd_sc_hd__and2_1
XFILLER_0_37_94 VGND VGND VPWR VPWR sky130_fd_sc_hd__decap_8
Xaccumulator._1474_ accumulator._0412_ accumulator._0453_ accumulator._0571_ VGND
+ VGND VPWR VPWR accumulator._0572_ sky130_fd_sc_hd__and3_1
XFILLER_0_65_318 VGND VGND VPWR VPWR sky130_fd_sc_hd__fill_2
XTAP_TAPCELL_ROW_38_413 VGND VPWR sky130_fd_sc_hd__tapvpwrvgnd_1
XFILLER_0_18_201 VGND VGND VPWR VPWR sky130_fd_sc_hd__fill_1
Xaccumulator._2026_ accumulator._1118_ VGND VGND VPWR VPWR accumulator._1124_ sky130_fd_sc_hd__buf_6
XFILLER_0_5_161 VGND VGND VPWR VPWR sky130_fd_sc_hd__decap_6
XFILLER_0_18_234 VGND VGND VPWR VPWR sky130_fd_sc_hd__decap_4
XFILLER_0_41_281 VGND VGND VPWR VPWR sky130_fd_sc_hd__decap_8
XFILLER_0_41_270 VGND VGND VPWR VPWR sky130_fd_sc_hd__decap_4
XFILLER_0_56_329 VPWR VGND VPWR VGND sky130_ef_sc_hd__decap_12
XFILLER_0_58_27 VGND VGND VPWR VPWR sky130_fd_sc_hd__fill_1
XscaleAdd._531_ scaleAdd._199_ VGND VGND VPWR VPWR scaleAdd._200_ sky130_fd_sc_hd__inv_2
Xinput28 reset VGND VGND VPWR VPWR net28 sky130_fd_sc_hd__dlymetal6s2s_1
XFILLER_0_24_248 VGND VGND VPWR VPWR sky130_fd_sc_hd__decap_4
XscaleAdd._462_ scaleAdd._137_ scaleAdd._138_ VGND VGND VPWR VPWR scaleAdd._139_ sky130_fd_sc_hd__and2_1
Xinput17 io_inScaleA[4] VGND VGND VPWR VPWR net17 sky130_fd_sc_hd__buf_1
XscaleAdd._393_ operator.io_outMant\[5\] scaleAdd._239_ scaleAdd._071_ VGND VGND VPWR
+ VPWR scaleAdd._073_ sky130_fd_sc_hd__a21o_1
XFILLER_0_59_167 VGND VGND VPWR VPWR sky130_fd_sc_hd__fill_1
XFILLER_0_47_329 VGND VGND VPWR VPWR sky130_fd_sc_hd__decap_6
Xaccumulator._1190_ accumulator.io_inExp\[6\] net78 VGND VGND VPWR VPWR accumulator._0290_
+ sky130_fd_sc_hd__nor2_1
XFILLER_0_23_281 VGND VGND VPWR VPWR sky130_fd_sc_hd__fill_1
XFILLER_0_2_197 VPWR VGND VPWR VGND sky130_ef_sc_hd__decap_12
XFILLER_0_2_153 VGND VGND VPWR VPWR sky130_fd_sc_hd__decap_6
Xaccumulator._1526_ accumulator.io_accOut\[6\] accumulator._0348_ VGND VGND VPWR VPWR
+ accumulator._0624_ sky130_fd_sc_hd__nand2_1
XFILLER_0_47_3 VPWR VGND VPWR VGND sky130_ef_sc_hd__decap_12
Xaccumulator._1457_ accumulator._0475_ accumulator._0505_ accumulator._0490_ VGND
+ VGND VPWR VPWR accumulator._0555_ sky130_fd_sc_hd__a21o_1
Xaccumulator._1388_ accumulator._0465_ accumulator._0463_ accumulator._0414_ VGND
+ VGND VPWR VPWR accumulator._0486_ sky130_fd_sc_hd__mux2_1
Xaccumulator._2009_ accumulator._1055_ accumulator._1106_ accumulator._1051_ VGND
+ VGND VPWR VPWR accumulator._1107_ sky130_fd_sc_hd__a21o_1
XFILLER_0_61_387 VGND VGND VPWR VPWR sky130_fd_sc_hd__decap_4
XFILLER_0_44_29 VPWR VGND VPWR VGND sky130_ef_sc_hd__decap_12
XTAP_TAPCELL_ROW_40_430 VGND VPWR sky130_fd_sc_hd__tapvpwrvgnd_1
XFILLER_0_8_29 VGND VGND VPWR VPWR sky130_fd_sc_hd__decap_8
XscaleAdd._514_ net19 net24 VGND VGND VPWR VPWR scaleAdd._184_ sky130_fd_sc_hd__xor2_1
XscaleAdd._445_ scaleAdd._122_ VGND VGND VPWR VPWR scaleAdd._123_ sky130_fd_sc_hd__inv_2
XFILLER_0_12_229 VGND VGND VPWR VPWR sky130_fd_sc_hd__decap_4
Xaccumulator._1311_ accumulator._0391_ accumulator._0396_ accumulator._0408_ VGND
+ VGND VPWR VPWR accumulator._0409_ sky130_fd_sc_hd__or3_1
XPHY_EDGE_ROW_40_Left_109 VGND VGND VPWR VPWR sky130_fd_sc_hd__decap_3
X_16_ accumulator.io_accOut\[16\] VGND VGND VPWR VPWR net36 sky130_fd_sc_hd__buf_1
Xaccumulator._2291_ net28 net61 VGND VGND VPWR VPWR accumulator._0272_ sky130_fd_sc_hd__nor2_1
XPHY_EDGE_ROW_25_Left_94 VGND VGND VPWR VPWR sky130_fd_sc_hd__decap_3
XscaleAdd._376_ scaleAdd._031_ scaleAdd._032_ scaleAdd._034_ VGND VGND VPWR VPWR scaleAdd._057_
+ sky130_fd_sc_hd__a21o_1
XFILLER_0_18_74 VGND VGND VPWR VPWR sky130_fd_sc_hd__decap_8
XFILLER_0_18_85 VPWR VGND VPWR VGND sky130_ef_sc_hd__decap_12
XTAP_TAPCELL_ROW_63_588 VGND VPWR sky130_fd_sc_hd__tapvpwrvgnd_1
Xaccumulator._1173_ accumulator._0083_ VGND VGND VPWR VPWR accumulator._0273_ sky130_fd_sc_hd__buf_4
XFILLER_0_7_201 VGND VGND VPWR VPWR sky130_fd_sc_hd__fill_1
XFILLER_0_7_223 VGND VGND VPWR VPWR sky130_fd_sc_hd__fill_1
Xaccumulator._1242_ accumulator.io_accOut\[29\] accumulator._0299_ VGND VGND VPWR
+ VPWR accumulator._0342_ sky130_fd_sc_hd__and2_1
XFILLER_0_55_181 VGND VGND VPWR VPWR sky130_fd_sc_hd__decap_8
XFILLER_0_50_50 VGND VGND VPWR VPWR sky130_fd_sc_hd__fill_2
XFILLER_0_28_362 VGND VGND VPWR VPWR sky130_fd_sc_hd__fill_2
XFILLER_0_59_81 VPWR VGND VPWR VGND sky130_ef_sc_hd__decap_12
XFILLER_0_11_273 VGND VGND VPWR VPWR sky130_fd_sc_hd__decap_6
Xaccumulator._1509_ accumulator.io_accOut\[5\] accumulator._0348_ VGND VGND VPWR VPWR
+ accumulator._0607_ sky130_fd_sc_hd__nand2_1
Xclone2 accumulator._0353_ VGND VGND VPWR VPWR net65 sky130_fd_sc_hd__buf_2
XTAP_TAPCELL_ROW_3_166 VGND VPWR sky130_fd_sc_hd__tapvpwrvgnd_1
XFILLER_0_38_148 VGND VGND VPWR VPWR sky130_fd_sc_hd__decap_6
XFILLER_0_55_39 VPWR VGND VPWR VGND sky130_ef_sc_hd__decap_12
XTAP_TAPCELL_ROW_17_268 VGND VPWR sky130_fd_sc_hd__tapvpwrvgnd_1
Xaccumulator._1860_ accumulator._0953_ accumulator._0957_ VGND VGND VPWR VPWR accumulator._0958_
+ sky130_fd_sc_hd__nor2_1
XTAP_TAPCELL_ROW_60_569 VGND VPWR sky130_fd_sc_hd__tapvpwrvgnd_1
XFILLER_0_37_192 VPWR VGND VPWR VGND sky130_ef_sc_hd__decap_12
Xaccumulator._1791_ accumulator._0817_ accumulator._0884_ accumulator._0410_ accumulator._0888_
+ VGND VGND VPWR VPWR accumulator._0889_ sky130_fd_sc_hd__o211ai_1
XFILLER_0_29_62 VPWR VGND VPWR VGND sky130_ef_sc_hd__decap_12
XscaleAdd._359_ scaleAdd._016_ scaleAdd._019_ VGND VGND VPWR VPWR scaleAdd._040_ sky130_fd_sc_hd__nand2_1
XscaleAdd._428_ scaleAdd._106_ scaleAdd._104_ VGND VGND VPWR VPWR accumulator.io_inMant\[10\]
+ sky130_fd_sc_hd__xnor2_2
XTAP_TAPCELL_ROW_68_625 VGND VPWR sky130_fd_sc_hd__tapvpwrvgnd_1
XFILLER_0_45_61 VGND VGND VPWR VPWR sky130_fd_sc_hd__fill_1
XFILLER_0_31_6 VPWR VGND VPWR VGND sky130_ef_sc_hd__decap_12
XTAP_TAPCELL_ROW_0_147 VGND VPWR sky130_fd_sc_hd__tapvpwrvgnd_1
Xaccumulator._2274_ net109 accumulator._0120_ accumulator._0352_ accumulator._0255_
+ VGND VGND VPWR VPWR accumulator._0030_ sky130_fd_sc_hd__o211a_1
XFILLER_0_63_405 VGND VGND VPWR VPWR sky130_fd_sc_hd__decap_4
XTAP_TAPCELL_ROW_51_503 VGND VPWR sky130_fd_sc_hd__tapvpwrvgnd_1
XFILLER_0_28_192 VGND VGND VPWR VPWR sky130_fd_sc_hd__decap_4
Xaccumulator._1225_ net96 net67 VGND VGND VPWR VPWR accumulator._0325_ sky130_fd_sc_hd__nor2_4
XPHY_EDGE_ROW_3_Right_3 VGND VGND VPWR VPWR sky130_fd_sc_hd__decap_3
XFILLER_0_0_41 VPWR VGND VPWR VGND sky130_ef_sc_hd__decap_12
Xaccumulator._1156_ accumulator.io_inMant\[12\] VGND VGND VPWR VPWR accumulator._0112_
+ sky130_fd_sc_hd__inv_2
XFILLER_0_16_321 VPWR VGND VPWR VGND sky130_ef_sc_hd__decap_12
Xaccumulator._1989_ accumulator._1014_ accumulator._0983_ VGND VGND VPWR VPWR accumulator._1087_
+ sky130_fd_sc_hd__or2_1
XFILLER_0_43_195 VGND VGND VPWR VPWR sky130_fd_sc_hd__fill_2
XFILLER_0_3_281 VPWR VGND VPWR VGND sky130_ef_sc_hd__decap_12
XTAP_TAPCELL_ROW_8_203 VGND VPWR sky130_fd_sc_hd__tapvpwrvgnd_1
XFILLER_0_16_365 VPWR VGND VPWR VGND sky130_ef_sc_hd__decap_12
XFILLER_0_34_195 VGND VGND VPWR VPWR sky130_fd_sc_hd__fill_1
XFILLER_0_34_151 VPWR VGND VPWR VGND sky130_ef_sc_hd__decap_12
XFILLER_0_22_324 VGND VGND VPWR VPWR sky130_fd_sc_hd__fill_1
XTAP_TAPCELL_ROW_14_249 VGND VPWR sky130_fd_sc_hd__tapvpwrvgnd_1
XFILLER_0_66_27 VGND VGND VPWR VPWR sky130_fd_sc_hd__fill_1
XTAP_TAPCELL_ROW_65_606 VGND VPWR sky130_fd_sc_hd__tapvpwrvgnd_1
XFILLER_0_31_30 VPWR VGND VPWR VGND sky130_ef_sc_hd__decap_12
XFILLER_0_9_329 VGND VGND VPWR VPWR sky130_fd_sc_hd__decap_6
XFILLER_0_15_42 VPWR VGND VPWR VGND sky130_ef_sc_hd__decap_12
XFILLER_0_60_408 VGND VGND VPWR VPWR sky130_fd_sc_hd__fill_1
Xaccumulator._1843_ accumulator._0854_ accumulator._0938_ accumulator._0939_ VGND
+ VGND VPWR VPWR accumulator._0941_ sky130_fd_sc_hd__and3_1
Xaccumulator._1912_ accumulator._0903_ accumulator._1005_ VGND VGND VPWR VPWR accumulator._1010_
+ sky130_fd_sc_hd__nand2_4
XFILLER_0_13_335 VGND VGND VPWR VPWR sky130_fd_sc_hd__fill_1
XFILLER_0_56_71 VGND VGND VPWR VPWR sky130_fd_sc_hd__decap_3
Xaccumulator._1774_ accumulator._0391_ accumulator._0755_ accumulator._0757_ VGND
+ VGND VPWR VPWR accumulator._0872_ sky130_fd_sc_hd__o21ai_1
XFILLER_0_21_390 VGND VGND VPWR VPWR sky130_fd_sc_hd__fill_2
Xaccumulator._2326_ clknet_2_1__leaf_clock accumulator._0033_ VGND VGND VPWR VPWR
+ accumulator.state\[0\] sky130_fd_sc_hd__dfxtp_1
Xaccumulator._1208_ accumulator._0301_ accumulator._0279_ accumulator._0281_ accumulator._0307_
+ VGND VGND VPWR VPWR accumulator._0308_ sky130_fd_sc_hd__a31o_1
Xaccumulator._2257_ accumulator._0057_ accumulator._0237_ VGND VGND VPWR VPWR accumulator._0238_
+ sky130_fd_sc_hd__or2_1
XFILLER_0_63_279 VGND VGND VPWR VPWR sky130_fd_sc_hd__fill_1
Xaccumulator._2188_ accumulator._0170_ accumulator._0156_ accumulator._1097_ VGND
+ VGND VPWR VPWR accumulator._0172_ sky130_fd_sc_hd__mux2_4
XPHY_EDGE_ROW_12_Left_81 VGND VGND VPWR VPWR sky130_fd_sc_hd__decap_3
XFILLER_0_54_213 VGND VGND VPWR VPWR sky130_fd_sc_hd__fill_1
XFILLER_0_52_29 VPWR VGND VPWR VGND sky130_ef_sc_hd__decap_12
XFILLER_0_10_305 VGND VGND VPWR VPWR sky130_fd_sc_hd__decap_3
Xaccumulator._1490_ accumulator._0586_ accumulator._0587_ accumulator._0449_ VGND
+ VGND VPWR VPWR accumulator._0588_ sky130_fd_sc_hd__a21o_1
Xaccumulator._2111_ accumulator._0063_ accumulator._0096_ accumulator._0035_ VGND
+ VGND VPWR VPWR accumulator._0097_ sky130_fd_sc_hd__mux2_1
Xaccumulator._2042_ accumulator._0363_ accumulator._1140_ VGND VGND VPWR VPWR accumulator._0002_
+ sky130_fd_sc_hd__nor2_1
XFILLER_0_26_85 VPWR VGND VPWR VGND sky130_ef_sc_hd__decap_12
XFILLER_0_26_63 VGND VGND VPWR VPWR sky130_fd_sc_hd__fill_2
XFILLER_0_33_408 VGND VGND VPWR VPWR sky130_fd_sc_hd__fill_1
XTAP_TAPCELL_ROW_33_377 VGND VPWR sky130_fd_sc_hd__tapvpwrvgnd_1
XFILLER_0_9_148 VPWR VGND VPWR VGND sky130_ef_sc_hd__decap_12
Xaccumulator._1826_ accumulator._0366_ accumulator._0914_ VGND VGND VPWR VPWR accumulator._0924_
+ sky130_fd_sc_hd__nor2_1
Xaccumulator._1757_ accumulator._0659_ accumulator._0828_ accumulator._0854_ accumulator._0658_
+ VGND VGND VPWR VPWR accumulator._0855_ sky130_fd_sc_hd__a31o_1
XFILLER_0_6_62 VGND VGND VPWR VPWR sky130_fd_sc_hd__fill_1
XFILLER_0_68_305 VGND VGND VPWR VPWR sky130_fd_sc_hd__decap_3
XFILLER_0_67_81 VPWR VGND VPWR VGND sky130_ef_sc_hd__decap_12
Xaccumulator._1688_ accumulator._0783_ accumulator._0784_ VGND VGND VPWR VPWR accumulator._0786_
+ sky130_fd_sc_hd__or2_1
XFILLER_0_68_349 VPWR VGND VPWR VGND sky130_ef_sc_hd__decap_12
XFILLER_0_36_202 VGND VGND VPWR VPWR sky130_fd_sc_hd__fill_2
Xaccumulator._2309_ clknet_2_0__leaf_clock accumulator._0016_ VGND VGND VPWR VPWR
+ accumulator.io_accOut\[14\] sky130_fd_sc_hd__dfxtp_1
XFILLER_0_63_39 VPWR VGND VPWR VGND sky130_ef_sc_hd__decap_12
XFILLER_0_59_316 VGND VGND VPWR VPWR sky130_fd_sc_hd__fill_2
XFILLER_0_67_393 VPWR VGND VPWR VGND sky130_ef_sc_hd__decap_12
XTAP_TAPCELL_ROW_30_358 VGND VPWR sky130_fd_sc_hd__tapvpwrvgnd_1
XFILLER_0_6_129 VGND VGND VPWR VPWR sky130_fd_sc_hd__decap_8
Xaccumulator._1611_ accumulator._0608_ accumulator._0626_ accumulator._0707_ accumulator._0708_
+ VGND VGND VPWR VPWR accumulator._0709_ sky130_fd_sc_hd__a31o_1
XFILLER_0_2_357 VGND VGND VPWR VPWR sky130_fd_sc_hd__decap_6
XFILLER_0_2_302 VGND VGND VPWR VPWR sky130_fd_sc_hd__decap_6
XFILLER_0_10_135 VGND VGND VPWR VPWR sky130_fd_sc_hd__decap_4
XFILLER_0_12_98 VGND VGND VPWR VPWR sky130_fd_sc_hd__decap_8
Xaccumulator._1542_ accumulator._0554_ accumulator._0555_ accumulator._0439_ VGND
+ VGND VPWR VPWR accumulator._0640_ sky130_fd_sc_hd__a21o_1
XTAP_TAPCELL_ROW_38_414 VGND VPWR sky130_fd_sc_hd__tapvpwrvgnd_1
Xaccumulator._1473_ accumulator.io_accOut\[9\] accumulator._0570_ accumulator._0346_
+ VGND VGND VPWR VPWR accumulator._0571_ sky130_fd_sc_hd__mux2_4
Xaccumulator._2025_ accumulator._1014_ accumulator._1101_ accumulator._1102_ VGND
+ VGND VPWR VPWR accumulator._1123_ sky130_fd_sc_hd__o21ai_1
XFILLER_0_33_216 VGND VGND VPWR VPWR sky130_fd_sc_hd__decap_3
XFILLER_0_5_173 VGND VGND VPWR VPWR sky130_fd_sc_hd__fill_1
XFILLER_0_18_246 VGND VGND VPWR VPWR sky130_fd_sc_hd__decap_6
Xaccumulator._1809_ accumulator._0876_ accumulator._0878_ accumulator._0880_ accumulator._0881_
+ VGND VGND VPWR VPWR accumulator._0907_ sky130_fd_sc_hd__a31o_1
XFILLER_0_68_113 VPWR VGND VPWR VGND sky130_ef_sc_hd__decap_12
XFILLER_0_49_393 VPWR VGND VPWR VGND sky130_ef_sc_hd__decap_12
Xinput18 io_inScaleA[5] VGND VGND VPWR VPWR net18 sky130_fd_sc_hd__buf_1
XFILLER_0_32_282 VPWR VGND VPWR VGND sky130_ef_sc_hd__decap_12
XFILLER_0_32_260 VGND VGND VPWR VPWR sky130_fd_sc_hd__decap_6
XscaleAdd._530_ net19 net24 scaleAdd._197_ scaleAdd._198_ VGND VGND VPWR VPWR scaleAdd._199_
+ sky130_fd_sc_hd__and4_1
XscaleAdd._392_ scaleAdd._071_ scaleAdd._239_ operator.io_outMant\[5\] VGND VGND VPWR
+ VPWR scaleAdd._072_ sky130_fd_sc_hd__and3_1
XscaleAdd._461_ scaleAdd._118_ scaleAdd._136_ VGND VGND VPWR VPWR scaleAdd._138_ sky130_fd_sc_hd__or2_1
XFILLER_0_20_400 VGND VGND VPWR VPWR sky130_fd_sc_hd__decap_4
XFILLER_0_59_113 VPWR VGND VPWR VGND sky130_ef_sc_hd__decap_12
XTAP_TAPCELL_ROW_43_450 VGND VPWR sky130_fd_sc_hd__tapvpwrvgnd_1
XFILLER_0_7_405 VGND VGND VPWR VPWR sky130_fd_sc_hd__decap_4
XFILLER_0_55_352 VGND VGND VPWR VPWR sky130_fd_sc_hd__fill_1
XFILLER_0_48_83 VGND VGND VPWR VPWR sky130_fd_sc_hd__fill_1
Xaccumulator._1525_ accumulator.io_accOut\[6\] accumulator._0349_ accumulator._0622_
+ VGND VGND VPWR VPWR accumulator._0623_ sky130_fd_sc_hd__and3_1
Xaccumulator._1456_ accumulator._0475_ accumulator._0500_ accumulator._0413_ VGND
+ VGND VPWR VPWR accumulator._0554_ sky130_fd_sc_hd__a21o_1
XFILLER_0_3_85 VGND VGND VPWR VPWR sky130_fd_sc_hd__fill_1
Xaccumulator._1387_ accumulator._0459_ accumulator._0462_ accumulator._0427_ VGND
+ VGND VPWR VPWR accumulator._0485_ sky130_fd_sc_hd__mux2_1
XFILLER_0_65_116 VGND VGND VPWR VPWR sky130_fd_sc_hd__decap_3
Xaccumulator._2008_ accumulator._1074_ accumulator._1105_ accumulator._1076_ VGND
+ VGND VPWR VPWR accumulator._1106_ sky130_fd_sc_hd__a21bo_1
XFILLER_0_38_319 VGND VGND VPWR VPWR sky130_fd_sc_hd__decap_4
XFILLER_0_60_29 VPWR VGND VPWR VGND sky130_ef_sc_hd__decap_12
XFILLER_0_52_377 VGND VGND VPWR VPWR sky130_fd_sc_hd__decap_8
XTAP_TAPCELL_ROW_40_431 VGND VPWR sky130_fd_sc_hd__tapvpwrvgnd_1
XscaleAdd._444_ scaleAdd._086_ scaleAdd._100_ scaleAdd._121_ VGND VGND VPWR VPWR scaleAdd._122_
+ sky130_fd_sc_hd__a21o_1
XscaleAdd._375_ scaleAdd._054_ scaleAdd._055_ VGND VGND VPWR VPWR scaleAdd._056_ sky130_fd_sc_hd__xnor2_2
XFILLER_0_20_241 VGND VGND VPWR VPWR sky130_fd_sc_hd__decap_8
XscaleAdd._513_ scaleAdd._154_ scaleAdd._175_ scaleAdd._161_ VGND VGND VPWR VPWR scaleAdd._183_
+ sky130_fd_sc_hd__nor3b_1
Xaccumulator._1310_ accumulator._0400_ accumulator._0407_ VGND VGND VPWR VPWR accumulator._0408_
+ sky130_fd_sc_hd__or2_1
X_15_ accumulator.io_accOut\[15\] VGND VGND VPWR VPWR net35 sky130_fd_sc_hd__buf_1
Xaccumulator._2290_ accumulator._0351_ accumulator._0270_ accumulator._0271_ accumulator._0092_
+ VGND VGND VPWR VPWR accumulator._0032_ sky130_fd_sc_hd__o211a_1
Xaccumulator._1241_ accumulator._0339_ accumulator._0337_ accumulator._0340_ VGND
+ VGND VPWR VPWR accumulator._0341_ sky130_fd_sc_hd__a21o_1
XFILLER_0_18_97 VGND VGND VPWR VPWR sky130_fd_sc_hd__fill_2
XTAP_TAPCELL_ROW_63_589 VGND VPWR sky130_fd_sc_hd__tapvpwrvgnd_1
XFILLER_0_34_85 VPWR VGND VPWR VGND sky130_ef_sc_hd__decap_12
XFILLER_0_34_41 VGND VGND VPWR VPWR sky130_fd_sc_hd__decap_8
XFILLER_0_28_330 VPWR VGND VPWR VGND sky130_ef_sc_hd__decap_12
Xaccumulator._1172_ accumulator._0181_ accumulator.io_inExp\[0\] accumulator._0239_
+ accumulator._0249_ accumulator._0259_ VGND VGND VPWR VPWR accumulator._0269_ sky130_fd_sc_hd__a41o_1
XFILLER_0_7_257 VGND VGND VPWR VPWR sky130_fd_sc_hd__decap_4
XFILLER_0_43_366 VGND VGND VPWR VPWR sky130_fd_sc_hd__fill_2
XFILLER_0_59_93 VPWR VGND VPWR VGND sky130_ef_sc_hd__decap_12
XTAP_TAPCELL_ROW_54_523 VGND VPWR sky130_fd_sc_hd__tapvpwrvgnd_1
Xaccumulator._1508_ accumulator._0389_ accumulator._0592_ accumulator._0602_ accumulator._0605_
+ accumulator._0581_ VGND VGND VPWR VPWR accumulator._0606_ sky130_fd_sc_hd__o32a_4
Xaccumulator._1439_ accumulator._0348_ accumulator._0507_ VGND VGND VPWR VPWR accumulator._0537_
+ sky130_fd_sc_hd__or2_1
XFILLER_0_38_127 VPWR VGND VPWR VGND sky130_ef_sc_hd__decap_12
XTAP_TAPCELL_ROW_3_167 VGND VPWR sky130_fd_sc_hd__tapvpwrvgnd_1
XFILLER_0_61_174 VPWR VGND VPWR VGND sky130_ef_sc_hd__decap_12
XTAP_TAPCELL_ROW_17_269 VGND VPWR sky130_fd_sc_hd__tapvpwrvgnd_1
XFILLER_0_52_174 VGND VGND VPWR VPWR sky130_fd_sc_hd__decap_8
XFILLER_0_52_141 VPWR VGND VPWR VGND sky130_ef_sc_hd__decap_12
Xaccumulator._1790_ accumulator._0885_ accumulator._0886_ accumulator._0887_ VGND
+ VGND VPWR VPWR accumulator._0888_ sky130_fd_sc_hd__o21a_1
XFILLER_0_20_76 VGND VGND VPWR VPWR sky130_fd_sc_hd__decap_8
XTAP_TAPCELL_ROW_68_626 VGND VPWR sky130_fd_sc_hd__tapvpwrvgnd_1
XFILLER_0_29_74 VPWR VGND VPWR VGND sky130_ef_sc_hd__decap_12
XscaleAdd._358_ scaleAdd._023_ scaleAdd._028_ VGND VGND VPWR VPWR scaleAdd._039_ sky130_fd_sc_hd__nand2_1
XscaleAdd._427_ scaleAdd._056_ scaleAdd._058_ scaleAdd._083_ scaleAdd._105_ VGND VGND
+ VPWR VPWR scaleAdd._106_ sky130_fd_sc_hd__a31o_4
XTAP_TAPCELL_ROW_51_504 VGND VPWR sky130_fd_sc_hd__tapvpwrvgnd_1
XFILLER_0_48_403 VGND VGND VPWR VPWR sky130_fd_sc_hd__decap_6
XFILLER_0_45_51 VGND VGND VPWR VPWR sky130_fd_sc_hd__decap_4
XTAP_TAPCELL_ROW_0_148 VGND VPWR sky130_fd_sc_hd__tapvpwrvgnd_1
XscaleAdd._289_ scaleAdd._232_ scaleAdd._233_ scaleAdd._239_ net63 VGND VGND VPWR
+ VPWR scaleAdd._240_ sky130_fd_sc_hd__or4bb_4
Xaccumulator._1224_ accumulator.io_accOut\[27\] accumulator._0323_ VGND VGND VPWR
+ VPWR accumulator._0324_ sky130_fd_sc_hd__xnor2_2
Xaccumulator._2273_ accumulator._0253_ accumulator._0254_ accumulator._0351_ VGND
+ VGND VPWR VPWR accumulator._0255_ sky130_fd_sc_hd__a21o_1
XFILLER_0_0_53 VGND VGND VPWR VPWR sky130_fd_sc_hd__decap_3
Xaccumulator._1155_ accumulator.io_inMant\[11\] VGND VGND VPWR VPWR accumulator._0103_
+ sky130_fd_sc_hd__inv_2
XFILLER_0_16_333 VPWR VGND VPWR VGND sky130_ef_sc_hd__decap_12
Xaccumulator._1988_ accumulator._1049_ accumulator._1079_ accumulator._1085_ VGND
+ VGND VPWR VPWR accumulator._1086_ sky130_fd_sc_hd__o21ai_1
XFILLER_0_3_293 VPWR VGND VPWR VGND sky130_ef_sc_hd__decap_12
XTAP_TAPCELL_ROW_8_204 VGND VPWR sky130_fd_sc_hd__tapvpwrvgnd_1
XFILLER_0_16_377 VGND VGND VPWR VPWR sky130_fd_sc_hd__fill_2
XFILLER_0_34_163 VGND VGND VPWR VPWR sky130_fd_sc_hd__decap_4
XFILLER_0_34_141 VGND VGND VPWR VPWR sky130_fd_sc_hd__decap_3
XPHY_EDGE_ROW_13_Right_13 VGND VGND VPWR VPWR sky130_fd_sc_hd__decap_3
XFILLER_0_15_54 VGND VGND VPWR VPWR sky130_fd_sc_hd__fill_2
XFILLER_0_57_222 VGND VGND VPWR VPWR sky130_fd_sc_hd__fill_2
XFILLER_0_31_42 VPWR VGND VPWR VGND sky130_ef_sc_hd__decap_12
XFILLER_0_25_141 VPWR VGND VPWR VGND sky130_ef_sc_hd__decap_12
XFILLER_0_25_130 VGND VGND VPWR VPWR sky130_fd_sc_hd__fill_1
XPHY_EDGE_ROW_22_Right_22 VGND VGND VPWR VPWR sky130_fd_sc_hd__decap_3
Xaccumulator._1773_ accumulator._0751_ accumulator._0870_ accumulator._0750_ VGND
+ VGND VPWR VPWR accumulator._0871_ sky130_fd_sc_hd__a21o_1
Xaccumulator._1842_ accumulator._0938_ accumulator._0939_ accumulator._0854_ VGND
+ VGND VPWR VPWR accumulator._0940_ sky130_fd_sc_hd__a21oi_1
Xaccumulator._1911_ accumulator._0892_ accumulator._1008_ VGND VGND VPWR VPWR accumulator._1009_
+ sky130_fd_sc_hd__xnor2_1
XFILLER_0_13_314 VPWR VGND VPWR VGND sky130_ef_sc_hd__decap_12
XPHY_EDGE_ROW_31_Right_31 VGND VGND VPWR VPWR sky130_fd_sc_hd__decap_3
XFILLER_0_63_203 VPWR VGND VPWR VGND sky130_ef_sc_hd__decap_12
Xaccumulator._2187_ accumulator._0169_ VGND VGND VPWR VPWR accumulator._0170_ sky130_fd_sc_hd__inv_2
XTAP_TAPCELL_ROW_36_397 VGND VPWR sky130_fd_sc_hd__tapvpwrvgnd_1
Xaccumulator._1207_ accumulator.io_inExp\[4\] accumulator.io_inExp\[3\] accumulator._0306_
+ VGND VGND VPWR VPWR accumulator._0307_ sky130_fd_sc_hd__and3b_1
Xaccumulator._2325_ clknet_2_1__leaf_clock accumulator._0032_ VGND VGND VPWR VPWR
+ accumulator.io_accOut\[30\] sky130_fd_sc_hd__dfxtp_2
Xaccumulator._2256_ accumulator.io_accOut\[27\] accumulator._0323_ accumulator._0356_
+ VGND VGND VPWR VPWR accumulator._0237_ sky130_fd_sc_hd__mux2_1
XFILLER_0_63_236 VGND VGND VPWR VPWR sky130_fd_sc_hd__fill_1
XPHY_EDGE_ROW_40_Right_40 VGND VGND VPWR VPWR sky130_fd_sc_hd__decap_3
XFILLER_0_31_111 VGND VGND VPWR VPWR sky130_fd_sc_hd__fill_1
Xoperator._089_ operator._021_ operator._026_ VGND VGND VPWR VPWR operator._027_ sky130_fd_sc_hd__nand2_4
XFILLER_0_8_363 VGND VGND VPWR VPWR sky130_fd_sc_hd__fill_1
XFILLER_0_31_166 VGND VGND VPWR VPWR sky130_fd_sc_hd__fill_2
XFILLER_0_22_177 VGND VGND VPWR VPWR sky130_fd_sc_hd__decap_3
XFILLER_0_22_100 VPWR VGND VPWR VGND sky130_ef_sc_hd__decap_12
XTAP_TAPCELL_ROW_10_220 VGND VPWR sky130_fd_sc_hd__tapvpwrvgnd_1
Xaccumulator._2110_ accumulator._0095_ accumulator._0078_ accumulator._1127_ VGND
+ VGND VPWR VPWR accumulator._0096_ sky130_fd_sc_hd__mux2_1
Xaccumulator._2041_ accumulator.io_accOut\[0\] accumulator._0364_ accumulator._1032_
+ accumulator._1139_ VGND VGND VPWR VPWR accumulator._1140_ sky130_fd_sc_hd__o2bb2a_1
XFILLER_0_42_41 VGND VGND VPWR VPWR sky130_fd_sc_hd__decap_3
XFILLER_0_26_97 VPWR VGND VPWR VGND sky130_ef_sc_hd__decap_12
XFILLER_0_9_105 VGND VGND VPWR VPWR sky130_fd_sc_hd__decap_6
XFILLER_0_45_225 VPWR VGND VPWR VGND sky130_ef_sc_hd__decap_12
XFILLER_0_42_85 VPWR VGND VPWR VGND sky130_ef_sc_hd__decap_12
XTAP_TAPCELL_ROW_33_378 VGND VPWR sky130_fd_sc_hd__tapvpwrvgnd_1
Xaccumulator._1825_ accumulator._0566_ accumulator._0729_ accumulator._0922_ VGND
+ VGND VPWR VPWR accumulator._0923_ sky130_fd_sc_hd__a21o_1
XFILLER_0_67_93 VGND VGND VPWR VPWR sky130_fd_sc_hd__decap_4
Xaccumulator._1756_ accumulator._0636_ accumulator._0637_ VGND VGND VPWR VPWR accumulator._0854_
+ sky130_fd_sc_hd__xor2_1
XFILLER_0_13_177 VGND VGND VPWR VPWR sky130_fd_sc_hd__fill_1
Xaccumulator._1687_ accumulator._0783_ accumulator._0784_ VGND VGND VPWR VPWR accumulator._0785_
+ sky130_fd_sc_hd__and2_1
Xaccumulator._2308_ clknet_2_3__leaf_clock accumulator._0015_ VGND VGND VPWR VPWR
+ accumulator.io_accOut\[13\] sky130_fd_sc_hd__dfxtp_1
Xrebuffer30 accumulator._0277_ VGND VGND VPWR VPWR net93 sky130_fd_sc_hd__buf_6
XFILLER_0_36_269 VGND VGND VPWR VPWR sky130_fd_sc_hd__fill_1
Xaccumulator._2239_ accumulator._0218_ accumulator._0217_ VGND VGND VPWR VPWR accumulator._0221_
+ sky130_fd_sc_hd__and2b_1
XFILLER_0_67_361 VPWR VGND VPWR VGND sky130_ef_sc_hd__decap_12
XTAP_TAPCELL_ROW_30_359 VGND VPWR sky130_fd_sc_hd__tapvpwrvgnd_1
Xaccumulator._1610_ accumulator._0622_ accumulator._0624_ VGND VGND VPWR VPWR accumulator._0708_
+ sky130_fd_sc_hd__nor2_1
XTAP_TAPCELL_ROW_38_415 VGND VPWR sky130_fd_sc_hd__tapvpwrvgnd_1
XFILLER_0_37_85 VGND VGND VPWR VPWR sky130_fd_sc_hd__decap_4
Xaccumulator._1541_ accumulator._0550_ accumulator._0551_ accumulator._0473_ VGND
+ VGND VPWR VPWR accumulator._0639_ sky130_fd_sc_hd__a21o_1
Xaccumulator._1472_ accumulator._0285_ accumulator._0519_ VGND VGND VPWR VPWR accumulator._0570_
+ sky130_fd_sc_hd__nor2_1
Xaccumulator._2024_ accumulator._1064_ accumulator._1071_ accumulator._1119_ VGND
+ VGND VPWR VPWR accumulator._1122_ sky130_fd_sc_hd__mux2_4
XFILLER_0_53_51 VGND VGND VPWR VPWR sky130_fd_sc_hd__decap_4
XTAP_TAPCELL_ROW_46_470 VGND VPWR sky130_fd_sc_hd__tapvpwrvgnd_1
XFILLER_0_41_294 VPWR VGND VPWR VGND sky130_ef_sc_hd__decap_12
XFILLER_0_5_130 VGND VGND VPWR VPWR sky130_fd_sc_hd__decap_6
Xaccumulator._1808_ accumulator._0817_ accumulator._0905_ VGND VGND VPWR VPWR accumulator._0906_
+ sky130_fd_sc_hd__xnor2_2
Xaccumulator._1739_ accumulator._0449_ accumulator._0440_ accumulator._0691_ accumulator._0393_
+ VGND VGND VPWR VPWR accumulator._0837_ sky130_fd_sc_hd__a31o_1
XFILLER_0_1_391 VGND VGND VPWR VPWR sky130_fd_sc_hd__fill_1
XFILLER_0_68_169 VPWR VGND VPWR VGND sky130_ef_sc_hd__decap_12
XFILLER_0_68_125 VPWR VGND VPWR VGND sky130_ef_sc_hd__decap_12
XFILLER_0_56_309 VGND VGND VPWR VPWR sky130_fd_sc_hd__decap_8
Xinput19 io_inScaleA[6] VGND VGND VPWR VPWR net19 sky130_fd_sc_hd__buf_1
XFILLER_0_58_29 VPWR VGND VPWR VGND sky130_ef_sc_hd__decap_12
XFILLER_0_32_294 VPWR VGND VPWR VGND sky130_ef_sc_hd__decap_12
XscaleAdd._460_ scaleAdd._118_ scaleAdd._136_ VGND VGND VPWR VPWR scaleAdd._137_ sky130_fd_sc_hd__nand2_1
XscaleAdd._391_ operator.io_outMant\[6\] net13 scaleAdd._224_ VGND VGND VPWR VPWR
+ scaleAdd._071_ sky130_fd_sc_hd__and3_1
X_31_ accumulator.io_accOut\[31\] VGND VGND VPWR VPWR net53 sky130_fd_sc_hd__buf_1
XFILLER_0_67_191 VGND VGND VPWR VPWR sky130_fd_sc_hd__fill_1
XFILLER_0_59_125 VPWR VGND VPWR VGND sky130_ef_sc_hd__decap_12
XTAP_TAPCELL_ROW_43_451 VGND VPWR sky130_fd_sc_hd__tapvpwrvgnd_1
XFILLER_0_23_32 VGND VGND VPWR VPWR sky130_fd_sc_hd__fill_1
XFILLER_0_48_51 VPWR VGND VPWR VGND sky130_ef_sc_hd__decap_12
Xaccumulator._1524_ accumulator._0389_ accumulator._0611_ accumulator._0620_ accumulator._0621_
+ VGND VGND VPWR VPWR accumulator._0622_ sky130_fd_sc_hd__o31a_1
Xaccumulator._1455_ accumulator._0549_ accumulator._0552_ accumulator._0493_ VGND
+ VGND VPWR VPWR accumulator._0553_ sky130_fd_sc_hd__a21o_1
Xaccumulator._1386_ accumulator._0427_ accumulator._0458_ accumulator._0483_ accumulator.io_inMant\[0\]
+ VGND VGND VPWR VPWR accumulator._0484_ sky130_fd_sc_hd__a22o_1
Xaccumulator._2007_ accumulator._1071_ accumulator._1104_ accumulator._1058_ VGND
+ VGND VPWR VPWR accumulator._1105_ sky130_fd_sc_hd__a21bo_1
XTAP_TAPCELL_ROW_6_187 VGND VPWR sky130_fd_sc_hd__tapvpwrvgnd_1
XFILLER_0_49_191 VGND VGND VPWR VPWR sky130_fd_sc_hd__decap_3
XFILLER_0_52_356 VGND VGND VPWR VPWR sky130_fd_sc_hd__decap_8
XscaleAdd._512_ scaleAdd._182_ VGND VGND VPWR VPWR accumulator.io_inExp\[2\] sky130_fd_sc_hd__clkbuf_1
XscaleAdd._443_ scaleAdd._107_ scaleAdd._120_ VGND VGND VPWR VPWR scaleAdd._121_ sky130_fd_sc_hd__xnor2_1
XscaleAdd._374_ scaleAdd._029_ scaleAdd._032_ VGND VGND VPWR VPWR scaleAdd._055_ sky130_fd_sc_hd__nand2_1
XFILLER_0_20_253 VGND VGND VPWR VPWR sky130_fd_sc_hd__decap_4
XFILLER_0_20_297 VGND VGND VPWR VPWR sky130_fd_sc_hd__fill_1
X_14_ accumulator.io_accOut\[14\] VGND VGND VPWR VPWR net34 sky130_fd_sc_hd__buf_1
Xaccumulator._1171_ accumulator.io_inExp\[1\] accumulator._0171_ VGND VGND VPWR VPWR
+ accumulator._0259_ sky130_fd_sc_hd__and2_1
Xaccumulator._1240_ accumulator.io_accOut\[28\] accumulator._0338_ VGND VGND VPWR
+ VPWR accumulator._0340_ sky130_fd_sc_hd__and2_1
XFILLER_0_62_109 VGND VGND VPWR VPWR sky130_fd_sc_hd__decap_6
XFILLER_0_50_41 VGND VGND VPWR VPWR sky130_fd_sc_hd__decap_4
XFILLER_0_34_97 VGND VGND VPWR VPWR sky130_fd_sc_hd__fill_1
XFILLER_0_28_342 VPWR VGND VPWR VGND sky130_ef_sc_hd__decap_12
XFILLER_0_7_225 VGND VGND VPWR VPWR sky130_fd_sc_hd__decap_4
XFILLER_0_7_236 VPWR VGND VPWR VGND sky130_ef_sc_hd__decap_12
XFILLER_0_43_389 VGND VGND VPWR VPWR sky130_fd_sc_hd__decap_3
XFILLER_0_52_3 VPWR VGND VPWR VGND sky130_ef_sc_hd__decap_12
Xaccumulator._1507_ accumulator._0395_ accumulator._0411_ accumulator._0604_ VGND
+ VGND VPWR VPWR accumulator._0605_ sky130_fd_sc_hd__or3b_4
XTAP_TAPCELL_ROW_3_168 VGND VPWR sky130_fd_sc_hd__tapvpwrvgnd_1
XTAP_TAPCELL_ROW_54_524 VGND VPWR sky130_fd_sc_hd__tapvpwrvgnd_1
Xaccumulator._1438_ accumulator._0447_ accumulator._0495_ accumulator._0535_ VGND
+ VGND VPWR VPWR accumulator._0536_ sky130_fd_sc_hd__o21ai_4
XFILLER_0_38_139 VGND VGND VPWR VPWR sky130_fd_sc_hd__fill_1
Xaccumulator._1369_ accumulator._0465_ accumulator._0466_ accumulator._0427_ VGND
+ VGND VPWR VPWR accumulator._0467_ sky130_fd_sc_hd__mux2_1
XFILLER_0_61_186 VPWR VGND VPWR VGND sky130_ef_sc_hd__decap_12
XFILLER_0_53_109 VGND VGND VPWR VPWR sky130_fd_sc_hd__decap_3
XFILLER_0_46_194 VGND VGND VPWR VPWR sky130_fd_sc_hd__fill_2
XFILLER_0_19_364 VGND VGND VPWR VPWR sky130_fd_sc_hd__decap_8
XFILLER_0_4_206 VGND VGND VPWR VPWR sky130_fd_sc_hd__decap_8
XFILLER_0_52_153 VGND VGND VPWR VPWR sky130_fd_sc_hd__decap_4
XFILLER_0_20_44 VGND VGND VPWR VPWR sky130_fd_sc_hd__decap_8
XFILLER_0_20_66 VGND VGND VPWR VPWR sky130_fd_sc_hd__fill_1
XTAP_TAPCELL_ROW_68_627 VGND VPWR sky130_fd_sc_hd__tapvpwrvgnd_1
XFILLER_0_29_86 VPWR VGND VPWR VGND sky130_ef_sc_hd__decap_12
XscaleAdd._426_ scaleAdd._061_ scaleAdd._059_ scaleAdd._082_ VGND VGND VPWR VPWR scaleAdd._105_
+ sky130_fd_sc_hd__a21boi_1
XscaleAdd._357_ scaleAdd._037_ scaleAdd._038_ VGND VGND VPWR VPWR accumulator.io_inMant\[7\]
+ sky130_fd_sc_hd__xnor2_2
XscaleAdd._288_ net13 scaleAdd._236_ scaleAdd._237_ scaleAdd._238_ VGND VGND VPWR
+ VPWR scaleAdd._239_ sky130_fd_sc_hd__a211oi_4
XFILLER_0_61_51 VGND VGND VPWR VPWR sky130_fd_sc_hd__decap_4
XTAP_TAPCELL_ROW_51_505 VGND VPWR sky130_fd_sc_hd__tapvpwrvgnd_1
Xaccumulator._1154_ accumulator.io_inExp\[2\] accumulator._0083_ VGND VGND VPWR VPWR
+ accumulator._0093_ sky130_fd_sc_hd__or2_1
XTAP_TAPCELL_ROW_0_149 VGND VPWR sky130_fd_sc_hd__tapvpwrvgnd_1
XTAP_TAPCELL_ROW_0_138 VGND VPWR sky130_fd_sc_hd__tapvpwrvgnd_1
XFILLER_0_17_6 VGND VGND VPWR VPWR sky130_fd_sc_hd__decap_4
Xaccumulator._2272_ accumulator._0248_ accumulator._0252_ VGND VGND VPWR VPWR accumulator._0254_
+ sky130_fd_sc_hd__nand2_1
Xaccumulator._1223_ accumulator._0303_ accumulator._0322_ VGND VGND VPWR VPWR accumulator._0323_
+ sky130_fd_sc_hd__nor2_1
XFILLER_0_61_73 VGND VGND VPWR VPWR sky130_fd_sc_hd__fill_1
XFILLER_0_35_109 VGND VGND VPWR VPWR sky130_fd_sc_hd__decap_3
XFILLER_0_9_30 VGND VGND VPWR VPWR sky130_fd_sc_hd__decap_8
XFILLER_0_16_345 VGND VGND VPWR VPWR sky130_fd_sc_hd__decap_6
Xaccumulator._1987_ accumulator._1082_ accumulator._1084_ VGND VGND VPWR VPWR accumulator._1085_
+ sky130_fd_sc_hd__nor2_1
XFILLER_0_31_337 VGND VGND VPWR VPWR sky130_fd_sc_hd__fill_2
XTAP_TAPCELL_ROW_8_205 VGND VPWR sky130_fd_sc_hd__tapvpwrvgnd_1
XFILLER_0_66_289 VGND VGND VPWR VPWR sky130_fd_sc_hd__decap_3
XFILLER_0_26_109 VPWR VGND VPWR VGND sky130_ef_sc_hd__decap_12
XFILLER_0_22_359 VGND VGND VPWR VPWR sky130_fd_sc_hd__decap_4
XFILLER_0_66_29 VPWR VGND VPWR VGND sky130_ef_sc_hd__decap_12
Xaccumulator._1910_ accumulator._0903_ accumulator._1007_ VGND VGND VPWR VPWR accumulator._1008_
+ sky130_fd_sc_hd__nand2_1
XFILLER_0_31_54 VGND VGND VPWR VPWR sky130_fd_sc_hd__fill_2
XFILLER_0_25_153 VPWR VGND VPWR VGND sky130_ef_sc_hd__decap_12
XTAP_TAPCELL_ROW_13_240 VGND VPWR sky130_fd_sc_hd__tapvpwrvgnd_1
Xaccumulator._1772_ accumulator._0743_ accumulator._0741_ VGND VGND VPWR VPWR accumulator._0870_
+ sky130_fd_sc_hd__or2b_1
Xaccumulator._1841_ accumulator._0672_ accumulator._0701_ accumulator._0702_ accumulator._0815_
+ VGND VGND VPWR VPWR accumulator._0939_ sky130_fd_sc_hd__a211o_1
XPHY_EDGE_ROW_37_Left_106 VGND VGND VPWR VPWR sky130_fd_sc_hd__decap_3
XscaleAdd._409_ scaleAdd._076_ scaleAdd._068_ VGND VGND VPWR VPWR scaleAdd._088_ sky130_fd_sc_hd__or2_4
XFILLER_0_0_253 VPWR VGND VPWR VGND sky130_ef_sc_hd__decap_12
XFILLER_0_13_337 VPWR VGND VPWR VGND sky130_ef_sc_hd__decap_12
XFILLER_0_56_95 VPWR VGND VPWR VGND sky130_ef_sc_hd__decap_12
Xaccumulator._2324_ clknet_2_0__leaf_clock accumulator._0031_ VGND VGND VPWR VPWR
+ accumulator.io_accOut\[29\] sky130_fd_sc_hd__dfxtp_1
XFILLER_0_63_215 VGND VGND VPWR VPWR sky130_fd_sc_hd__decap_8
Xaccumulator._2186_ accumulator._1016_ accumulator._1013_ net92 VGND VGND VPWR VPWR
+ accumulator._0169_ sky130_fd_sc_hd__mux2_1
XPHY_EDGE_ROW_46_Left_115 VGND VGND VPWR VPWR sky130_fd_sc_hd__decap_3
XFILLER_0_36_407 VGND VGND VPWR VPWR sky130_fd_sc_hd__fill_2
XTAP_TAPCELL_ROW_36_398 VGND VPWR sky130_fd_sc_hd__tapvpwrvgnd_1
Xaccumulator._1206_ accumulator._0034_ accumulator._0064_ VGND VGND VPWR VPWR accumulator._0306_
+ sky130_fd_sc_hd__or2_1
Xaccumulator._2255_ accumulator._0351_ accumulator._0235_ accumulator._0236_ accumulator._0092_
+ VGND VGND VPWR VPWR accumulator._0028_ sky130_fd_sc_hd__o211a_1
Xoperator._088_ operator._022_ operator._025_ VGND VGND VPWR VPWR operator._026_ sky130_fd_sc_hd__xnor2_2
XFILLER_0_16_197 VGND VGND VPWR VPWR sky130_fd_sc_hd__fill_2
XPHY_EDGE_ROW_55_Left_124 VGND VGND VPWR VPWR sky130_fd_sc_hd__decap_3
XPHY_EDGE_ROW_64_Left_133 VGND VGND VPWR VPWR sky130_fd_sc_hd__decap_3
XFILLER_0_39_267 VPWR VGND VPWR VGND sky130_ef_sc_hd__decap_12
XTAP_TAPCELL_ROW_10_221 VGND VPWR sky130_fd_sc_hd__tapvpwrvgnd_1
XFILLER_0_22_112 VPWR VGND VPWR VGND sky130_ef_sc_hd__decap_12
XFILLER_0_45_237 VGND VGND VPWR VPWR sky130_fd_sc_hd__decap_4
Xaccumulator._2040_ accumulator._1121_ accumulator._1128_ accumulator._1138_ VGND
+ VGND VPWR VPWR accumulator._1139_ sky130_fd_sc_hd__mux2_1
XFILLER_0_53_281 VGND VGND VPWR VPWR sky130_fd_sc_hd__decap_6
XFILLER_0_42_97 VGND VGND VPWR VPWR sky130_fd_sc_hd__decap_8
XTAP_TAPCELL_ROW_33_379 VGND VPWR sky130_fd_sc_hd__tapvpwrvgnd_1
Xaccumulator._1824_ accumulator._0736_ accumulator._0737_ VGND VGND VPWR VPWR accumulator._0922_
+ sky130_fd_sc_hd__nor2_1
Xaccumulator._1755_ accumulator._0851_ accumulator._0834_ accumulator._0672_ accumulator._0852_
+ VGND VGND VPWR VPWR accumulator._0853_ sky130_fd_sc_hd__a211o_4
Xaccumulator._1686_ accumulator.io_accOut\[18\] accumulator._0516_ accumulator._0355_
+ VGND VGND VPWR VPWR accumulator._0784_ sky130_fd_sc_hd__mux2_1
XTAP_TAPCELL_ROW_49_490 VGND VPWR sky130_fd_sc_hd__tapvpwrvgnd_1
Xaccumulator._2307_ clknet_2_3__leaf_clock accumulator._0014_ VGND VGND VPWR VPWR
+ accumulator.io_accOut\[12\] sky130_fd_sc_hd__dfxtp_1
Xaccumulator._2238_ accumulator._0217_ accumulator._0218_ VGND VGND VPWR VPWR accumulator._0220_
+ sky130_fd_sc_hd__and2b_1
Xrebuffer20 net99 VGND VGND VPWR VPWR net83 sky130_fd_sc_hd__dlygate4sd1_1
XFILLER_0_36_226 VPWR VGND VPWR VGND sky130_ef_sc_hd__decap_12
Xaccumulator._2169_ net114 accumulator._0120_ accumulator._0092_ accumulator._0153_
+ VGND VGND VPWR VPWR accumulator._0017_ sky130_fd_sc_hd__o211a_1
XTAP_TAPCELL_ROW_24_313 VGND VPWR sky130_fd_sc_hd__tapvpwrvgnd_1
XFILLER_0_8_150 VGND VGND VPWR VPWR sky130_fd_sc_hd__decap_4
XFILLER_0_8_194 VGND VGND VPWR VPWR sky130_fd_sc_hd__fill_2
XFILLER_0_67_373 VPWR VGND VPWR VGND sky130_ef_sc_hd__decap_12
Xaccumulator._1540_ accumulator._0636_ accumulator._0637_ VGND VGND VPWR VPWR accumulator._0638_
+ sky130_fd_sc_hd__nand2_1
XFILLER_0_50_273 VPWR VGND VPWR VGND sky130_ef_sc_hd__decap_12
Xaccumulator._1471_ accumulator._0567_ accumulator._0568_ accumulator._0447_ VGND
+ VGND VPWR VPWR accumulator._0569_ sky130_fd_sc_hd__a21oi_1
XTAP_TAPCELL_ROW_38_416 VGND VPWR sky130_fd_sc_hd__tapvpwrvgnd_1
Xaccumulator._2023_ accumulator._1033_ accumulator._1097_ net102 VGND VGND VPWR VPWR
+ accumulator._1121_ sky130_fd_sc_hd__or3b_1
XTAP_TAPCELL_ROW_46_471 VGND VPWR sky130_fd_sc_hd__tapvpwrvgnd_1
XFILLER_0_18_215 VGND VGND VPWR VPWR sky130_fd_sc_hd__fill_1
Xaccumulator._1807_ accumulator._0367_ accumulator._0810_ accumulator._0904_ VGND
+ VGND VPWR VPWR accumulator._0905_ sky130_fd_sc_hd__a21o_1
XFILLER_0_26_281 VGND VGND VPWR VPWR sky130_fd_sc_hd__decap_3
XFILLER_0_5_197 VGND VGND VPWR VPWR sky130_fd_sc_hd__decap_3
Xaccumulator._1669_ accumulator._0730_ accumulator._0746_ accumulator._0759_ accumulator._0762_
+ accumulator._0766_ VGND VGND VPWR VPWR accumulator._0767_ sky130_fd_sc_hd__o311a_2
Xaccumulator._1738_ accumulator._0512_ accumulator._0612_ accumulator._0619_ accumulator._0446_
+ VGND VGND VPWR VPWR accumulator._0836_ sky130_fd_sc_hd__a211o_1
XFILLER_0_68_137 VGND VGND VPWR VPWR sky130_fd_sc_hd__decap_3
XFILLER_0_32_240 VPWR VGND VPWR VGND sky130_ef_sc_hd__decap_12
XFILLER_0_32_273 VGND VGND VPWR VPWR sky130_fd_sc_hd__fill_1
XscaleAdd._390_ operator.io_outMant\[4\] scaleAdd._248_ VGND VGND VPWR VPWR scaleAdd._070_
+ sky130_fd_sc_hd__nand2_1
XFILLER_0_59_137 VPWR VGND VPWR VGND sky130_ef_sc_hd__decap_12
X_30_ accumulator.io_accOut\[30\] VGND VGND VPWR VPWR net52 sky130_fd_sc_hd__clkbuf_1
XTAP_TAPCELL_ROW_43_452 VGND VPWR sky130_fd_sc_hd__tapvpwrvgnd_1
XFILLER_0_23_295 VGND VGND VPWR VPWR sky130_fd_sc_hd__decap_8
XFILLER_0_48_85 VPWR VGND VPWR VGND sky130_ef_sc_hd__decap_12
XFILLER_0_48_63 VGND VGND VPWR VPWR sky130_fd_sc_hd__decap_6
Xaccumulator._1523_ accumulator._0394_ accumulator._0581_ accumulator._0512_ accumulator._0441_
+ VGND VGND VPWR VPWR accumulator._0621_ sky130_fd_sc_hd__or4b_1
Xaccumulator._1454_ accumulator._0550_ accumulator._0551_ accumulator._0439_ VGND
+ VGND VPWR VPWR accumulator._0552_ sky130_fd_sc_hd__a21o_1
XFILLER_0_65_107 VGND VGND VPWR VPWR sky130_fd_sc_hd__fill_2
XFILLER_0_64_95 VPWR VGND VPWR VGND sky130_ef_sc_hd__decap_12
XFILLER_0_3_98 VGND VGND VPWR VPWR sky130_fd_sc_hd__decap_8
Xaccumulator._1385_ accumulator._0427_ accumulator._0415_ VGND VGND VPWR VPWR accumulator._0483_
+ sky130_fd_sc_hd__nor2_1
XFILLER_0_61_335 VGND VGND VPWR VPWR sky130_fd_sc_hd__fill_1
Xaccumulator._2006_ accumulator._1103_ accumulator._1069_ accumulator._1064_ VGND
+ VGND VPWR VPWR accumulator._1104_ sky130_fd_sc_hd__a21bo_1
XFILLER_0_46_365 VGND VGND VPWR VPWR sky130_fd_sc_hd__decap_3
XFILLER_0_14_251 VGND VGND VPWR VPWR sky130_fd_sc_hd__fill_1
XFILLER_0_14_262 VGND VGND VPWR VPWR sky130_fd_sc_hd__decap_6
XTAP_TAPCELL_ROW_57_544 VGND VPWR sky130_fd_sc_hd__tapvpwrvgnd_1
XTAP_TAPCELL_ROW_6_188 VGND VPWR sky130_fd_sc_hd__tapvpwrvgnd_1
XFILLER_0_56_107 VPWR VGND VPWR VGND sky130_ef_sc_hd__decap_12
XFILLER_0_37_365 VGND VGND VPWR VPWR sky130_fd_sc_hd__fill_1
XFILLER_0_64_195 VGND VGND VPWR VPWR sky130_fd_sc_hd__fill_1
XscaleAdd._442_ scaleAdd._118_ scaleAdd._119_ VGND VGND VPWR VPWR scaleAdd._120_ sky130_fd_sc_hd__or2b_4
XscaleAdd._511_ scaleAdd._180_ scaleAdd._181_ VGND VGND VPWR VPWR scaleAdd._182_ sky130_fd_sc_hd__and2_1
XscaleAdd._373_ scaleAdd._039_ scaleAdd._053_ VGND VGND VPWR VPWR scaleAdd._054_ sky130_fd_sc_hd__xnor2_2
X_13_ accumulator.io_accOut\[13\] VGND VGND VPWR VPWR net33 sky130_fd_sc_hd__clkbuf_1
Xaccumulator._1170_ accumulator.io_inMant\[14\] accumulator.io_inMant\[13\] VGND VGND
+ VPWR VPWR accumulator._0249_ sky130_fd_sc_hd__or2b_1
XFILLER_0_55_140 VGND VGND VPWR VPWR sky130_fd_sc_hd__fill_1
XFILLER_0_50_97 VGND VGND VPWR VPWR sky130_fd_sc_hd__decap_8
XFILLER_0_28_365 VGND VGND VPWR VPWR sky130_fd_sc_hd__fill_2
XFILLER_0_28_354 VGND VGND VPWR VPWR sky130_fd_sc_hd__decap_8
XFILLER_0_7_248 VGND VGND VPWR VPWR sky130_fd_sc_hd__fill_2
XFILLER_0_59_51 VGND VGND VPWR VPWR sky130_fd_sc_hd__decap_4
Xaccumulator._1437_ accumulator._0395_ accumulator._0511_ accumulator._0532_ accumulator._0534_
+ VGND VGND VPWR VPWR accumulator._0535_ sky130_fd_sc_hd__o31a_1
XFILLER_0_45_3 VPWR VGND VPWR VGND sky130_ef_sc_hd__decap_12
Xaccumulator._1506_ accumulator._0472_ accumulator._0456_ accumulator._0471_ accumulator._0603_
+ VGND VGND VPWR VPWR accumulator._0604_ sky130_fd_sc_hd__a31o_1
XTAP_TAPCELL_ROW_3_169 VGND VPWR sky130_fd_sc_hd__tapvpwrvgnd_1
XTAP_TAPCELL_ROW_62_580 VGND VPWR sky130_fd_sc_hd__tapvpwrvgnd_1
XTAP_TAPCELL_ROW_54_525 VGND VPWR sky130_fd_sc_hd__tapvpwrvgnd_1
Xaccumulator._1299_ accumulator._0353_ VGND VGND VPWR VPWR accumulator._0397_ sky130_fd_sc_hd__buf_6
Xaccumulator._1368_ accumulator.io_inMant\[12\] accumulator.io_inMant\[11\] accumulator._0415_
+ VGND VGND VPWR VPWR accumulator._0466_ sky130_fd_sc_hd__mux2_1
XFILLER_0_61_165 VGND VGND VPWR VPWR sky130_fd_sc_hd__decap_3
XFILLER_0_34_335 VGND VGND VPWR VPWR sky130_fd_sc_hd__decap_4
XFILLER_0_52_121 VGND VGND VPWR VPWR sky130_fd_sc_hd__decap_4
XFILLER_0_37_173 VGND VGND VPWR VPWR sky130_fd_sc_hd__decap_6
XFILLER_0_25_357 VPWR VGND VPWR VGND sky130_ef_sc_hd__decap_12
XFILLER_0_25_335 VGND VGND VPWR VPWR sky130_fd_sc_hd__fill_1
XFILLER_0_52_165 VGND VGND VPWR VPWR sky130_fd_sc_hd__decap_6
XFILLER_0_40_305 VGND VGND VPWR VPWR sky130_fd_sc_hd__decap_3
XPHY_EDGE_ROW_29_Left_98 VGND VGND VPWR VPWR sky130_fd_sc_hd__decap_3
XscaleAdd._425_ scaleAdd._102_ scaleAdd._103_ VGND VGND VPWR VPWR scaleAdd._104_ sky130_fd_sc_hd__or2b_1
XTAP_TAPCELL_ROW_68_628 VGND VPWR sky130_fd_sc_hd__tapvpwrvgnd_1
XFILLER_0_29_98 VPWR VGND VPWR VGND sky130_ef_sc_hd__decap_12
XFILLER_0_29_54 VGND VGND VPWR VPWR sky130_fd_sc_hd__fill_2
XscaleAdd._287_ net13 scaleAdd._222_ VGND VGND VPWR VPWR scaleAdd._238_ sky130_fd_sc_hd__nor2_1
XscaleAdd._356_ scaleAdd._260_ scaleAdd._259_ scaleAdd._011_ VGND VGND VPWR VPWR scaleAdd._038_
+ sky130_fd_sc_hd__o21a_1
Xaccumulator._2271_ accumulator._0248_ accumulator._0252_ VGND VGND VPWR VPWR accumulator._0253_
+ sky130_fd_sc_hd__or2_1
XFILLER_0_61_85 VGND VGND VPWR VPWR sky130_fd_sc_hd__fill_1
XTAP_TAPCELL_ROW_51_506 VGND VPWR sky130_fd_sc_hd__tapvpwrvgnd_1
Xaccumulator._1153_ net100 accumulator._0044_ accumulator._0074_ VGND VGND VPWR VPWR
+ accumulator._0083_ sky130_fd_sc_hd__o21a_1
XTAP_TAPCELL_ROW_0_139 VGND VPWR sky130_fd_sc_hd__tapvpwrvgnd_1
XTAP_TAPCELL_ROW_16_260 VGND VPWR sky130_fd_sc_hd__tapvpwrvgnd_1
Xaccumulator._1222_ accumulator._0321_ VGND VGND VPWR VPWR accumulator._0322_ sky130_fd_sc_hd__buf_2
Xaccumulator._1986_ accumulator._0972_ accumulator._1083_ VGND VGND VPWR VPWR accumulator._1084_
+ sky130_fd_sc_hd__xnor2_2
XFILLER_0_43_110 VGND VGND VPWR VPWR sky130_fd_sc_hd__fill_2
XFILLER_0_9_20 VGND VGND VPWR VPWR sky130_fd_sc_hd__fill_2
XFILLER_0_16_357 VGND VGND VPWR VPWR sky130_fd_sc_hd__decap_6
XTAP_TAPCELL_ROW_8_206 VGND VPWR sky130_fd_sc_hd__tapvpwrvgnd_1
XFILLER_0_34_121 VPWR VGND VPWR VGND sky130_ef_sc_hd__decap_12
XFILLER_0_15_89 VGND VGND VPWR VPWR sky130_fd_sc_hd__decap_4
Xaccumulator._1840_ accumulator._0833_ accumulator._0853_ accumulator._0365_ VGND
+ VGND VPWR VPWR accumulator._0938_ sky130_fd_sc_hd__a21o_1
XFILLER_0_25_165 VGND VGND VPWR VPWR sky130_fd_sc_hd__decap_3
XTAP_TAPCELL_ROW_13_241 VGND VPWR sky130_fd_sc_hd__tapvpwrvgnd_1
XFILLER_0_13_349 VPWR VGND VPWR VGND sky130_ef_sc_hd__decap_12
Xaccumulator._1771_ accumulator._0758_ accumulator._0772_ VGND VGND VPWR VPWR accumulator._0869_
+ sky130_fd_sc_hd__or2b_1
XFILLER_0_56_41 VGND VGND VPWR VPWR sky130_fd_sc_hd__decap_8
XscaleAdd._408_ scaleAdd._069_ scaleAdd._075_ VGND VGND VPWR VPWR scaleAdd._087_ sky130_fd_sc_hd__nand2_1
XFILLER_0_0_221 VGND VGND VPWR VPWR sky130_fd_sc_hd__decap_3
XFILLER_0_0_265 VPWR VGND VPWR VGND sky130_ef_sc_hd__decap_12
XscaleAdd._339_ scaleAdd._018_ scaleAdd._019_ scaleAdd._020_ VGND VGND VPWR VPWR scaleAdd._021_
+ sky130_fd_sc_hd__nand3_2
XPHY_EDGE_ROW_7_Right_7 VGND VGND VPWR VPWR sky130_fd_sc_hd__decap_3
XFILLER_0_21_382 VGND VGND VPWR VPWR sky130_fd_sc_hd__decap_8
XFILLER_0_21_393 VPWR VGND VPWR VGND sky130_ef_sc_hd__decap_12
XFILLER_0_56_85 VGND VGND VPWR VPWR sky130_fd_sc_hd__decap_4
Xaccumulator._2323_ clknet_2_0__leaf_clock accumulator._0030_ VGND VGND VPWR VPWR
+ accumulator.io_accOut\[28\] sky130_fd_sc_hd__dfxtp_1
Xaccumulator._2254_ accumulator.io_accOut\[26\] accumulator._0358_ VGND VGND VPWR
+ VPWR accumulator._0236_ sky130_fd_sc_hd__or2_1
Xaccumulator._2185_ accumulator._0089_ accumulator._0109_ accumulator._0154_ accumulator._0043_
+ VGND VGND VPWR VPWR accumulator._0168_ sky130_fd_sc_hd__o22a_1
XTAP_TAPCELL_ROW_36_399 VGND VPWR sky130_fd_sc_hd__tapvpwrvgnd_1
XFILLER_0_8_321 VPWR VGND VPWR VGND sky130_ef_sc_hd__decap_12
XFILLER_0_8_365 VPWR VGND VPWR VGND sky130_ef_sc_hd__decap_12
Xaccumulator._1205_ accumulator._0292_ accumulator._0304_ VGND VGND VPWR VPWR accumulator._0305_
+ sky130_fd_sc_hd__xnor2_2
Xaccumulator._1969_ accumulator._0850_ accumulator._1066_ VGND VGND VPWR VPWR accumulator._1067_
+ sky130_fd_sc_hd__xnor2_1
XFILLER_0_31_102 VGND VGND VPWR VPWR sky130_fd_sc_hd__decap_3
Xoperator._087_ operator._018_ operator._023_ operator._024_ operator._020_ VGND VGND
+ VPWR VPWR operator._025_ sky130_fd_sc_hd__o22a_1
XFILLER_0_39_235 VPWR VGND VPWR VGND sky130_ef_sc_hd__decap_12
XFILLER_0_39_279 VGND VGND VPWR VPWR sky130_fd_sc_hd__fill_1
XFILLER_0_22_124 VGND VGND VPWR VPWR sky130_fd_sc_hd__decap_4
XFILLER_0_26_55 VGND VGND VPWR VPWR sky130_fd_sc_hd__decap_8
Xaccumulator._1823_ accumulator._0772_ accumulator._0920_ VGND VGND VPWR VPWR accumulator._0921_
+ sky130_fd_sc_hd__xnor2_2
XFILLER_0_41_400 VGND VGND VPWR VPWR sky130_fd_sc_hd__decap_4
XFILLER_0_5_335 VGND VGND VPWR VPWR sky130_fd_sc_hd__fill_1
XFILLER_0_13_113 VPWR VGND VPWR VGND sky130_ef_sc_hd__decap_12
XFILLER_0_67_51 VGND VGND VPWR VPWR sky130_fd_sc_hd__decap_4
Xaccumulator._1754_ accumulator._0685_ accumulator._0700_ VGND VGND VPWR VPWR accumulator._0852_
+ sky130_fd_sc_hd__and2b_1
Xaccumulator._1685_ accumulator._0534_ accumulator._0668_ VGND VGND VPWR VPWR accumulator._0783_
+ sky130_fd_sc_hd__nand2_1
XTAP_TAPCELL_ROW_49_491 VGND VPWR sky130_fd_sc_hd__tapvpwrvgnd_1
Xaccumulator._2306_ clknet_2_2__leaf_clock accumulator._0013_ VGND VGND VPWR VPWR
+ accumulator.io_accOut\[11\] sky130_fd_sc_hd__dfxtp_2
Xrebuffer32 accumulator._0434_ VGND VGND VPWR VPWR net95 sky130_fd_sc_hd__clkbuf_1
Xrebuffer10 accumulator._0405_ VGND VGND VPWR VPWR net73 sky130_fd_sc_hd__dlymetal6s2s_1
Xaccumulator._2237_ accumulator._0211_ accumulator._1096_ VGND VGND VPWR VPWR accumulator._0218_
+ sky130_fd_sc_hd__or2b_1
XTAP_TAPCELL_ROW_24_314 VGND VPWR sky130_fd_sc_hd__tapvpwrvgnd_1
Xrebuffer21 accumulator._0282_ VGND VGND VPWR VPWR net84 sky130_fd_sc_hd__dlygate4sd1_1
XPHY_EDGE_ROW_16_Left_85 VGND VGND VPWR VPWR sky130_fd_sc_hd__decap_3
Xaccumulator._2099_ accumulator._0084_ accumulator._0071_ accumulator._1097_ VGND
+ VGND VPWR VPWR accumulator._0085_ sky130_fd_sc_hd__mux2_2
Xaccumulator._2168_ accumulator._0146_ accumulator._0150_ accumulator._0151_ VGND
+ VGND VPWR VPWR accumulator._0153_ sky130_fd_sc_hd__a21o_1
XFILLER_0_36_238 VPWR VGND VPWR VGND sky130_ef_sc_hd__decap_12
XFILLER_0_36_216 VGND VGND VPWR VPWR sky130_fd_sc_hd__decap_6
XFILLER_0_59_308 VGND VGND VPWR VPWR sky130_fd_sc_hd__decap_8
XFILLER_0_67_385 VGND VGND VPWR VPWR sky130_fd_sc_hd__decap_6
Xaccumulator._1470_ accumulator._0524_ accumulator._0531_ accumulator._0400_ VGND
+ VGND VPWR VPWR accumulator._0568_ sky130_fd_sc_hd__a21o_1
XTAP_TAPCELL_ROW_46_472 VGND VPWR sky130_fd_sc_hd__tapvpwrvgnd_1
XTAP_TAPCELL_ROW_38_417 VGND VPWR sky130_fd_sc_hd__tapvpwrvgnd_1
Xaccumulator._2022_ accumulator._1119_ VGND VGND VPWR VPWR accumulator._1120_ sky130_fd_sc_hd__buf_8
XFILLER_0_33_208 VGND VGND VPWR VPWR sky130_fd_sc_hd__decap_8
Xaccumulator._1806_ accumulator._0816_ accumulator._0884_ accumulator._0886_ VGND
+ VGND VPWR VPWR accumulator._0904_ sky130_fd_sc_hd__and3_1
XFILLER_0_41_274 VGND VGND VPWR VPWR sky130_fd_sc_hd__fill_1
XFILLER_0_1_393 VPWR VGND VPWR VGND sky130_ef_sc_hd__decap_12
Xaccumulator._1668_ accumulator._0759_ accumulator._0765_ VGND VGND VPWR VPWR accumulator._0766_
+ sky130_fd_sc_hd__or2_1
Xaccumulator._1737_ accumulator._0695_ accumulator._0697_ accumulator._0698_ VGND
+ VGND VPWR VPWR accumulator._0835_ sky130_fd_sc_hd__nand3_2
Xaccumulator._1599_ accumulator._0512_ accumulator._0654_ accumulator._0581_ accumulator._0696_
+ accumulator._0394_ VGND VGND VPWR VPWR accumulator._0697_ sky130_fd_sc_hd__a2111o_1
XFILLER_0_64_344 VGND VGND VPWR VPWR sky130_fd_sc_hd__decap_8
XFILLER_0_64_377 VPWR VGND VPWR VGND sky130_ef_sc_hd__decap_12
XFILLER_0_59_149 VPWR VGND VPWR VGND sky130_ef_sc_hd__decap_12
XFILLER_0_59_105 VGND VGND VPWR VPWR sky130_fd_sc_hd__decap_6
XFILLER_0_23_89 VPWR VGND VPWR VGND sky130_ef_sc_hd__decap_12
XFILLER_0_23_78 VGND VGND VPWR VPWR sky130_fd_sc_hd__decap_8
XFILLER_0_64_41 VPWR VGND VPWR VGND sky130_ef_sc_hd__decap_12
XFILLER_0_48_97 VPWR VGND VPWR VGND sky130_ef_sc_hd__decap_12
XFILLER_0_48_75 VGND VGND VPWR VPWR sky130_fd_sc_hd__decap_8
Xaccumulator._1522_ accumulator._0411_ accumulator._0612_ accumulator._0619_ accumulator._0395_
+ VGND VGND VPWR VPWR accumulator._0620_ sky130_fd_sc_hd__a211oi_1
Xaccumulator._1453_ accumulator._0454_ accumulator._0497_ accumulator._0490_ VGND
+ VGND VPWR VPWR accumulator._0551_ sky130_fd_sc_hd__a21o_1
XFILLER_0_3_55 VGND VGND VPWR VPWR sky130_fd_sc_hd__fill_1
Xaccumulator._2005_ accumulator._1014_ accumulator._1101_ accumulator._1102_ VGND
+ VGND VPWR VPWR accumulator._1103_ sky130_fd_sc_hd__o21a_1
Xaccumulator._1384_ accumulator._0475_ accumulator._0481_ accumulator._0413_ VGND
+ VGND VPWR VPWR accumulator._0482_ sky130_fd_sc_hd__a21o_1
XTAP_TAPCELL_ROW_57_545 VGND VPWR sky130_fd_sc_hd__tapvpwrvgnd_1
XTAP_TAPCELL_ROW_6_189 VGND VPWR sky130_fd_sc_hd__tapvpwrvgnd_1
XFILLER_0_64_141 VPWR VGND VPWR VGND sky130_ef_sc_hd__decap_12
XFILLER_0_56_119 VGND VGND VPWR VPWR sky130_fd_sc_hd__decap_4
XFILLER_0_60_380 VPWR VGND VPWR VGND sky130_ef_sc_hd__decap_12
XFILLER_0_52_347 VGND VGND VPWR VPWR sky130_fd_sc_hd__fill_1
XscaleAdd._441_ scaleAdd._108_ scaleAdd._109_ scaleAdd._117_ VGND VGND VPWR VPWR scaleAdd._119_
+ sky130_fd_sc_hd__or3b_1
XscaleAdd._372_ scaleAdd._040_ scaleAdd._052_ VGND VGND VPWR VPWR scaleAdd._053_ sky130_fd_sc_hd__xor2_2
XscaleAdd._510_ scaleAdd._165_ scaleAdd._168_ scaleAdd._179_ VGND VGND VPWR VPWR scaleAdd._181_
+ sky130_fd_sc_hd__nand3_1
XFILLER_0_20_211 VGND VGND VPWR VPWR sky130_fd_sc_hd__decap_8
X_12_ accumulator.io_accOut\[12\] VGND VGND VPWR VPWR net32 sky130_fd_sc_hd__buf_1
XFILLER_0_18_67 VGND VGND VPWR VPWR sky130_fd_sc_hd__decap_4
XFILLER_0_7_205 VPWR VGND VPWR VGND sky130_ef_sc_hd__decap_12
XFILLER_0_28_388 VGND VGND VPWR VPWR sky130_fd_sc_hd__decap_4
XFILLER_0_51_391 VGND VGND VPWR VPWR sky130_fd_sc_hd__fill_1
Xclkbuf_2_0__f_clock clknet_0_clock VGND VGND VPWR VPWR clknet_2_0__leaf_clock sky130_fd_sc_hd__clkbuf_16
XFILLER_0_11_222 VGND VGND VPWR VPWR sky130_fd_sc_hd__fill_2
XTAP_TAPCELL_ROW_54_526 VGND VPWR sky130_fd_sc_hd__tapvpwrvgnd_1
Xaccumulator._1436_ accumulator._0533_ VGND VGND VPWR VPWR accumulator._0534_ sky130_fd_sc_hd__clkbuf_4
XFILLER_0_38_3 VPWR VGND VPWR VGND sky130_ef_sc_hd__decap_12
Xaccumulator._1505_ accumulator._0490_ net72 accumulator._0406_ accumulator._0435_
+ VGND VGND VPWR VPWR accumulator._0603_ sky130_fd_sc_hd__nor4_1
Xaccumulator._1367_ accumulator.io_inMant\[10\] accumulator.io_inMant\[9\] accumulator._0415_
+ VGND VGND VPWR VPWR accumulator._0465_ sky130_fd_sc_hd__mux2_1
XTAP_TAPCELL_ROW_62_581 VGND VPWR sky130_fd_sc_hd__tapvpwrvgnd_1
XFILLER_0_61_100 VGND VGND VPWR VPWR sky130_fd_sc_hd__decap_8
Xaccumulator._1298_ accumulator._0395_ VGND VGND VPWR VPWR accumulator._0396_ sky130_fd_sc_hd__buf_2
XFILLER_0_46_174 VPWR VGND VPWR VGND sky130_ef_sc_hd__decap_12
XFILLER_0_46_141 VGND VGND VPWR VPWR sky130_fd_sc_hd__decap_8
XFILLER_0_46_130 VGND VGND VPWR VPWR sky130_fd_sc_hd__fill_1
XFILLER_0_38_108 VPWR VGND VPWR VGND sky130_ef_sc_hd__decap_12
XTAP_TAPCELL_ROW_19_280 VGND VPWR sky130_fd_sc_hd__tapvpwrvgnd_1
XFILLER_0_19_355 VGND VGND VPWR VPWR sky130_fd_sc_hd__fill_2
XFILLER_0_19_388 VGND VGND VPWR VPWR sky130_fd_sc_hd__decap_4
XFILLER_0_25_369 VGND VGND VPWR VPWR sky130_fd_sc_hd__fill_2
XFILLER_0_25_325 VGND VGND VPWR VPWR sky130_fd_sc_hd__decap_3
XPHY_EDGE_ROW_4_Left_73 VGND VGND VPWR VPWR sky130_fd_sc_hd__decap_3
XFILLER_0_29_33 VGND VGND VPWR VPWR sky130_fd_sc_hd__fill_1
XscaleAdd._424_ scaleAdd._084_ net97 VGND VGND VPWR VPWR scaleAdd._103_ sky130_fd_sc_hd__or2_4
XscaleAdd._355_ scaleAdd._035_ scaleAdd._036_ VGND VGND VPWR VPWR scaleAdd._037_ sky130_fd_sc_hd__or2_1
XTAP_TAPCELL_ROW_68_629 VGND VPWR sky130_fd_sc_hd__tapvpwrvgnd_1
XscaleAdd._286_ net15 scaleAdd._234_ scaleAdd._235_ VGND VGND VPWR VPWR scaleAdd._237_
+ sky130_fd_sc_hd__nor3_2
Xaccumulator._2270_ accumulator._0238_ accumulator._0251_ VGND VGND VPWR VPWR accumulator._0252_
+ sky130_fd_sc_hd__xnor2_1
Xaccumulator._1221_ accumulator._0305_ accumulator._0298_ accumulator._0320_ accumulator._0297_
+ VGND VGND VPWR VPWR accumulator._0321_ sky130_fd_sc_hd__a31o_4
XTAP_TAPCELL_ROW_51_507 VGND VPWR sky130_fd_sc_hd__tapvpwrvgnd_1
Xaccumulator._1152_ accumulator._0054_ accumulator._0064_ VGND VGND VPWR VPWR accumulator._0074_
+ sky130_fd_sc_hd__nand2_2
XTAP_TAPCELL_ROW_16_261 VGND VPWR sky130_fd_sc_hd__tapvpwrvgnd_1
Xaccumulator._1985_ accumulator._0903_ accumulator._0966_ VGND VGND VPWR VPWR accumulator._1083_
+ sky130_fd_sc_hd__nand2_1
XFILLER_0_43_144 VPWR VGND VPWR VGND sky130_ef_sc_hd__decap_12
XTAP_TAPCELL_ROW_8_207 VGND VPWR sky130_fd_sc_hd__tapvpwrvgnd_1
XFILLER_0_9_54 VGND VGND VPWR VPWR sky130_fd_sc_hd__fill_2
Xaccumulator._1419_ accumulator.io_accOut\[18\] accumulator._0516_ accumulator._0347_
+ VGND VGND VPWR VPWR accumulator._0517_ sky130_fd_sc_hd__mux2_1
XFILLER_0_34_133 VGND VGND VPWR VPWR sky130_fd_sc_hd__decap_6
XPHY_EDGE_ROW_30_Left_99 VGND VGND VPWR VPWR sky130_fd_sc_hd__decap_3
XFILLER_0_19_196 VGND VGND VPWR VPWR sky130_fd_sc_hd__decap_4
XFILLER_0_30_361 VGND VGND VPWR VPWR sky130_fd_sc_hd__decap_3
XFILLER_0_57_225 VPWR VGND VPWR VGND sky130_ef_sc_hd__decap_12
XFILLER_0_57_214 VGND VGND VPWR VPWR sky130_fd_sc_hd__fill_2
XTAP_TAPCELL_ROW_13_242 VGND VPWR sky130_fd_sc_hd__tapvpwrvgnd_1
XFILLER_0_15_57 VPWR VGND VPWR VGND sky130_ef_sc_hd__decap_12
Xaccumulator._1770_ accumulator._0745_ accumulator._0752_ VGND VGND VPWR VPWR accumulator._0868_
+ sky130_fd_sc_hd__or2_1
XFILLER_0_40_158 VGND VGND VPWR VPWR sky130_fd_sc_hd__fill_2
XFILLER_0_31_78 VGND VGND VPWR VPWR sky130_fd_sc_hd__fill_2
XFILLER_0_25_177 VGND VGND VPWR VPWR sky130_fd_sc_hd__fill_1
XFILLER_0_25_111 VGND VGND VPWR VPWR sky130_fd_sc_hd__fill_1
XscaleAdd._407_ scaleAdd._062_ scaleAdd._078_ scaleAdd._085_ VGND VGND VPWR VPWR scaleAdd._086_
+ sky130_fd_sc_hd__o21ai_2
XFILLER_0_0_277 VGND VGND VPWR VPWR sky130_fd_sc_hd__decap_3
XscaleAdd._338_ scaleAdd._221_ operator.io_outMant\[4\] scaleAdd._224_ scaleAdd._226_
+ operator.io_outMant\[5\] VGND VGND VPWR VPWR scaleAdd._020_ sky130_fd_sc_hd__a32o_1
XFILLER_0_48_225 VPWR VGND VPWR VGND sky130_ef_sc_hd__decap_12
Xaccumulator._2184_ accumulator._0162_ accumulator._0167_ accumulator._0362_ VGND
+ VGND VPWR VPWR accumulator._0019_ sky130_fd_sc_hd__a21oi_1
Xaccumulator._2253_ accumulator._0232_ accumulator._0234_ VGND VGND VPWR VPWR accumulator._0235_
+ sky130_fd_sc_hd__xor2_1
XscaleAdd._269_ net14 net15 VGND VGND VPWR VPWR scaleAdd._222_ sky130_fd_sc_hd__and2b_1
Xaccumulator._2322_ clknet_2_1__leaf_clock accumulator._0029_ VGND VGND VPWR VPWR
+ accumulator.io_accOut\[27\] sky130_fd_sc_hd__dfxtp_2
Xaccumulator._1204_ accumulator.io_inExp\[5\] accumulator._0290_ accumulator._0289_
+ net68 VGND VGND VPWR VPWR accumulator._0304_ sky130_fd_sc_hd__o2bb2a_2
XFILLER_0_22_6 VPWR VGND VPWR VGND sky130_ef_sc_hd__decap_12
XFILLER_0_8_333 VPWR VGND VPWR VGND sky130_ef_sc_hd__decap_12
XFILLER_0_8_377 VPWR VGND VPWR VGND sky130_ef_sc_hd__decap_12
Xaccumulator._1968_ accumulator._0367_ accumulator._1065_ VGND VGND VPWR VPWR accumulator._1066_
+ sky130_fd_sc_hd__nor2_1
Xaccumulator._1899_ accumulator._0993_ accumulator._0996_ VGND VGND VPWR VPWR accumulator._0997_
+ sky130_fd_sc_hd__nand2_2
Xoperator._086_ net11 net10 net9 net1 VGND VGND VPWR VPWR operator._024_ sky130_fd_sc_hd__o31a_1
XFILLER_0_39_247 VPWR VGND VPWR VGND sky130_ef_sc_hd__decap_12
XFILLER_0_39_225 VGND VGND VPWR VPWR sky130_fd_sc_hd__fill_1
XTAP_TAPCELL_ROW_27_334 VGND VPWR sky130_fd_sc_hd__tapvpwrvgnd_1
XFILLER_0_62_283 VGND VGND VPWR VPWR sky130_fd_sc_hd__decap_6
XFILLER_0_30_180 VGND VGND VPWR VPWR sky130_fd_sc_hd__decap_3
XFILLER_0_22_169 VGND VGND VPWR VPWR sky130_fd_sc_hd__decap_8
XFILLER_0_10_309 VPWR VGND VPWR VGND sky130_ef_sc_hd__decap_12
XFILLER_0_38_280 VGND VGND VPWR VPWR sky130_fd_sc_hd__decap_6
Xaccumulator._1822_ accumulator._0767_ accumulator._0919_ accumulator._0816_ VGND
+ VGND VPWR VPWR accumulator._0920_ sky130_fd_sc_hd__mux2_1
Xaccumulator._1753_ accumulator._0699_ accumulator._0835_ accumulator._0839_ accumulator._0844_
+ accumulator._0850_ VGND VGND VPWR VPWR accumulator._0851_ sky130_fd_sc_hd__a2111o_4
XFILLER_0_13_125 VPWR VGND VPWR VGND sky130_ef_sc_hd__decap_12
XFILLER_0_13_169 VGND VGND VPWR VPWR sky130_fd_sc_hd__decap_8
Xaccumulator._1684_ accumulator._0767_ accumulator._0779_ accumulator._0781_ VGND
+ VGND VPWR VPWR accumulator._0782_ sky130_fd_sc_hd__o21bai_1
Xrebuffer11 accumulator._0341_ VGND VGND VPWR VPWR net74 sky130_fd_sc_hd__dlymetal6s2s_1
XFILLER_0_68_309 VPWR VGND VPWR VGND sky130_ef_sc_hd__decap_12
XTAP_TAPCELL_ROW_49_492 VGND VPWR sky130_fd_sc_hd__tapvpwrvgnd_1
Xaccumulator._2305_ clknet_2_2__leaf_clock accumulator._0012_ VGND VGND VPWR VPWR
+ accumulator.io_accOut\[10\] sky130_fd_sc_hd__dfxtp_1
Xaccumulator._2167_ accumulator._0046_ accumulator._0049_ accumulator._0121_ accumulator._0350_
+ VGND VGND VPWR VPWR accumulator._0151_ sky130_fd_sc_hd__a31o_1
Xaccumulator._2236_ accumulator._0216_ accumulator._1137_ VGND VGND VPWR VPWR accumulator._0217_
+ sky130_fd_sc_hd__xnor2_1
Xrebuffer22 accumulator._0034_ VGND VGND VPWR VPWR net85 sky130_fd_sc_hd__dlymetal6s2s_1
XTAP_TAPCELL_ROW_24_315 VGND VPWR sky130_fd_sc_hd__tapvpwrvgnd_1
Xrebuffer33 accumulator._0311_ VGND VGND VPWR VPWR net96 sky130_fd_sc_hd__dlygate4sd1_1
Xaccumulator._2098_ accumulator._1046_ accumulator._1048_ accumulator._1120_ VGND
+ VGND VPWR VPWR accumulator._0084_ sky130_fd_sc_hd__mux2_2
XFILLER_0_51_209 VPWR VGND VPWR VGND sky130_ef_sc_hd__decap_12
XTAP_TAPCELL_ROW_32_370 VGND VPWR sky130_fd_sc_hd__tapvpwrvgnd_1
XFILLER_0_8_141 VGND VGND VPWR VPWR sky130_fd_sc_hd__decap_3
XFILLER_0_8_174 VPWR VGND VPWR VGND sky130_ef_sc_hd__decap_12
XFILLER_0_12_180 VPWR VGND VPWR VGND sky130_ef_sc_hd__decap_12
Xoperator._069_ net4 VGND VGND VPWR VPWR operator._012_ sky130_fd_sc_hd__inv_2
XFILLER_0_12_36 VPWR VGND VPWR VGND sky130_ef_sc_hd__decap_12
XFILLER_0_50_253 VGND VGND VPWR VPWR sky130_fd_sc_hd__fill_1
XFILLER_0_10_139 VGND VGND VPWR VPWR sky130_fd_sc_hd__fill_1
XFILLER_0_37_77 VGND VGND VPWR VPWR sky130_fd_sc_hd__fill_2
XFILLER_0_37_55 VGND VGND VPWR VPWR sky130_fd_sc_hd__fill_1
Xaccumulator._2021_ accumulator._1118_ VGND VGND VPWR VPWR accumulator._1119_ sky130_fd_sc_hd__buf_6
XTAP_TAPCELL_ROW_46_473 VGND VPWR sky130_fd_sc_hd__tapvpwrvgnd_1
XFILLER_0_5_177 VPWR VGND VPWR VGND sky130_ef_sc_hd__decap_12
XFILLER_0_14_401 VGND VGND VPWR VPWR sky130_fd_sc_hd__decap_4
XFILLER_0_68_3 VPWR VGND VPWR VGND sky130_ef_sc_hd__decap_12
Xaccumulator._1805_ accumulator._0902_ VGND VGND VPWR VPWR accumulator._0903_ sky130_fd_sc_hd__buf_2
Xaccumulator._1736_ accumulator._0698_ net90 accumulator._0695_ VGND VGND VPWR VPWR
+ accumulator._0834_ sky130_fd_sc_hd__nand3b_1
XFILLER_0_1_361 VPWR VGND VPWR VGND sky130_ef_sc_hd__decap_12
Xaccumulator._1667_ accumulator._0763_ accumulator._0764_ accumulator._0744_ VGND
+ VGND VPWR VPWR accumulator._0765_ sky130_fd_sc_hd__a21o_1
Xaccumulator._1598_ accumulator._0642_ accumulator._0643_ accumulator._0400_ VGND
+ VGND VPWR VPWR accumulator._0696_ sky130_fd_sc_hd__a21oi_1
XFILLER_0_64_323 VPWR VGND VPWR VGND sky130_ef_sc_hd__decap_12
Xaccumulator._2219_ accumulator._0199_ accumulator._0201_ accumulator._1031_ VGND
+ VGND VPWR VPWR accumulator._0202_ sky130_fd_sc_hd__a21o_1
XFILLER_0_64_389 VPWR VGND VPWR VGND sky130_ef_sc_hd__decap_12
XFILLER_0_32_253 VGND VGND VPWR VPWR sky130_fd_sc_hd__fill_1
XFILLER_0_20_404 VGND VGND VPWR VPWR sky130_fd_sc_hd__fill_1
XFILLER_0_67_150 VGND VGND VPWR VPWR sky130_fd_sc_hd__decap_4
XFILLER_0_55_301 VGND VGND VPWR VPWR sky130_fd_sc_hd__decap_8
XFILLER_0_23_220 VGND VGND VPWR VPWR sky130_fd_sc_hd__decap_4
XFILLER_0_64_53 VPWR VGND VPWR VGND sky130_ef_sc_hd__decap_12
Xaccumulator._1521_ accumulator._0400_ accumulator._0618_ VGND VGND VPWR VPWR accumulator._0619_
+ sky130_fd_sc_hd__nor2_1
Xaccumulator._1452_ accumulator._0454_ accumulator._0529_ accumulator._0455_ VGND
+ VGND VPWR VPWR accumulator._0550_ sky130_fd_sc_hd__a21o_1
Xaccumulator._1383_ accumulator.io_accOut\[20\] accumulator._0480_ accumulator._0346_
+ VGND VGND VPWR VPWR accumulator._0481_ sky130_fd_sc_hd__mux2_1
Xaccumulator._2004_ accumulator._0891_ accumulator._0900_ accumulator._1100_ VGND
+ VGND VPWR VPWR accumulator._1102_ sky130_fd_sc_hd__or3b_1
XFILLER_0_61_337 VGND VGND VPWR VPWR sky130_fd_sc_hd__fill_1
XFILLER_0_14_220 VPWR VGND VPWR VGND sky130_ef_sc_hd__decap_12
Xaccumulator._1719_ accumulator._0445_ accumulator._0811_ VGND VGND VPWR VPWR accumulator._0817_
+ sky130_fd_sc_hd__nor2_2
XTAP_TAPCELL_ROW_57_546 VGND VPWR sky130_fd_sc_hd__tapvpwrvgnd_1
XPHY_EDGE_ROW_29_Right_29 VGND VGND VPWR VPWR sky130_fd_sc_hd__decap_3
XFILLER_0_64_197 VGND VGND VPWR VPWR sky130_fd_sc_hd__fill_1
XFILLER_0_64_153 VPWR VGND VPWR VGND sky130_ef_sc_hd__decap_12
XFILLER_0_64_131 VGND VGND VPWR VPWR sky130_fd_sc_hd__decap_8
XFILLER_0_52_315 VGND VGND VPWR VPWR sky130_fd_sc_hd__fill_1
XFILLER_0_49_161 VGND VGND VPWR VPWR sky130_fd_sc_hd__decap_6
XPHY_EDGE_ROW_38_Right_38 VGND VGND VPWR VPWR sky130_fd_sc_hd__decap_3
XFILLER_0_60_392 VPWR VGND VPWR VGND sky130_ef_sc_hd__decap_12
XscaleAdd._440_ scaleAdd._108_ scaleAdd._109_ scaleAdd._117_ VGND VGND VPWR VPWR scaleAdd._118_
+ sky130_fd_sc_hd__o21ba_1
XscaleAdd._371_ scaleAdd._021_ scaleAdd._051_ VGND VGND VPWR VPWR scaleAdd._052_ sky130_fd_sc_hd__xor2_2
XFILLER_0_20_201 VGND VGND VPWR VPWR sky130_fd_sc_hd__fill_1
XPHY_EDGE_ROW_47_Right_47 VGND VGND VPWR VPWR sky130_fd_sc_hd__decap_3
X_11_ accumulator.io_accOut\[11\] VGND VGND VPWR VPWR net31 sky130_fd_sc_hd__buf_1
XFILLER_0_18_24 VGND VGND VPWR VPWR sky130_fd_sc_hd__decap_4
XPHY_EDGE_ROW_56_Right_56 VGND VGND VPWR VPWR sky130_fd_sc_hd__decap_3
XFILLER_0_47_109 VGND VGND VPWR VPWR sky130_fd_sc_hd__decap_3
XFILLER_0_7_217 VGND VGND VPWR VPWR sky130_fd_sc_hd__decap_6
XFILLER_0_50_66 VPWR VGND VPWR VGND sky130_ef_sc_hd__decap_12
XFILLER_0_43_304 VGND VGND VPWR VPWR sky130_fd_sc_hd__decap_8
XPHY_EDGE_ROW_65_Right_65 VGND VGND VPWR VPWR sky130_fd_sc_hd__decap_3
Xaccumulator._1504_ accumulator._0450_ accumulator._0598_ accumulator._0601_ accumulator._0396_
+ VGND VGND VPWR VPWR accumulator._0602_ sky130_fd_sc_hd__a211oi_1
XTAP_TAPCELL_ROW_54_527 VGND VPWR sky130_fd_sc_hd__tapvpwrvgnd_1
Xaccumulator._1435_ accumulator._0386_ accumulator._0388_ VGND VGND VPWR VPWR accumulator._0533_
+ sky130_fd_sc_hd__and2b_1
Xclone7 accumulator._0451_ accumulator._0452_ net71 VGND VGND VPWR VPWR net70 sky130_fd_sc_hd__mux2_2
Xaccumulator._1366_ accumulator._0462_ accumulator._0463_ accumulator._0427_ VGND
+ VGND VPWR VPWR accumulator._0464_ sky130_fd_sc_hd__mux2_1
XTAP_TAPCELL_ROW_19_281 VGND VPWR sky130_fd_sc_hd__tapvpwrvgnd_1
XTAP_TAPCELL_ROW_62_582 VGND VPWR sky130_fd_sc_hd__tapvpwrvgnd_1
XFILLER_0_61_134 VGND VGND VPWR VPWR sky130_fd_sc_hd__fill_1
Xaccumulator._1297_ accumulator._0394_ VGND VGND VPWR VPWR accumulator._0395_ sky130_fd_sc_hd__buf_2
XFILLER_0_46_186 VGND VGND VPWR VPWR sky130_fd_sc_hd__decap_8
XTAP_TAPCELL_ROW_2_160 VGND VPWR sky130_fd_sc_hd__tapvpwrvgnd_1
XFILLER_0_52_134 VGND VGND VPWR VPWR sky130_fd_sc_hd__decap_6
XFILLER_0_52_101 VGND VGND VPWR VPWR sky130_fd_sc_hd__fill_1
XFILLER_0_40_318 VPWR VGND VPWR VGND sky130_ef_sc_hd__decap_12
XFILLER_0_25_337 VPWR VGND VPWR VGND sky130_ef_sc_hd__decap_12
XscaleAdd._423_ scaleAdd._084_ scaleAdd._101_ VGND VGND VPWR VPWR scaleAdd._102_ sky130_fd_sc_hd__and2_1
XscaleAdd._354_ scaleAdd._031_ scaleAdd._032_ scaleAdd._034_ VGND VGND VPWR VPWR scaleAdd._036_
+ sky130_fd_sc_hd__and3_1
XscaleAdd._285_ scaleAdd._234_ scaleAdd._235_ net15 VGND VGND VPWR VPWR scaleAdd._236_
+ sky130_fd_sc_hd__o21a_2
XFILLER_0_45_55 VGND VGND VPWR VPWR sky130_fd_sc_hd__fill_1
Xaccumulator._1151_ accumulator.io_inMant\[8\] accumulator.io_inMant\[7\] accumulator.io_inMant\[9\]
+ accumulator.io_inMant\[10\] VGND VGND VPWR VPWR accumulator._0064_ sky130_fd_sc_hd__or4_4
Xaccumulator._1220_ accumulator._0309_ accumulator._0303_ accumulator._0318_ accumulator._0319_
+ VGND VGND VPWR VPWR accumulator._0320_ sky130_fd_sc_hd__and4_1
XTAP_TAPCELL_ROW_51_508 VGND VPWR sky130_fd_sc_hd__tapvpwrvgnd_1
XFILLER_0_28_153 VGND VGND VPWR VPWR sky130_fd_sc_hd__decap_3
XFILLER_0_0_57 VPWR VGND VPWR VGND sky130_ef_sc_hd__decap_12
XTAP_TAPCELL_ROW_16_262 VGND VPWR sky130_fd_sc_hd__tapvpwrvgnd_1
Xaccumulator._1984_ accumulator._0937_ accumulator._1081_ VGND VGND VPWR VPWR accumulator._1082_
+ sky130_fd_sc_hd__xor2_1
XFILLER_0_43_189 VGND VGND VPWR VPWR sky130_fd_sc_hd__fill_1
XFILLER_0_43_156 VPWR VGND VPWR VGND sky130_ef_sc_hd__decap_12
XFILLER_0_31_318 VGND VGND VPWR VPWR sky130_fd_sc_hd__decap_6
XFILLER_0_24_381 VGND VGND VPWR VPWR sky130_fd_sc_hd__fill_1
XFILLER_0_10_91 VGND VGND VPWR VPWR sky130_fd_sc_hd__fill_1
XFILLER_0_50_3 VPWR VGND VPWR VGND sky130_ef_sc_hd__decap_12
Xaccumulator._1349_ accumulator._0446_ VGND VGND VPWR VPWR accumulator._0447_ sky130_fd_sc_hd__clkbuf_4
Xaccumulator._1418_ accumulator._0513_ accumulator._0422_ accumulator._0515_ VGND
+ VGND VPWR VPWR accumulator._0516_ sky130_fd_sc_hd__a21o_1
XFILLER_0_34_189 VGND VGND VPWR VPWR sky130_fd_sc_hd__decap_6
XFILLER_0_34_167 VGND VGND VPWR VPWR sky130_fd_sc_hd__fill_1
XFILLER_0_22_318 VGND VGND VPWR VPWR sky130_fd_sc_hd__decap_6
XFILLER_0_22_307 VGND VGND VPWR VPWR sky130_fd_sc_hd__fill_1
XFILLER_0_57_237 VPWR VGND VPWR VGND sky130_ef_sc_hd__decap_12
XFILLER_0_31_57 VPWR VGND VPWR VGND sky130_ef_sc_hd__decap_12
Xaccumulator._2321_ clknet_2_1__leaf_clock accumulator._0028_ VGND VGND VPWR VPWR
+ accumulator.io_accOut\[26\] sky130_fd_sc_hd__dfxtp_1
XscaleAdd._406_ scaleAdd._064_ scaleAdd._077_ VGND VGND VPWR VPWR scaleAdd._085_ sky130_fd_sc_hd__or2_1
XscaleAdd._337_ operator.io_outMant\[1\] scaleAdd._009_ scaleAdd._016_ scaleAdd._017_
+ VGND VGND VPWR VPWR scaleAdd._019_ sky130_fd_sc_hd__nand4_2
XscaleAdd._268_ net13 VGND VGND VPWR VPWR scaleAdd._221_ sky130_fd_sc_hd__buf_2
XFILLER_0_48_237 VPWR VGND VPWR VGND sky130_ef_sc_hd__decap_12
Xaccumulator._2183_ accumulator.io_accOut\[17\] accumulator._0364_ accumulator._1031_
+ accumulator._0166_ VGND VGND VPWR VPWR accumulator._0167_ sky130_fd_sc_hd__o2bb2a_1
Xaccumulator._2252_ accumulator._0222_ accumulator._0205_ accumulator._0233_ net92
+ accumulator._0220_ VGND VGND VPWR VPWR accumulator._0234_ sky130_fd_sc_hd__a41o_1
XFILLER_0_8_301 VGND VGND VPWR VPWR sky130_fd_sc_hd__decap_6
XFILLER_0_15_6 VPWR VGND VPWR VGND sky130_ef_sc_hd__decap_12
Xaccumulator._1203_ accumulator._0302_ net84 VGND VGND VPWR VPWR accumulator._0303_
+ sky130_fd_sc_hd__xnor2_2
XFILLER_0_8_345 VPWR VGND VPWR VGND sky130_ef_sc_hd__decap_12
XFILLER_0_8_389 VPWR VGND VPWR VGND sky130_ef_sc_hd__decap_12
Xoperator._085_ net9 net10 net11 net2 VGND VGND VPWR VPWR operator._023_ sky130_fd_sc_hd__o31ai_4
Xaccumulator._1967_ accumulator._0839_ accumulator._0844_ VGND VGND VPWR VPWR accumulator._1065_
+ sky130_fd_sc_hd__nor2_1
Xaccumulator._1898_ accumulator._0787_ accumulator._0995_ VGND VGND VPWR VPWR accumulator._0996_
+ sky130_fd_sc_hd__xnor2_2
XFILLER_0_47_281 VGND VGND VPWR VPWR sky130_fd_sc_hd__fill_2
XFILLER_0_39_259 VGND VGND VPWR VPWR sky130_fd_sc_hd__decap_4
XTAP_TAPCELL_ROW_35_390 VGND VPWR sky130_fd_sc_hd__tapvpwrvgnd_1
XPHY_EDGE_ROW_33_Left_102 VGND VGND VPWR VPWR sky130_fd_sc_hd__decap_3
XTAP_TAPCELL_ROW_27_335 VGND VPWR sky130_fd_sc_hd__tapvpwrvgnd_1
XFILLER_0_62_251 VGND VGND VPWR VPWR sky130_fd_sc_hd__fill_1
XPHY_EDGE_ROW_42_Left_111 VGND VGND VPWR VPWR sky130_fd_sc_hd__decap_3
XFILLER_0_30_192 VGND VGND VPWR VPWR sky130_fd_sc_hd__decap_4
XFILLER_0_26_68 VGND VGND VPWR VPWR sky130_fd_sc_hd__fill_1
XFILLER_0_26_35 VGND VGND VPWR VPWR sky130_fd_sc_hd__decap_4
XFILLER_0_53_262 VGND VGND VPWR VPWR sky130_fd_sc_hd__fill_1
XPHY_EDGE_ROW_51_Left_120 VGND VGND VPWR VPWR sky130_fd_sc_hd__decap_3
XFILLER_0_5_337 VPWR VGND VPWR VGND sky130_ef_sc_hd__decap_12
Xaccumulator._1821_ accumulator._0758_ accumulator._0915_ accumulator._0872_ VGND
+ VGND VPWR VPWR accumulator._0919_ sky130_fd_sc_hd__o21ai_1
Xaccumulator._1683_ accumulator._0777_ accumulator._0780_ accumulator._0776_ VGND
+ VGND VPWR VPWR accumulator._0781_ sky130_fd_sc_hd__a21boi_1
Xaccumulator._1752_ accumulator._0669_ accumulator._0753_ accumulator._0754_ accumulator._0845_
+ accumulator._0849_ VGND VGND VPWR VPWR accumulator._0850_ sky130_fd_sc_hd__a32o_1
XFILLER_0_6_34 VGND VGND VPWR VPWR sky130_fd_sc_hd__decap_6
XFILLER_0_13_137 VGND VGND VPWR VPWR sky130_fd_sc_hd__decap_4
XFILLER_0_67_97 VGND VGND VPWR VPWR sky130_fd_sc_hd__fill_1
XTAP_TAPCELL_ROW_49_493 VGND VPWR sky130_fd_sc_hd__tapvpwrvgnd_1
Xaccumulator._2304_ clknet_2_3__leaf_clock accumulator._0011_ VGND VGND VPWR VPWR
+ accumulator.io_accOut\[9\] sky130_fd_sc_hd__dfxtp_1
Xrebuffer12 accumulator._0327_ VGND VGND VPWR VPWR net75 sky130_fd_sc_hd__dlymetal6s4s_1
Xrebuffer34 scaleAdd._101_ VGND VGND VPWR VPWR net97 sky130_fd_sc_hd__clkbuf_1
Xrebuffer23 accumulator._0301_ VGND VGND VPWR VPWR net86 sky130_fd_sc_hd__clkbuf_1
Xaccumulator._2166_ accumulator._0115_ accumulator._0149_ accumulator._0046_ VGND
+ VGND VPWR VPWR accumulator._0150_ sky130_fd_sc_hd__mux2_1
Xaccumulator._2097_ accumulator._0363_ accumulator._0082_ VGND VGND VPWR VPWR accumulator._0008_
+ sky130_fd_sc_hd__nor2_1
XFILLER_0_29_281 VPWR VGND VPWR VGND sky130_ef_sc_hd__decap_12
XTAP_TAPCELL_ROW_24_316 VGND VPWR sky130_fd_sc_hd__tapvpwrvgnd_1
Xaccumulator._2235_ accumulator.io_accOut\[25\] accumulator._0325_ accumulator._0356_
+ VGND VGND VPWR VPWR accumulator._0216_ sky130_fd_sc_hd__mux2_1
XTAP_TAPCELL_ROW_32_371 VGND VPWR sky130_fd_sc_hd__tapvpwrvgnd_1
XFILLER_0_8_186 VGND VGND VPWR VPWR sky130_fd_sc_hd__decap_8
XFILLER_0_8_197 VGND VGND VPWR VPWR sky130_fd_sc_hd__fill_2
Xoperator._068_ operator._009_ operator._010_ VGND VGND VPWR VPWR operator._011_ sky130_fd_sc_hd__nor2_1
XFILLER_0_4_6 VPWR VGND VPWR VGND sky130_ef_sc_hd__decap_12
XFILLER_0_12_192 VGND VGND VPWR VPWR sky130_fd_sc_hd__decap_4
XFILLER_0_67_321 VPWR VGND VPWR VGND sky130_ef_sc_hd__decap_12
XFILLER_0_35_251 VPWR VGND VPWR VGND sky130_ef_sc_hd__decap_12
XFILLER_0_12_48 VPWR VGND VPWR VGND sky130_ef_sc_hd__decap_12
XFILLER_0_50_210 VPWR VGND VPWR VGND sky130_ef_sc_hd__decap_12
XFILLER_0_58_365 VPWR VGND VPWR VGND sky130_ef_sc_hd__decap_12
XFILLER_0_53_77 VPWR VGND VPWR VGND sky130_ef_sc_hd__decap_12
XFILLER_0_53_55 VGND VGND VPWR VPWR sky130_fd_sc_hd__fill_1
Xaccumulator._2020_ accumulator._1115_ accumulator._1117_ accumulator._1023_ VGND
+ VGND VPWR VPWR accumulator._1118_ sky130_fd_sc_hd__a21o_1
XFILLER_0_5_189 VGND VGND VPWR VPWR sky130_fd_sc_hd__decap_8
XFILLER_0_5_167 VGND VGND VPWR VPWR sky130_fd_sc_hd__fill_1
Xaccumulator._1735_ accumulator._0830_ accumulator._0831_ accumulator._0832_ VGND
+ VGND VPWR VPWR accumulator._0833_ sky130_fd_sc_hd__a21oi_1
Xaccumulator._1804_ accumulator._0901_ VGND VGND VPWR VPWR accumulator._0902_ sky130_fd_sc_hd__buf_6
Xaccumulator._1666_ accumulator._0391_ accumulator._0731_ accumulator._0732_ accumulator._0735_
+ VGND VGND VPWR VPWR accumulator._0764_ sky130_fd_sc_hd__or4_2
XFILLER_0_1_373 VPWR VGND VPWR VGND sky130_ef_sc_hd__decap_12
Xaccumulator._1597_ accumulator._0394_ accumulator._0686_ accumulator._0687_ accumulator._0389_
+ accumulator._0694_ VGND VGND VPWR VPWR accumulator._0695_ sky130_fd_sc_hd__a311o_1
Xaccumulator._2218_ accumulator._1026_ accumulator._1095_ accumulator._1138_ accumulator._0172_
+ VGND VGND VPWR VPWR accumulator._0201_ sky130_fd_sc_hd__o2bb2a_1
Xaccumulator._2149_ accumulator._1088_ accumulator._1090_ net94 VGND VGND VPWR VPWR
+ accumulator._0134_ sky130_fd_sc_hd__mux2_1
XFILLER_0_2_3 VPWR VGND VPWR VGND sky130_ef_sc_hd__decap_12
Xrebuffer3 accumulator._0321_ VGND VGND VPWR VPWR net66 sky130_fd_sc_hd__dlymetal6s2s_1
XFILLER_0_23_243 VGND VGND VPWR VPWR sky130_fd_sc_hd__fill_1
XFILLER_0_11_405 VGND VGND VPWR VPWR sky130_fd_sc_hd__decap_4
Xaccumulator._1520_ accumulator._0473_ accumulator._0613_ accumulator._0614_ accumulator._0617_
+ VGND VGND VPWR VPWR accumulator._0618_ sky130_fd_sc_hd__o31ai_2
XFILLER_0_64_65 VGND VGND VPWR VPWR sky130_fd_sc_hd__fill_1
Xaccumulator._1451_ accumulator._0547_ accumulator._0548_ accumulator._0472_ VGND
+ VGND VPWR VPWR accumulator._0549_ sky130_fd_sc_hd__a21o_1
Xaccumulator._1382_ accumulator._0285_ accumulator._0273_ accumulator._0476_ accumulator._0479_
+ VGND VGND VPWR VPWR accumulator._0480_ sky130_fd_sc_hd__a31o_1
XFILLER_0_3_57 VPWR VGND VPWR VGND sky130_ef_sc_hd__decap_12
XFILLER_0_58_162 VGND VGND VPWR VPWR sky130_fd_sc_hd__decap_3
Xaccumulator._2003_ accumulator._1033_ accumulator._1100_ accumulator._1065_ VGND
+ VGND VPWR VPWR accumulator._1101_ sky130_fd_sc_hd__o21ba_1
Xaccumulator._1718_ accumulator._0815_ VGND VGND VPWR VPWR accumulator._0816_ sky130_fd_sc_hd__clkbuf_4
Xaccumulator._1649_ accumulator.io_accOut\[14\] accumulator._0496_ accumulator._0355_
+ VGND VGND VPWR VPWR accumulator._0747_ sky130_fd_sc_hd__mux2_1
XTAP_TAPCELL_ROW_57_547 VGND VPWR sky130_fd_sc_hd__tapvpwrvgnd_1
XFILLER_0_49_140 VGND VGND VPWR VPWR sky130_fd_sc_hd__decap_6
XFILLER_0_64_165 VGND VGND VPWR VPWR sky130_fd_sc_hd__decap_6
XFILLER_0_45_390 VGND VGND VPWR VPWR sky130_fd_sc_hd__fill_2
XTAP_TAPCELL_ROW_40_425 VGND VPWR sky130_fd_sc_hd__tapvpwrvgnd_1
XFILLER_0_37_357 VGND VGND VPWR VPWR sky130_fd_sc_hd__decap_8
XFILLER_0_37_335 VGND VGND VPWR VPWR sky130_fd_sc_hd__fill_1
XFILLER_0_9_281 VPWR VGND VPWR VGND sky130_ef_sc_hd__decap_12
XscaleAdd._370_ scaleAdd._043_ scaleAdd._050_ VGND VGND VPWR VPWR scaleAdd._051_ sky130_fd_sc_hd__xnor2_2
XFILLER_0_20_268 VPWR VGND VPWR VGND sky130_ef_sc_hd__decap_12
X_10_ accumulator.io_accOut\[10\] VGND VGND VPWR VPWR net30 sky130_fd_sc_hd__buf_1
XTAP_TAPCELL_ROW_5_180 VGND VPWR sky130_fd_sc_hd__tapvpwrvgnd_1
XFILLER_0_50_45 VGND VGND VPWR VPWR sky130_fd_sc_hd__fill_1
XFILLER_0_34_79 VGND VGND VPWR VPWR sky130_fd_sc_hd__decap_4
XFILLER_0_34_68 VGND VGND VPWR VPWR sky130_fd_sc_hd__decap_3
XFILLER_0_28_302 VGND VGND VPWR VPWR sky130_fd_sc_hd__decap_6
XFILLER_0_7_229 VGND VGND VPWR VPWR sky130_fd_sc_hd__fill_1
XFILLER_0_50_78 VGND VGND VPWR VPWR sky130_fd_sc_hd__decap_6
Xaccumulator._1434_ accumulator._0512_ accumulator._0524_ accumulator._0531_ VGND
+ VGND VPWR VPWR accumulator._0532_ sky130_fd_sc_hd__and3_1
Xaccumulator._1503_ accumulator._0399_ accumulator._0599_ accumulator._0600_ VGND
+ VGND VPWR VPWR accumulator._0601_ sky130_fd_sc_hd__and3_1
XFILLER_0_11_279 VGND VGND VPWR VPWR sky130_fd_sc_hd__fill_1
XscaleAdd._499_ scaleAdd._170_ VGND VGND VPWR VPWR accumulator.io_inExp\[1\] sky130_fd_sc_hd__buf_1
XTAP_TAPCELL_ROW_54_528 VGND VPWR sky130_fd_sc_hd__tapvpwrvgnd_1
Xaccumulator._1296_ accumulator._0393_ VGND VGND VPWR VPWR accumulator._0394_ sky130_fd_sc_hd__buf_2
Xaccumulator._1365_ accumulator.io_inMant\[8\] accumulator.io_inMant\[7\] accumulator._0415_
+ VGND VGND VPWR VPWR accumulator._0463_ sky130_fd_sc_hd__mux2_1
XTAP_TAPCELL_ROW_19_282 VGND VPWR sky130_fd_sc_hd__tapvpwrvgnd_1
XTAP_TAPCELL_ROW_62_583 VGND VPWR sky130_fd_sc_hd__tapvpwrvgnd_1
XFILLER_0_46_110 VPWR VGND VPWR VGND sky130_ef_sc_hd__decap_12
XFILLER_0_6_284 VPWR VGND VPWR VGND sky130_ef_sc_hd__decap_12
XFILLER_0_19_346 VGND VGND VPWR VPWR sky130_fd_sc_hd__decap_3
XTAP_TAPCELL_ROW_2_161 VGND VPWR sky130_fd_sc_hd__tapvpwrvgnd_1
XFILLER_0_37_165 VGND VGND VPWR VPWR sky130_fd_sc_hd__decap_3
XFILLER_0_52_157 VGND VGND VPWR VPWR sky130_fd_sc_hd__fill_1
XFILLER_0_33_393 VGND VGND VPWR VPWR sky130_fd_sc_hd__decap_8
XFILLER_0_25_349 VGND VGND VPWR VPWR sky130_fd_sc_hd__fill_1
XscaleAdd._422_ scaleAdd._086_ scaleAdd._100_ VGND VGND VPWR VPWR scaleAdd._101_ sky130_fd_sc_hd__xor2_2
XFILLER_0_0_405 VGND VGND VPWR VPWR sky130_fd_sc_hd__decap_4
XFILLER_0_20_26 VGND VGND VPWR VPWR sky130_fd_sc_hd__fill_2
XscaleAdd._284_ net19 net18 net20 VGND VGND VPWR VPWR scaleAdd._235_ sky130_fd_sc_hd__or3_2
XscaleAdd._353_ scaleAdd._031_ scaleAdd._032_ scaleAdd._034_ VGND VGND VPWR VPWR scaleAdd._035_
+ sky130_fd_sc_hd__a21oi_1
Xaccumulator._1150_ net85 VGND VGND VPWR VPWR accumulator._0054_ sky130_fd_sc_hd__inv_2
Xmax_cap1 scaleAdd._000_ VGND VGND VPWR VPWR net103 sky130_fd_sc_hd__buf_1
XFILLER_0_61_55 VGND VGND VPWR VPWR sky130_fd_sc_hd__fill_1
XFILLER_0_43_113 VGND VGND VPWR VPWR sky130_fd_sc_hd__decap_4
XFILLER_0_0_69 VPWR VGND VPWR VGND sky130_ef_sc_hd__decap_12
XTAP_TAPCELL_ROW_16_263 VGND VPWR sky130_fd_sc_hd__tapvpwrvgnd_1
Xaccumulator._1983_ accumulator._0903_ accumulator._1080_ VGND VGND VPWR VPWR accumulator._1081_
+ sky130_fd_sc_hd__and2_1
XFILLER_0_24_393 VGND VGND VPWR VPWR sky130_fd_sc_hd__decap_4
XFILLER_0_3_221 VGND VGND VPWR VPWR sky130_fd_sc_hd__decap_3
XFILLER_0_10_81 VGND VGND VPWR VPWR sky130_fd_sc_hd__decap_3
XTAP_TAPCELL_ROW_67_620 VGND VPWR sky130_fd_sc_hd__tapvpwrvgnd_1
XFILLER_0_43_3 VPWR VGND VPWR VGND sky130_ef_sc_hd__decap_12
Xaccumulator._1417_ accumulator._0306_ accumulator._0514_ accumulator._0428_ accumulator._0034_
+ VGND VGND VPWR VPWR accumulator._0515_ sky130_fd_sc_hd__a2bb2o_1
Xaccumulator._1348_ accumulator._0376_ accumulator._0392_ VGND VGND VPWR VPWR accumulator._0446_
+ sky130_fd_sc_hd__xnor2_4
Xaccumulator._1279_ accumulator._0326_ net89 VGND VGND VPWR VPWR accumulator._0377_
+ sky130_fd_sc_hd__xor2_4
XFILLER_0_19_110 VGND VGND VPWR VPWR sky130_fd_sc_hd__fill_2
XFILLER_0_15_393 VPWR VGND VPWR VGND sky130_ef_sc_hd__decap_12
XTAP_TAPCELL_ROW_22_299 VGND VPWR sky130_fd_sc_hd__tapvpwrvgnd_1
XFILLER_0_30_385 VGND VGND VPWR VPWR sky130_fd_sc_hd__fill_2
XFILLER_0_57_249 VPWR VGND VPWR VGND sky130_ef_sc_hd__decap_12
XFILLER_0_31_69 VGND VGND VPWR VPWR sky130_fd_sc_hd__decap_3
XFILLER_0_25_113 VGND VGND VPWR VPWR sky130_fd_sc_hd__decap_6
XscaleAdd._405_ scaleAdd._079_ scaleAdd._081_ VGND VGND VPWR VPWR scaleAdd._084_ sky130_fd_sc_hd__nor2_1
Xaccumulator._2251_ accumulator._0212_ VGND VGND VPWR VPWR accumulator._0233_ sky130_fd_sc_hd__inv_2
Xaccumulator._2320_ clknet_2_0__leaf_clock accumulator._0027_ VGND VGND VPWR VPWR
+ accumulator.io_accOut\[25\] sky130_fd_sc_hd__dfxtp_2
XscaleAdd._336_ operator.io_outMant\[1\] scaleAdd._009_ scaleAdd._016_ scaleAdd._017_
+ VGND VGND VPWR VPWR scaleAdd._018_ sky130_fd_sc_hd__a22o_1
XscaleAdd._267_ scaleAdd._220_ VGND VGND VPWR VPWR accumulator.io_inMant\[1\] sky130_fd_sc_hd__dlymetal6s2s_1
XFILLER_0_48_249 VGND VGND VPWR VPWR sky130_fd_sc_hd__decap_3
XFILLER_0_48_216 VGND VGND VPWR VPWR sky130_fd_sc_hd__decap_3
XFILLER_0_48_205 VGND VGND VPWR VPWR sky130_fd_sc_hd__decap_3
Xaccumulator._2182_ accumulator._0163_ accumulator._0165_ accumulator._0035_ VGND
+ VGND VPWR VPWR accumulator._0166_ sky130_fd_sc_hd__mux2_1
Xaccumulator._1202_ accumulator._0301_ accumulator._0279_ VGND VGND VPWR VPWR accumulator._0302_
+ sky130_fd_sc_hd__nand2_1
Xaccumulator._1966_ accumulator._0902_ accumulator._1062_ accumulator._1063_ VGND
+ VGND VPWR VPWR accumulator._1064_ sky130_fd_sc_hd__o21ba_1
XFILLER_0_8_357 VGND VGND VPWR VPWR sky130_fd_sc_hd__decap_6
Xoperator._084_ net7 net3 VGND VGND VPWR VPWR operator._022_ sky130_fd_sc_hd__nand2_1
Xaccumulator._1897_ accumulator._0782_ accumulator._0994_ accumulator._0816_ VGND
+ VGND VPWR VPWR accumulator._0995_ sky130_fd_sc_hd__mux2_1
XFILLER_0_12_363 VGND VGND VPWR VPWR sky130_fd_sc_hd__fill_1
XTAP_TAPCELL_ROW_27_336 VGND VPWR sky130_fd_sc_hd__tapvpwrvgnd_1
XTAP_TAPCELL_ROW_35_391 VGND VPWR sky130_fd_sc_hd__tapvpwrvgnd_1
XFILLER_0_30_160 VPWR VGND VPWR VGND sky130_ef_sc_hd__decap_12
XFILLER_0_22_138 VGND VGND VPWR VPWR sky130_fd_sc_hd__fill_2
Xaccumulator._1820_ accumulator._0758_ accumulator._0917_ VGND VGND VPWR VPWR accumulator._0918_
+ sky130_fd_sc_hd__xnor2_2
XFILLER_0_42_79 VGND VGND VPWR VPWR sky130_fd_sc_hd__decap_4
XFILLER_0_38_293 VPWR VGND VPWR VGND sky130_ef_sc_hd__decap_12
XANTENNA_1 reset VGND VGND VPWR VPWR sky130_fd_sc_hd__diode_2
XFILLER_0_5_349 VPWR VGND VPWR VGND sky130_ef_sc_hd__decap_12
XFILLER_0_5_305 VPWR VGND VPWR VGND sky130_ef_sc_hd__decap_12
Xaccumulator._1682_ accumulator._0768_ accumulator._0769_ VGND VGND VPWR VPWR accumulator._0780_
+ sky130_fd_sc_hd__or2b_1
Xaccumulator._1751_ accumulator._0846_ accumulator._0848_ accumulator._0389_ VGND
+ VGND VPWR VPWR accumulator._0849_ sky130_fd_sc_hd__a21oi_1
XFILLER_0_6_24 VGND VGND VPWR VPWR sky130_fd_sc_hd__decap_4
XFILLER_0_6_46 VPWR VGND VPWR VGND sky130_ef_sc_hd__decap_12
XFILLER_0_6_68 VGND VGND VPWR VPWR sky130_fd_sc_hd__decap_4
XTAP_TAPCELL_ROW_49_494 VGND VPWR sky130_fd_sc_hd__tapvpwrvgnd_1
Xaccumulator._2303_ clknet_2_2__leaf_clock accumulator._0010_ VGND VGND VPWR VPWR
+ accumulator.io_accOut\[8\] sky130_fd_sc_hd__dfxtp_2
Xrebuffer13 net75 VGND VGND VPWR VPWR net76 sky130_fd_sc_hd__dlygate4sd1_1
Xaccumulator._2234_ net116 accumulator._0120_ accumulator._0352_ accumulator._0215_
+ VGND VGND VPWR VPWR accumulator._0026_ sky130_fd_sc_hd__o211a_1
Xrebuffer24 accumulator._0335_ VGND VGND VPWR VPWR net87 sky130_fd_sc_hd__dlygate4sd1_1
XscaleAdd._319_ operator.io_outMant\[1\] scaleAdd._248_ VGND VGND VPWR VPWR scaleAdd._002_
+ sky130_fd_sc_hd__nand2_1
Xrebuffer35 scaleAdd._058_ VGND VGND VPWR VPWR net98 sky130_fd_sc_hd__dlygate4sd1_1
Xaccumulator._2165_ accumulator._0148_ accumulator._0134_ accumulator._1127_ VGND
+ VGND VPWR VPWR accumulator._0149_ sky130_fd_sc_hd__mux2_1
XTAP_TAPCELL_ROW_32_372 VGND VPWR sky130_fd_sc_hd__tapvpwrvgnd_1
Xaccumulator._2096_ accumulator.io_accOut\[6\] accumulator._0364_ accumulator._0058_
+ accumulator._0081_ VGND VGND VPWR VPWR accumulator._0082_ sky130_fd_sc_hd__o2bb2a_1
XFILLER_0_29_293 VGND VGND VPWR VPWR sky130_fd_sc_hd__decap_6
XTAP_TAPCELL_ROW_24_317 VGND VPWR sky130_fd_sc_hd__tapvpwrvgnd_1
XFILLER_0_8_154 VGND VGND VPWR VPWR sky130_fd_sc_hd__fill_1
Xaccumulator._1949_ accumulator._1014_ accumulator._0965_ VGND VGND VPWR VPWR accumulator._1047_
+ sky130_fd_sc_hd__nor2_1
XFILLER_0_44_274 VPWR VGND VPWR VGND sky130_ef_sc_hd__decap_12
Xoperator._067_ net10 net9 net11 VGND VGND VPWR VPWR operator._010_ sky130_fd_sc_hd__a21oi_1
XFILLER_0_67_333 VGND VGND VPWR VPWR sky130_fd_sc_hd__decap_3
XFILLER_0_27_208 VPWR VGND VPWR VGND sky130_ef_sc_hd__decap_12
XFILLER_0_50_222 VPWR VGND VPWR VGND sky130_ef_sc_hd__decap_12
XFILLER_0_35_263 VPWR VGND VPWR VGND sky130_ef_sc_hd__decap_12
XFILLER_0_12_27 VGND VGND VPWR VPWR sky130_fd_sc_hd__fill_1
Xoutput60 net60 VGND VGND VPWR VPWR io_accOut[9] sky130_fd_sc_hd__buf_2
XFILLER_0_37_57 VPWR VGND VPWR VGND sky130_ef_sc_hd__decap_12
XFILLER_0_58_377 VPWR VGND VPWR VGND sky130_ef_sc_hd__decap_12
XFILLER_0_58_344 VPWR VGND VPWR VGND sky130_ef_sc_hd__decap_12
XFILLER_0_53_89 VPWR VGND VPWR VGND sky130_ef_sc_hd__decap_12
Xaccumulator._1803_ accumulator._0891_ accumulator._0900_ VGND VGND VPWR VPWR accumulator._0901_
+ sky130_fd_sc_hd__or2_4
XFILLER_0_41_211 VPWR VGND VPWR VGND sky130_ef_sc_hd__decap_12
XFILLER_0_26_296 VGND VGND VPWR VPWR sky130_fd_sc_hd__decap_8
Xaccumulator._1665_ accumulator._0743_ accumulator._0741_ VGND VGND VPWR VPWR accumulator._0763_
+ sky130_fd_sc_hd__nand2_1
Xaccumulator._1734_ accumulator._0670_ accumulator._0671_ VGND VGND VPWR VPWR accumulator._0832_
+ sky130_fd_sc_hd__nor2_1
Xaccumulator._1596_ accumulator._0689_ accumulator._0692_ accumulator._0693_ accumulator._0394_
+ VGND VGND VPWR VPWR accumulator._0694_ sky130_fd_sc_hd__a31oi_1
XFILLER_0_1_385 VGND VGND VPWR VPWR sky130_fd_sc_hd__decap_6
Xaccumulator._2217_ accumulator._0047_ accumulator._0187_ VGND VGND VPWR VPWR accumulator._0199_
+ sky130_fd_sc_hd__nand2_1
XFILLER_0_27_90 VGND VGND VPWR VPWR sky130_fd_sc_hd__fill_1
XFILLER_0_49_377 VGND VGND VPWR VPWR sky130_fd_sc_hd__fill_1
Xaccumulator._2079_ accumulator._1121_ accumulator._1138_ VGND VGND VPWR VPWR accumulator._0066_
+ sky130_fd_sc_hd__and2b_1
Xaccumulator._2148_ accumulator._0073_ VGND VGND VPWR VPWR accumulator._0133_ sky130_fd_sc_hd__inv_2
Xoperator._119_ operator._052_ operator._030_ operator._040_ VGND VGND VPWR VPWR operator._053_
+ sky130_fd_sc_hd__and3_1
XFILLER_0_55_347 VGND VGND VPWR VPWR sky130_fd_sc_hd__fill_2
XFILLER_0_23_15 VPWR VGND VPWR VGND sky130_ef_sc_hd__decap_12
XFILLER_0_23_288 VGND VGND VPWR VPWR sky130_fd_sc_hd__fill_1
Xrebuffer4 accumulator._0321_ VGND VGND VPWR VPWR net67 sky130_fd_sc_hd__dlygate4sd1_1
Xaccumulator._1450_ accumulator._0454_ accumulator._0526_ accumulator._0490_ VGND
+ VGND VPWR VPWR accumulator._0548_ sky130_fd_sc_hd__a21o_1
Xaccumulator._1381_ accumulator._0477_ accumulator._0478_ accumulator._0429_ VGND
+ VGND VPWR VPWR accumulator._0479_ sky130_fd_sc_hd__mux2_1
XFILLER_0_3_69 VGND VGND VPWR VPWR sky130_fd_sc_hd__fill_1
Xaccumulator._2002_ accumulator._0839_ accumulator._1099_ VGND VGND VPWR VPWR accumulator._1100_
+ sky130_fd_sc_hd__xnor2_1
XFILLER_0_13_81 VGND VGND VPWR VPWR sky130_fd_sc_hd__decap_4
Xaccumulator._1648_ accumulator._0738_ accumulator._0745_ VGND VGND VPWR VPWR accumulator._0746_
+ sky130_fd_sc_hd__nand2_1
XTAP_TAPCELL_ROW_57_548 VGND VPWR sky130_fd_sc_hd__tapvpwrvgnd_1
Xaccumulator._1717_ accumulator._0814_ VGND VGND VPWR VPWR accumulator._0815_ sky130_fd_sc_hd__buf_2
Xaccumulator._1579_ accumulator._0512_ accumulator._0589_ accumulator._0590_ VGND
+ VGND VPWR VPWR accumulator._0677_ sky130_fd_sc_hd__nand3_1
XFILLER_0_49_130 VGND VGND VPWR VPWR sky130_fd_sc_hd__fill_2
XTAP_TAPCELL_ROW_40_426 VGND VPWR sky130_fd_sc_hd__tapvpwrvgnd_1
XFILLER_0_64_177 VPWR VGND VPWR VGND sky130_ef_sc_hd__decap_12
XFILLER_0_37_369 VPWR VGND VPWR VGND sky130_ef_sc_hd__decap_12
XFILLER_0_9_293 VPWR VGND VPWR VGND sky130_ef_sc_hd__decap_12
XFILLER_0_18_15 VGND VGND VPWR VPWR sky130_fd_sc_hd__decap_6
XFILLER_0_18_48 VGND VGND VPWR VPWR sky130_fd_sc_hd__decap_8
XTAP_TAPCELL_ROW_5_181 VGND VPWR sky130_fd_sc_hd__tapvpwrvgnd_1
XFILLER_0_59_55 VGND VGND VPWR VPWR sky130_fd_sc_hd__fill_1
XFILLER_0_11_214 VGND VGND VPWR VPWR sky130_fd_sc_hd__decap_8
XFILLER_0_11_225 VGND VGND VPWR VPWR sky130_fd_sc_hd__fill_1
XFILLER_0_11_247 VGND VGND VPWR VPWR sky130_fd_sc_hd__decap_3
Xaccumulator._1502_ accumulator._0438_ accumulator._0572_ accumulator._0573_ VGND
+ VGND VPWR VPWR accumulator._0600_ sky130_fd_sc_hd__or3_1
Xaccumulator._1433_ accumulator._0527_ accumulator._0530_ accumulator._0439_ VGND
+ VGND VPWR VPWR accumulator._0531_ sky130_fd_sc_hd__a21o_1
XscaleAdd._498_ scaleAdd._168_ scaleAdd._169_ VGND VGND VPWR VPWR scaleAdd._170_ sky130_fd_sc_hd__and2_1
XTAP_TAPCELL_ROW_62_584 VGND VPWR sky130_fd_sc_hd__tapvpwrvgnd_1
XTAP_TAPCELL_ROW_54_529 VGND VPWR sky130_fd_sc_hd__tapvpwrvgnd_1
XFILLER_0_46_122 VGND VGND VPWR VPWR sky130_fd_sc_hd__decap_8
Xaccumulator._1295_ accumulator._0376_ accumulator._0392_ VGND VGND VPWR VPWR accumulator._0393_
+ sky130_fd_sc_hd__xor2_2
Xaccumulator._1364_ accumulator.io_inMant\[6\] accumulator.io_inMant\[5\] accumulator._0415_
+ VGND VGND VPWR VPWR accumulator._0462_ sky130_fd_sc_hd__mux2_1
XFILLER_0_19_325 VGND VGND VPWR VPWR sky130_fd_sc_hd__decap_3
XTAP_TAPCELL_ROW_19_283 VGND VPWR sky130_fd_sc_hd__tapvpwrvgnd_1
XFILLER_0_34_339 VGND VGND VPWR VPWR sky130_fd_sc_hd__fill_1
XFILLER_0_34_306 VGND VGND VPWR VPWR sky130_fd_sc_hd__fill_2
XFILLER_0_27_391 VGND VGND VPWR VPWR sky130_fd_sc_hd__fill_1
XFILLER_0_6_296 VPWR VGND VPWR VGND sky130_ef_sc_hd__decap_12
XTAP_TAPCELL_ROW_2_162 VGND VPWR sky130_fd_sc_hd__tapvpwrvgnd_1
XFILLER_0_52_125 VGND VGND VPWR VPWR sky130_fd_sc_hd__fill_1
XFILLER_0_37_111 VGND VGND VPWR VPWR sky130_fd_sc_hd__fill_1
XFILLER_0_25_306 VGND VGND VPWR VPWR sky130_fd_sc_hd__decap_3
XFILLER_0_60_180 VGND VGND VPWR VPWR sky130_fd_sc_hd__decap_8
XFILLER_0_40_309 VGND VGND VPWR VPWR sky130_fd_sc_hd__fill_2
XscaleAdd._421_ scaleAdd._067_ scaleAdd._099_ VGND VGND VPWR VPWR scaleAdd._100_ sky130_fd_sc_hd__xor2_4
XscaleAdd._352_ operator.io_outMant\[0\] scaleAdd._008_ scaleAdd._009_ scaleAdd._033_
+ VGND VGND VPWR VPWR scaleAdd._034_ sky130_fd_sc_hd__a31o_1
XscaleAdd._283_ net16 net17 VGND VGND VPWR VPWR scaleAdd._234_ sky130_fd_sc_hd__or2_1
XFILLER_0_61_67 VGND VGND VPWR VPWR sky130_fd_sc_hd__decap_6
XFILLER_0_45_68 VGND VGND VPWR VPWR sky130_fd_sc_hd__decap_4
XFILLER_0_45_57 VGND VGND VPWR VPWR sky130_fd_sc_hd__decap_4
XFILLER_0_0_15 VPWR VGND VPWR VGND sky130_ef_sc_hd__decap_12
Xaccumulator._1982_ accumulator._0933_ accumulator._0965_ VGND VGND VPWR VPWR accumulator._1080_
+ sky130_fd_sc_hd__or2b_1
XFILLER_0_43_169 VPWR VGND VPWR VGND sky130_ef_sc_hd__decap_12
XFILLER_0_9_57 VGND VGND VPWR VPWR sky130_fd_sc_hd__decap_3
XFILLER_0_3_266 VPWR VGND VPWR VGND sky130_ef_sc_hd__decap_12
XFILLER_0_10_71 VGND VGND VPWR VPWR sky130_fd_sc_hd__decap_6
Xaccumulator._1347_ accumulator._0444_ VGND VGND VPWR VPWR accumulator._0445_ sky130_fd_sc_hd__inv_2
XFILLER_0_36_3 VPWR VGND VPWR VGND sky130_ef_sc_hd__decap_12
Xaccumulator._1416_ accumulator._0429_ accumulator._0419_ VGND VGND VPWR VPWR accumulator._0514_
+ sky130_fd_sc_hd__or2_1
Xaccumulator._1278_ accumulator._0332_ accumulator._0375_ VGND VGND VPWR VPWR accumulator._0376_
+ sky130_fd_sc_hd__xor2_4
XFILLER_0_19_166 VGND VGND VPWR VPWR sky130_fd_sc_hd__fill_2
XFILLER_0_19_177 VGND VGND VPWR VPWR sky130_fd_sc_hd__fill_1
XPHY_EDGE_ROW_8_Left_77 VGND VGND VPWR VPWR sky130_fd_sc_hd__decap_3
XFILLER_0_57_206 VGND VGND VPWR VPWR sky130_fd_sc_hd__decap_8
XFILLER_0_65_250 VGND VGND VPWR VPWR sky130_fd_sc_hd__fill_2
XFILLER_0_40_117 VGND VGND VPWR VPWR sky130_fd_sc_hd__fill_1
XFILLER_0_25_169 VGND VGND VPWR VPWR sky130_fd_sc_hd__decap_8
XFILLER_0_40_128 VPWR VGND VPWR VGND sky130_ef_sc_hd__decap_12
XFILLER_0_0_225 VPWR VGND VPWR VGND sky130_ef_sc_hd__decap_12
XscaleAdd._335_ operator.io_outMant\[3\] scaleAdd._239_ scaleAdd._248_ operator.io_outMant\[2\]
+ VGND VGND VPWR VPWR scaleAdd._017_ sky130_fd_sc_hd__a22o_1
XscaleAdd._404_ scaleAdd._060_ scaleAdd._083_ VGND VGND VPWR VPWR accumulator.io_inMant\[9\]
+ sky130_fd_sc_hd__xor2_2
XFILLER_0_21_375 VGND VGND VPWR VPWR sky130_fd_sc_hd__fill_2
Xaccumulator._1201_ accumulator._0093_ net79 accumulator._0274_ VGND VGND VPWR VPWR
+ accumulator._0301_ sky130_fd_sc_hd__a21o_1
XscaleAdd._266_ operator.io_outMant\[1\] net13 VGND VGND VPWR VPWR scaleAdd._220_
+ sky130_fd_sc_hd__and2_1
Xaccumulator._2250_ accumulator._0230_ accumulator._0231_ VGND VGND VPWR VPWR accumulator._0232_
+ sky130_fd_sc_hd__nor2_1
Xaccumulator._2181_ accumulator._0164_ accumulator._0147_ accumulator._0047_ VGND
+ VGND VPWR VPWR accumulator._0165_ sky130_fd_sc_hd__mux2_4
Xaccumulator._1965_ accumulator._0891_ accumulator._0900_ accumulator._1062_ accumulator._1060_
+ accumulator._0851_ VGND VGND VPWR VPWR accumulator._1063_ sky130_fd_sc_hd__o221a_1
Xoperator._083_ operator._018_ operator._019_ operator._021_ VGND VGND VPWR VPWR operator.io_outMant\[1\]
+ sky130_fd_sc_hd__a21oi_4
Xaccumulator._1896_ accumulator._0778_ accumulator._0875_ accumulator._0879_ VGND
+ VGND VPWR VPWR accumulator._0994_ sky130_fd_sc_hd__o21ba_1
XTAP_TAPCELL_ROW_27_337 VGND VPWR sky130_fd_sc_hd__tapvpwrvgnd_1
XFILLER_0_62_253 VGND VGND VPWR VPWR sky130_fd_sc_hd__decap_3
XFILLER_0_50_404 VGND VGND VPWR VPWR sky130_fd_sc_hd__fill_1
XTAP_TAPCELL_ROW_35_392 VGND VPWR sky130_fd_sc_hd__tapvpwrvgnd_1
XFILLER_0_7_391 VGND VGND VPWR VPWR sky130_fd_sc_hd__fill_1
XTAP_TAPCELL_ROW_10_215 VGND VPWR sky130_fd_sc_hd__tapvpwrvgnd_1
XFILLER_0_30_172 VGND VGND VPWR VPWR sky130_fd_sc_hd__decap_8
XFILLER_0_22_128 VGND VGND VPWR VPWR sky130_fd_sc_hd__fill_1
XFILLER_0_26_48 VGND VGND VPWR VPWR sky130_fd_sc_hd__fill_2
XFILLER_0_26_26 VGND VGND VPWR VPWR sky130_fd_sc_hd__fill_2
XFILLER_0_38_250 VGND VGND VPWR VPWR sky130_fd_sc_hd__fill_2
XFILLER_0_53_220 VGND VGND VPWR VPWR sky130_fd_sc_hd__decap_4
XANTENNA_2 net36 VGND VGND VPWR VPWR sky130_fd_sc_hd__diode_2
Xaccumulator._1750_ accumulator._0493_ accumulator._0502_ accumulator._0841_ accumulator._0847_
+ VGND VGND VPWR VPWR accumulator._0848_ sky130_fd_sc_hd__a31oi_1
XFILLER_0_41_404 VGND VGND VPWR VPWR sky130_fd_sc_hd__fill_1
XFILLER_0_5_317 VPWR VGND VPWR VGND sky130_ef_sc_hd__decap_12
XFILLER_0_67_55 VGND VGND VPWR VPWR sky130_fd_sc_hd__fill_1
Xaccumulator._1681_ accumulator._0772_ accumulator._0778_ VGND VGND VPWR VPWR accumulator._0779_
+ sky130_fd_sc_hd__or2b_1
XFILLER_0_6_58 VGND VGND VPWR VPWR sky130_fd_sc_hd__decap_4
XscaleAdd._318_ scaleAdd._264_ net103 VGND VGND VPWR VPWR scaleAdd._001_ sky130_fd_sc_hd__xnor2_2
XFILLER_0_21_161 VGND VGND VPWR VPWR sky130_fd_sc_hd__decap_6
Xaccumulator._2164_ accumulator._0147_ VGND VGND VPWR VPWR accumulator._0148_ sky130_fd_sc_hd__inv_2
Xaccumulator._2302_ clknet_2_3__leaf_clock accumulator._0009_ VGND VGND VPWR VPWR
+ accumulator.io_accOut\[7\] sky130_fd_sc_hd__dfxtp_2
Xrebuffer25 net95 VGND VGND VPWR VPWR net88 sky130_fd_sc_hd__dlygate4sd1_1
Xaccumulator._2233_ accumulator._0213_ accumulator._0214_ accumulator._0358_ VGND
+ VGND VPWR VPWR accumulator._0215_ sky130_fd_sc_hd__o21ai_1
Xrebuffer36 net101 VGND VGND VPWR VPWR net99 sky130_fd_sc_hd__dlygate4sd1_1
Xrebuffer14 accumulator._0276_ VGND VGND VPWR VPWR net77 sky130_fd_sc_hd__dlygate4sd1_1
XFILLER_0_16_81 VGND VGND VPWR VPWR sky130_fd_sc_hd__decap_3
XFILLER_0_20_6 VPWR VGND VPWR VGND sky130_ef_sc_hd__decap_12
XFILLER_0_44_253 VPWR VGND VPWR VGND sky130_ef_sc_hd__decap_12
XFILLER_0_44_242 VGND VGND VPWR VPWR sky130_fd_sc_hd__fill_1
Xaccumulator._2095_ accumulator._0077_ accumulator._0080_ accumulator._0061_ VGND
+ VGND VPWR VPWR accumulator._0081_ sky130_fd_sc_hd__mux2_4
XTAP_TAPCELL_ROW_32_373 VGND VPWR sky130_fd_sc_hd__tapvpwrvgnd_1
XFILLER_0_32_80 VGND VGND VPWR VPWR sky130_fd_sc_hd__decap_4
XTAP_TAPCELL_ROW_24_318 VGND VPWR sky130_fd_sc_hd__tapvpwrvgnd_1
Xaccumulator._1948_ accumulator._0961_ accumulator._1045_ VGND VGND VPWR VPWR accumulator._1046_
+ sky130_fd_sc_hd__xnor2_2
Xaccumulator._1879_ accumulator._0724_ accumulator._0976_ VGND VGND VPWR VPWR accumulator._0977_
+ sky130_fd_sc_hd__xor2_4
XFILLER_0_44_286 VGND VGND VPWR VPWR sky130_fd_sc_hd__decap_8
Xoperator._066_ net11 net10 net9 VGND VGND VPWR VPWR operator._009_ sky130_fd_sc_hd__and3_1
XFILLER_0_12_17 VGND VGND VPWR VPWR sky130_fd_sc_hd__decap_3
XFILLER_0_50_234 VGND VGND VPWR VPWR sky130_fd_sc_hd__fill_1
XFILLER_0_35_275 VGND VGND VPWR VPWR sky130_fd_sc_hd__decap_4
XFILLER_0_2_309 VPWR VGND VPWR VGND sky130_ef_sc_hd__decap_12
XFILLER_0_37_47 VGND VGND VPWR VPWR sky130_fd_sc_hd__decap_8
Xoutput61 net61 VGND VGND VPWR VPWR io_done sky130_fd_sc_hd__buf_2
Xoutput50 net50 VGND VGND VPWR VPWR io_accOut[29] sky130_fd_sc_hd__buf_2
XFILLER_0_58_301 VGND VGND VPWR VPWR sky130_fd_sc_hd__decap_6
XFILLER_0_53_57 VPWR VGND VPWR VGND sky130_ef_sc_hd__decap_12
XFILLER_0_37_69 VGND VGND VPWR VPWR sky130_fd_sc_hd__decap_8
XFILLER_0_58_389 VPWR VGND VPWR VGND sky130_ef_sc_hd__decap_12
XFILLER_0_58_356 VGND VGND VPWR VPWR sky130_fd_sc_hd__decap_8
XFILLER_0_26_220 VGND VGND VPWR VPWR sky130_fd_sc_hd__decap_4
Xaccumulator._1733_ accumulator._0684_ accumulator._0683_ accumulator._0675_ VGND
+ VGND VPWR VPWR accumulator._0831_ sky130_fd_sc_hd__and3b_1
Xaccumulator._1802_ accumulator._0816_ accumulator._0767_ accumulator._0894_ accumulator._0899_
+ VGND VGND VPWR VPWR accumulator._0900_ sky130_fd_sc_hd__o31ai_4
XFILLER_0_41_289 VGND VGND VPWR VPWR sky130_fd_sc_hd__fill_2
XFILLER_0_41_278 VGND VGND VPWR VPWR sky130_fd_sc_hd__fill_2
XFILLER_0_41_223 VGND VGND VPWR VPWR sky130_fd_sc_hd__fill_1
XFILLER_0_5_169 VGND VGND VPWR VPWR sky130_fd_sc_hd__decap_4
Xaccumulator._1664_ accumulator._0756_ accumulator._0757_ accumulator._0761_ VGND
+ VGND VPWR VPWR accumulator._0762_ sky130_fd_sc_hd__a21oi_1
Xaccumulator._1595_ accumulator._0399_ accumulator._0472_ accumulator._0663_ VGND
+ VGND VPWR VPWR accumulator._0693_ sky130_fd_sc_hd__or3_1
Xclkbuf_2_3__f_clock clknet_0_clock VGND VGND VPWR VPWR clknet_2_3__leaf_clock sky130_fd_sc_hd__clkbuf_16
XFILLER_0_68_109 VGND VGND VPWR VPWR sky130_fd_sc_hd__decap_3
XTAP_TAPCELL_ROW_37_410 VGND VPWR sky130_fd_sc_hd__tapvpwrvgnd_1
Xaccumulator._2147_ accumulator._0070_ accumulator._0130_ accumulator._0358_ VGND
+ VGND VPWR VPWR accumulator._0131_ sky130_fd_sc_hd__o21ai_1
Xaccumulator._2216_ accumulator.io_accOut\[22\] VGND VGND VPWR VPWR accumulator._0198_
+ sky130_fd_sc_hd__inv_2
Xaccumulator._2078_ accumulator._1128_ accumulator._0063_ accumulator._1137_ VGND
+ VGND VPWR VPWR accumulator._0065_ sky130_fd_sc_hd__mux2_4
Xoperator._118_ operator._049_ operator._046_ operator._032_ VGND VGND VPWR VPWR operator._052_
+ sky130_fd_sc_hd__or3b_4
XFILLER_0_7_90 VPWR VGND VPWR VGND sky130_ef_sc_hd__decap_12
XFILLER_0_67_142 VGND VGND VPWR VPWR sky130_fd_sc_hd__fill_1
XFILLER_0_55_337 VGND VGND VPWR VPWR sky130_fd_sc_hd__decap_6
XTAP_TAPCELL_ROW_43_446 VGND VPWR sky130_fd_sc_hd__tapvpwrvgnd_1
XFILLER_0_23_27 VGND VGND VPWR VPWR sky130_fd_sc_hd__fill_1
XFILLER_0_23_256 VGND VGND VPWR VPWR sky130_fd_sc_hd__fill_2
XFILLER_0_2_117 VPWR VGND VPWR VGND sky130_ef_sc_hd__decap_12
Xrebuffer5 accumulator._0288_ VGND VGND VPWR VPWR net68 sky130_fd_sc_hd__clkbuf_2
XFILLER_0_3_15 VGND VGND VPWR VPWR sky130_fd_sc_hd__decap_4
Xaccumulator._1380_ accumulator._0421_ accumulator._0425_ accumulator._0427_ VGND
+ VGND VPWR VPWR accumulator._0478_ sky130_fd_sc_hd__mux2_1
Xaccumulator._2001_ accumulator._0367_ accumulator._1033_ VGND VGND VPWR VPWR accumulator._1099_
+ sky130_fd_sc_hd__nor2_1
XFILLER_0_58_197 VGND VGND VPWR VPWR sky130_fd_sc_hd__decap_3
XFILLER_0_6_401 VGND VGND VPWR VPWR sky130_fd_sc_hd__decap_8
XFILLER_0_66_3 VPWR VGND VPWR VGND sky130_ef_sc_hd__decap_12
Xaccumulator._1716_ accumulator.io_accOut\[31\] accumulator.io_inSign VGND VGND VPWR
+ VPWR accumulator._0814_ sky130_fd_sc_hd__xor2_2
Xaccumulator._1647_ accumulator._0742_ accumulator._0744_ VGND VGND VPWR VPWR accumulator._0745_
+ sky130_fd_sc_hd__nor2_2
XTAP_TAPCELL_ROW_57_549 VGND VPWR sky130_fd_sc_hd__tapvpwrvgnd_1
Xaccumulator._1578_ accumulator._0493_ accumulator._0599_ accumulator._0600_ VGND
+ VGND VPWR VPWR accumulator._0676_ sky130_fd_sc_hd__nand3_1
XTAP_TAPCELL_ROW_40_427 VGND VPWR sky130_fd_sc_hd__tapvpwrvgnd_1
XFILLER_0_37_337 VGND VGND VPWR VPWR sky130_fd_sc_hd__decap_4
XFILLER_0_9_272 VGND VGND VPWR VPWR sky130_fd_sc_hd__decap_8
XFILLER_0_64_189 VGND VGND VPWR VPWR sky130_fd_sc_hd__decap_6
XFILLER_0_45_370 VPWR VGND VPWR VGND sky130_ef_sc_hd__decap_12
XTAP_TAPCELL_ROW_5_182 VGND VPWR sky130_fd_sc_hd__tapvpwrvgnd_1
XFILLER_0_34_15 VPWR VGND VPWR VGND sky130_ef_sc_hd__decap_12
XPHY_EDGE_ROW_16_Right_16 VGND VGND VPWR VPWR sky130_fd_sc_hd__decap_3
XFILLER_0_55_189 VGND VGND VPWR VPWR sky130_fd_sc_hd__fill_2
XFILLER_0_55_167 VGND VGND VPWR VPWR sky130_fd_sc_hd__fill_1
XFILLER_0_55_134 VGND VGND VPWR VPWR sky130_fd_sc_hd__decap_6
XPHY_EDGE_ROW_25_Right_25 VGND VGND VPWR VPWR sky130_fd_sc_hd__decap_3
XFILLER_0_51_362 VGND VGND VPWR VPWR sky130_fd_sc_hd__fill_1
XFILLER_0_11_259 VGND VGND VPWR VPWR sky130_fd_sc_hd__fill_1
XscaleAdd._497_ scaleAdd._156_ scaleAdd._167_ VGND VGND VPWR VPWR scaleAdd._169_ sky130_fd_sc_hd__nand2_1
Xaccumulator._1501_ accumulator._0506_ accumulator._0509_ accumulator._0472_ VGND
+ VGND VPWR VPWR accumulator._0599_ sky130_fd_sc_hd__a21o_1
Xaccumulator._1432_ accumulator._0475_ accumulator._0529_ accumulator._0490_ VGND
+ VGND VPWR VPWR accumulator._0530_ sky130_fd_sc_hd__a21o_1
XPHY_EDGE_ROW_34_Right_34 VGND VGND VPWR VPWR sky130_fd_sc_hd__decap_3
Xaccumulator._1363_ accumulator._0457_ accumulator._0460_ accumulator._0273_ VGND
+ VGND VPWR VPWR accumulator._0461_ sky130_fd_sc_hd__mux2_1
XTAP_TAPCELL_ROW_62_585 VGND VPWR sky130_fd_sc_hd__tapvpwrvgnd_1
Xaccumulator._1294_ accumulator._0377_ accumulator._0382_ accumulator._0354_ VGND
+ VGND VPWR VPWR accumulator._0392_ sky130_fd_sc_hd__o21a_2
XFILLER_0_24_92 VGND VGND VPWR VPWR sky130_fd_sc_hd__decap_4
XTAP_TAPCELL_ROW_19_284 VGND VPWR sky130_fd_sc_hd__tapvpwrvgnd_1
XPHY_EDGE_ROW_43_Right_43 VGND VGND VPWR VPWR sky130_fd_sc_hd__decap_3
XFILLER_0_42_373 VGND VGND VPWR VPWR sky130_fd_sc_hd__fill_2
XFILLER_0_6_253 VGND VGND VPWR VPWR sky130_fd_sc_hd__decap_3
XPHY_EDGE_ROW_52_Right_52 VGND VGND VPWR VPWR sky130_fd_sc_hd__decap_3
XFILLER_0_10_281 VPWR VGND VPWR VGND sky130_ef_sc_hd__decap_12
XTAP_TAPCELL_ROW_2_163 VGND VPWR sky130_fd_sc_hd__tapvpwrvgnd_1
XPHY_EDGE_ROW_61_Right_61 VGND VGND VPWR VPWR sky130_fd_sc_hd__decap_3
XFILLER_0_37_145 VPWR VGND VPWR VGND sky130_ef_sc_hd__decap_12
XscaleAdd._420_ scaleAdd._098_ scaleAdd._097_ VGND VGND VPWR VPWR scaleAdd._099_ sky130_fd_sc_hd__or2_4
XscaleAdd._351_ scaleAdd._261_ scaleAdd._007_ VGND VGND VPWR VPWR scaleAdd._033_ sky130_fd_sc_hd__nor2_1
XscaleAdd._282_ scaleAdd._221_ operator.io_outMant\[4\] scaleAdd._231_ VGND VGND VPWR
+ VPWR scaleAdd._233_ sky130_fd_sc_hd__a21oi_1
XFILLER_0_68_281 VPWR VGND VPWR VGND sky130_ef_sc_hd__decap_12
XFILLER_0_61_57 VGND VGND VPWR VPWR sky130_fd_sc_hd__decap_3
XFILLER_0_0_27 VGND VGND VPWR VPWR sky130_fd_sc_hd__fill_1
XFILLER_0_16_307 VGND VGND VPWR VPWR sky130_fd_sc_hd__fill_1
Xaccumulator._1981_ accumulator._1056_ accumulator._1078_ VGND VGND VPWR VPWR accumulator._1079_
+ sky130_fd_sc_hd__nor2_1
XFILLER_0_43_137 VGND VGND VPWR VPWR sky130_fd_sc_hd__fill_1
XFILLER_0_3_278 VGND VGND VPWR VPWR sky130_fd_sc_hd__fill_2
XscaleAdd._549_ scaleAdd._215_ scaleAdd._216_ VGND VGND VPWR VPWR scaleAdd._217_ sky130_fd_sc_hd__and2_1
XPHY_EDGE_ROW_24_Left_93 VGND VGND VPWR VPWR sky130_fd_sc_hd__decap_3
XFILLER_0_19_81 VGND VGND VPWR VPWR sky130_fd_sc_hd__decap_4
Xaccumulator._1346_ accumulator._0442_ accumulator._0443_ VGND VGND VPWR VPWR accumulator._0444_
+ sky130_fd_sc_hd__or2b_1
Xaccumulator._1415_ accumulator._0054_ accumulator._0064_ VGND VGND VPWR VPWR accumulator._0513_
+ sky130_fd_sc_hd__and2_1
XFILLER_0_59_281 VPWR VGND VPWR VGND sky130_ef_sc_hd__decap_12
XTAP_TAPCELL_ROW_50_500 VGND VPWR sky130_fd_sc_hd__tapvpwrvgnd_1
Xaccumulator._1277_ accumulator._0334_ accumulator._0333_ VGND VGND VPWR VPWR accumulator._0375_
+ sky130_fd_sc_hd__and2b_1
XTAP_TAPCELL_ROW_7_200 VGND VPWR sky130_fd_sc_hd__tapvpwrvgnd_1
XFILLER_0_33_181 VGND VGND VPWR VPWR sky130_fd_sc_hd__decap_4
XFILLER_0_25_126 VGND VGND VPWR VPWR sky130_fd_sc_hd__decap_4
XFILLER_0_0_237 VPWR VGND VPWR VGND sky130_ef_sc_hd__decap_12
XscaleAdd._403_ scaleAdd._061_ scaleAdd._082_ VGND VGND VPWR VPWR scaleAdd._083_ sky130_fd_sc_hd__xnor2_2
XscaleAdd._334_ operator.io_outMant\[3\] scaleAdd._248_ net62 VGND VGND VPWR VPWR
+ scaleAdd._016_ sky130_fd_sc_hd__nand3_1
Xaccumulator._2180_ accumulator._1019_ accumulator._1017_ accumulator._1120_ VGND
+ VGND VPWR VPWR accumulator._0164_ sky130_fd_sc_hd__mux2_2
Xaccumulator._1200_ accumulator.io_accOut\[29\] accumulator._0299_ VGND VGND VPWR
+ VPWR accumulator._0300_ sky130_fd_sc_hd__or2_1
Xoperator._082_ net63 operator._020_ VGND VGND VPWR VPWR operator._021_ sky130_fd_sc_hd__and2_2
XFILLER_0_16_137 VGND VGND VPWR VPWR sky130_fd_sc_hd__decap_3
Xaccumulator._1895_ accumulator._0989_ accumulator._0992_ VGND VGND VPWR VPWR accumulator._0993_
+ sky130_fd_sc_hd__and2_4
Xaccumulator._1964_ accumulator._1059_ accumulator._1061_ VGND VGND VPWR VPWR accumulator._1062_
+ sky130_fd_sc_hd__xnor2_1
XFILLER_0_24_170 VGND VGND VPWR VPWR sky130_fd_sc_hd__decap_3
XFILLER_0_12_321 VPWR VGND VPWR VGND sky130_ef_sc_hd__decap_12
XFILLER_0_12_365 VPWR VGND VPWR VGND sky130_ef_sc_hd__decap_12
XFILLER_0_21_93 VGND VGND VPWR VPWR sky130_fd_sc_hd__fill_2
XPHY_EDGE_ROW_2_Right_2 VGND VGND VPWR VPWR sky130_fd_sc_hd__decap_3
XTAP_TAPCELL_ROW_27_338 VGND VPWR sky130_fd_sc_hd__tapvpwrvgnd_1
Xaccumulator._1329_ net91 VGND VGND VPWR VPWR accumulator._0427_ sky130_fd_sc_hd__buf_2
XFILLER_0_62_221 VGND VGND VPWR VPWR sky130_fd_sc_hd__fill_1
XTAP_TAPCELL_ROW_35_393 VGND VPWR sky130_fd_sc_hd__tapvpwrvgnd_1
XTAP_TAPCELL_ROW_10_216 VGND VPWR sky130_fd_sc_hd__tapvpwrvgnd_1
XFILLER_0_15_181 VPWR VGND VPWR VGND sky130_ef_sc_hd__decap_12
Xhold50 accumulator.io_accOut\[23\] VGND VGND VPWR VPWR net113 sky130_fd_sc_hd__dlygate4sd3_1
XFILLER_0_42_15 VPWR VGND VPWR VGND sky130_ef_sc_hd__decap_12
XFILLER_0_5_329 VGND VGND VPWR VPWR sky130_fd_sc_hd__decap_6
XANTENNA_3 net60 VGND VGND VPWR VPWR sky130_fd_sc_hd__diode_2
XFILLER_0_53_298 VPWR VGND VPWR VGND sky130_ef_sc_hd__decap_12
XFILLER_0_53_243 VGND VGND VPWR VPWR sky130_fd_sc_hd__decap_6
Xaccumulator._1680_ accumulator._0776_ accumulator._0777_ VGND VGND VPWR VPWR accumulator._0778_
+ sky130_fd_sc_hd__and2_1
Xaccumulator._2301_ clknet_2_2__leaf_clock accumulator._0008_ VGND VGND VPWR VPWR
+ accumulator.io_accOut\[6\] sky130_fd_sc_hd__dfxtp_2
XscaleAdd._317_ net13 scaleAdd._236_ scaleAdd._237_ scaleAdd._238_ scaleAdd._265_
+ VGND VGND VPWR VPWR scaleAdd._000_ sky130_fd_sc_hd__a2111oi_1
Xaccumulator._2163_ accumulator._1036_ accumulator._1038_ net92 VGND VGND VPWR VPWR
+ accumulator._0147_ sky130_fd_sc_hd__mux2_1
Xaccumulator._2094_ accumulator._0042_ accumulator._0079_ accumulator._1137_ VGND
+ VGND VPWR VPWR accumulator._0080_ sky130_fd_sc_hd__mux2_4
Xrebuffer26 accumulator._0330_ VGND VGND VPWR VPWR net89 sky130_fd_sc_hd__dlygate4sd1_1
Xaccumulator._2232_ accumulator._0207_ accumulator._0212_ VGND VGND VPWR VPWR accumulator._0214_
+ sky130_fd_sc_hd__and2_1
Xrebuffer37 net82 VGND VGND VPWR VPWR net100 sky130_fd_sc_hd__clkbuf_1
XTAP_TAPCELL_ROW_24_319 VGND VPWR sky130_fd_sc_hd__tapvpwrvgnd_1
Xrebuffer15 net77 VGND VGND VPWR VPWR net78 sky130_fd_sc_hd__dlygate4sd1_1
XFILLER_0_13_6 VGND VGND VPWR VPWR sky130_fd_sc_hd__decap_3
XFILLER_0_44_265 VGND VGND VPWR VPWR sky130_fd_sc_hd__decap_6
XFILLER_0_44_210 VGND VGND VPWR VPWR sky130_fd_sc_hd__fill_1
XTAP_TAPCELL_ROW_32_374 VGND VPWR sky130_fd_sc_hd__tapvpwrvgnd_1
Xoperator._065_ operator._004_ operator._008_ VGND VGND VPWR VPWR operator.io_outExp\[1\]
+ sky130_fd_sc_hd__xor2_1
Xaccumulator._1947_ accumulator._1014_ accumulator._1044_ VGND VGND VPWR VPWR accumulator._1045_
+ sky130_fd_sc_hd__nor2_1
Xaccumulator._1878_ accumulator._0366_ accumulator._0564_ accumulator._0973_ accumulator._0975_
+ VGND VGND VPWR VPWR accumulator._0976_ sky130_fd_sc_hd__a31o_1
XPHY_EDGE_ROW_11_Left_80 VGND VGND VPWR VPWR sky130_fd_sc_hd__decap_3
Xoutput40 net40 VGND VGND VPWR VPWR io_accOut[1] sky130_fd_sc_hd__buf_2
Xoutput51 net51 VGND VGND VPWR VPWR io_accOut[2] sky130_fd_sc_hd__buf_2
XFILLER_0_37_15 VPWR VGND VPWR VGND sky130_ef_sc_hd__decap_12
XFILLER_0_58_335 VGND VGND VPWR VPWR sky130_fd_sc_hd__decap_3
XFILLER_0_53_69 VGND VGND VPWR VPWR sky130_fd_sc_hd__decap_3
Xaccumulator._1663_ accumulator._0756_ accumulator._0757_ accumulator._0760_ VGND
+ VGND VPWR VPWR accumulator._0761_ sky130_fd_sc_hd__o21ba_1
Xaccumulator._1732_ accumulator._0670_ accumulator._0671_ VGND VGND VPWR VPWR accumulator._0830_
+ sky130_fd_sc_hd__nand2_1
Xaccumulator._1801_ accumulator._0409_ accumulator._0895_ accumulator._0898_ accumulator._0816_
+ VGND VGND VPWR VPWR accumulator._0899_ sky130_fd_sc_hd__a31o_1
XFILLER_0_41_246 VPWR VGND VPWR VGND sky130_ef_sc_hd__decap_12
Xaccumulator._1594_ accumulator._0399_ accumulator._0438_ accumulator._0691_ VGND
+ VGND VPWR VPWR accumulator._0692_ sky130_fd_sc_hd__or3_1
XFILLER_0_64_305 VGND VGND VPWR VPWR sky130_fd_sc_hd__decap_3
XFILLER_0_49_357 VGND VGND VPWR VPWR sky130_fd_sc_hd__fill_2
XFILLER_0_49_335 VGND VGND VPWR VPWR sky130_fd_sc_hd__fill_1
XFILLER_0_49_302 VGND VGND VPWR VPWR sky130_fd_sc_hd__fill_2
Xaccumulator._2077_ accumulator._0062_ accumulator._0041_ accumulator._1127_ VGND
+ VGND VPWR VPWR accumulator._0063_ sky130_fd_sc_hd__mux2_2
Xaccumulator._2146_ accumulator._0121_ VGND VGND VPWR VPWR accumulator._0130_ sky130_fd_sc_hd__inv_2
Xaccumulator._2215_ accumulator._0089_ accumulator._0143_ VGND VGND VPWR VPWR accumulator._0197_
+ sky130_fd_sc_hd__or2_1
Xoperator._117_ operator._050_ operator._051_ VGND VGND VPWR VPWR operator.io_outMant\[5\]
+ sky130_fd_sc_hd__xnor2_4
XFILLER_0_17_298 VGND VGND VPWR VPWR sky130_fd_sc_hd__fill_1
XFILLER_0_67_154 VGND VGND VPWR VPWR sky130_fd_sc_hd__fill_1
XTAP_TAPCELL_ROW_43_447 VGND VPWR sky130_fd_sc_hd__tapvpwrvgnd_1
XFILLER_0_63_393 VPWR VGND VPWR VGND sky130_ef_sc_hd__decap_12
XFILLER_0_2_129 VGND VGND VPWR VPWR sky130_fd_sc_hd__decap_6
Xrebuffer6 accumulator._0288_ VGND VGND VPWR VPWR net69 sky130_fd_sc_hd__dlymetal6s4s_1
XFILLER_0_48_69 VGND VGND VPWR VPWR sky130_fd_sc_hd__fill_1
XFILLER_0_3_49 VGND VGND VPWR VPWR sky130_fd_sc_hd__decap_6
Xaccumulator._2000_ accumulator._1082_ VGND VGND VPWR VPWR accumulator._1098_ sky130_fd_sc_hd__inv_2
XFILLER_0_58_176 VPWR VGND VPWR VGND sky130_ef_sc_hd__decap_12
XFILLER_0_58_154 VGND VGND VPWR VPWR sky130_fd_sc_hd__decap_8
XFILLER_0_46_338 VGND VGND VPWR VPWR sky130_fd_sc_hd__decap_3
XFILLER_0_61_308 VGND VGND VPWR VPWR sky130_fd_sc_hd__decap_8
XFILLER_0_54_360 VGND VGND VPWR VPWR sky130_fd_sc_hd__decap_4
Xaccumulator._1646_ accumulator._0743_ accumulator._0741_ VGND VGND VPWR VPWR accumulator._0744_
+ sky130_fd_sc_hd__nor2_1
XFILLER_0_59_3 VPWR VGND VPWR VGND sky130_ef_sc_hd__decap_12
Xaccumulator._1715_ accumulator._0410_ accumulator._0812_ VGND VGND VPWR VPWR accumulator._0813_
+ sky130_fd_sc_hd__xnor2_1
Xaccumulator._1577_ accumulator._0450_ accumulator._0673_ accumulator._0674_ accumulator._0581_
+ accumulator._0395_ VGND VGND VPWR VPWR accumulator._0675_ sky130_fd_sc_hd__a2111o_1
Xaccumulator._2129_ accumulator._1097_ accumulator._0113_ VGND VGND VPWR VPWR accumulator._0114_
+ sky130_fd_sc_hd__nor2_1
XFILLER_0_49_176 VGND VGND VPWR VPWR sky130_fd_sc_hd__decap_6
XFILLER_0_45_382 VGND VGND VPWR VPWR sky130_fd_sc_hd__decap_8
XTAP_TAPCELL_ROW_40_428 VGND VPWR sky130_fd_sc_hd__tapvpwrvgnd_1
XFILLER_0_37_305 VPWR VGND VPWR VGND sky130_ef_sc_hd__decap_12
XFILLER_0_45_393 VGND VGND VPWR VPWR sky130_fd_sc_hd__decap_3
XFILLER_0_20_249 VGND VGND VPWR VPWR sky130_fd_sc_hd__decap_3
XTAP_TAPCELL_ROW_5_183 VGND VPWR sky130_fd_sc_hd__tapvpwrvgnd_1
XFILLER_0_0_3 VPWR VGND VPWR VGND sky130_ef_sc_hd__decap_12
XFILLER_0_55_113 VPWR VGND VPWR VGND sky130_ef_sc_hd__decap_12
XFILLER_0_50_15 VPWR VGND VPWR VGND sky130_ef_sc_hd__decap_12
XFILLER_0_34_49 VGND VGND VPWR VPWR sky130_fd_sc_hd__fill_1
XFILLER_0_34_27 VGND VGND VPWR VPWR sky130_fd_sc_hd__fill_1
XFILLER_0_3_405 VGND VGND VPWR VPWR sky130_fd_sc_hd__decap_4
XFILLER_0_59_57 VGND VGND VPWR VPWR sky130_fd_sc_hd__decap_4
Xaccumulator._1500_ accumulator._0502_ accumulator._0577_ accumulator._0597_ VGND
+ VGND VPWR VPWR accumulator._0598_ sky130_fd_sc_hd__o21a_1
XscaleAdd._496_ scaleAdd._156_ scaleAdd._167_ VGND VGND VPWR VPWR scaleAdd._168_ sky130_fd_sc_hd__or2_1
Xaccumulator._1293_ accumulator._0390_ VGND VGND VPWR VPWR accumulator._0391_ sky130_fd_sc_hd__clkbuf_2
Xaccumulator._1431_ accumulator.io_accOut\[15\] accumulator._0528_ accumulator._0347_
+ VGND VGND VPWR VPWR accumulator._0529_ sky130_fd_sc_hd__mux2_1
Xaccumulator._1362_ accumulator._0458_ accumulator._0459_ accumulator._0427_ VGND
+ VGND VPWR VPWR accumulator._0460_ sky130_fd_sc_hd__mux2_1
XPHY_EDGE_ROW_49_Left_118 VGND VGND VPWR VPWR sky130_fd_sc_hd__decap_3
XFILLER_0_24_82 VGND VGND VPWR VPWR sky130_fd_sc_hd__fill_2
XFILLER_0_54_190 VGND VGND VPWR VPWR sky130_fd_sc_hd__decap_6
XFILLER_0_42_341 VGND VGND VPWR VPWR sky130_fd_sc_hd__fill_2
XPHY_EDGE_ROW_58_Left_127 VGND VGND VPWR VPWR sky130_fd_sc_hd__decap_3
Xaccumulator._1629_ accumulator._0390_ accumulator._0546_ accumulator._0562_ accumulator._0563_
+ VGND VGND VPWR VPWR accumulator._0727_ sky130_fd_sc_hd__or4_1
XFILLER_0_4_81 VGND VGND VPWR VPWR sky130_fd_sc_hd__decap_3
XFILLER_0_10_293 VPWR VGND VPWR VGND sky130_ef_sc_hd__decap_12
XPHY_EDGE_ROW_67_Left_136 VGND VGND VPWR VPWR sky130_fd_sc_hd__decap_3
XTAP_TAPCELL_ROW_53_520 VGND VPWR sky130_fd_sc_hd__tapvpwrvgnd_1
XFILLER_0_37_102 VGND VGND VPWR VPWR sky130_fd_sc_hd__decap_3
XTAP_TAPCELL_ROW_2_164 VGND VPWR sky130_fd_sc_hd__tapvpwrvgnd_1
XFILLER_0_37_157 VGND VGND VPWR VPWR sky130_fd_sc_hd__decap_8
XFILLER_0_33_341 VGND VGND VPWR VPWR sky130_fd_sc_hd__fill_1
XFILLER_0_20_18 VGND VGND VPWR VPWR sky130_fd_sc_hd__decap_8
XFILLER_0_20_29 VGND VGND VPWR VPWR sky130_fd_sc_hd__decap_8
XscaleAdd._350_ net63 scaleAdd._014_ scaleAdd._029_ scaleAdd._030_ VGND VGND VPWR
+ VPWR scaleAdd._032_ sky130_fd_sc_hd__nand4_2
XscaleAdd._281_ scaleAdd._221_ operator.io_outMant\[4\] scaleAdd._231_ VGND VGND VPWR
+ VPWR scaleAdd._232_ sky130_fd_sc_hd__and3_1
XFILLER_0_45_15 VPWR VGND VPWR VGND sky130_ef_sc_hd__decap_12
XFILLER_0_68_293 VPWR VGND VPWR VGND sky130_ef_sc_hd__decap_12
Xaccumulator._1980_ accumulator._1058_ accumulator._1072_ accumulator._1077_ VGND
+ VGND VPWR VPWR accumulator._1078_ sky130_fd_sc_hd__a21oi_1
XscaleAdd._548_ scaleAdd._207_ scaleAdd._209_ scaleAdd._214_ VGND VGND VPWR VPWR scaleAdd._216_
+ sky130_fd_sc_hd__nand3_1
XFILLER_0_3_202 VGND VGND VPWR VPWR sky130_fd_sc_hd__decap_3
XscaleAdd._479_ scaleAdd._151_ scaleAdd._149_ scaleAdd._153_ VGND VGND VPWR VPWR accumulator.io_inMant\[14\]
+ sky130_fd_sc_hd__o21ai_2
Xaccumulator._1414_ accumulator._0399_ VGND VGND VPWR VPWR accumulator._0512_ sky130_fd_sc_hd__buf_2
Xaccumulator._1345_ accumulator.io_accOut\[22\] accumulator._0431_ accumulator._0356_
+ VGND VGND VPWR VPWR accumulator._0443_ sky130_fd_sc_hd__mux2_1
XFILLER_0_19_102 VGND VGND VPWR VPWR sky130_fd_sc_hd__decap_8
XFILLER_0_19_113 VPWR VGND VPWR VGND sky130_ef_sc_hd__decap_12
Xaccumulator._1276_ accumulator._0324_ net87 VGND VGND VPWR VPWR accumulator._0374_
+ sky130_fd_sc_hd__xor2_2
XTAP_TAPCELL_ROW_50_501 VGND VPWR sky130_fd_sc_hd__tapvpwrvgnd_1
XFILLER_0_2_290 VPWR VGND VPWR VGND sky130_ef_sc_hd__decap_12
XFILLER_0_15_374 VPWR VGND VPWR VGND sky130_ef_sc_hd__decap_12
XFILLER_0_15_18 VPWR VGND VPWR VGND sky130_ef_sc_hd__decap_12
XTAP_TAPCELL_ROW_13_236 VGND VPWR sky130_fd_sc_hd__tapvpwrvgnd_1
XscaleAdd._402_ scaleAdd._079_ scaleAdd._081_ VGND VGND VPWR VPWR scaleAdd._082_ sky130_fd_sc_hd__xor2_2
XFILLER_0_21_333 VGND VGND VPWR VPWR sky130_fd_sc_hd__decap_3
XFILLER_0_0_249 VGND VGND VPWR VPWR sky130_fd_sc_hd__decap_3
XscaleAdd._333_ scaleAdd._263_ scaleAdd._003_ VGND VGND VPWR VPWR scaleAdd._015_ sky130_fd_sc_hd__and2_1
Xoperator._081_ net8 net2 VGND VGND VPWR VPWR operator._020_ sky130_fd_sc_hd__and2_1
Xaccumulator._1894_ accumulator._0778_ accumulator._0991_ VGND VGND VPWR VPWR accumulator._0992_
+ sky130_fd_sc_hd__xnor2_2
Xaccumulator._1963_ accumulator._0367_ accumulator._1060_ VGND VGND VPWR VPWR accumulator._1061_
+ sky130_fd_sc_hd__or2_1
XFILLER_0_12_333 VPWR VGND VPWR VGND sky130_ef_sc_hd__decap_12
XFILLER_0_12_377 VPWR VGND VPWR VGND sky130_ef_sc_hd__decap_12
XFILLER_0_41_3 VPWR VGND VPWR VGND sky130_ef_sc_hd__decap_12
XTAP_TAPCELL_ROW_35_394 VGND VPWR sky130_fd_sc_hd__tapvpwrvgnd_1
Xaccumulator._1259_ accumulator._0356_ accumulator._0358_ accumulator.io_accOut\[31\]
+ VGND VGND VPWR VPWR accumulator._0359_ sky130_fd_sc_hd__a21o_1
XTAP_TAPCELL_ROW_27_339 VGND VPWR sky130_fd_sc_hd__tapvpwrvgnd_1
XFILLER_0_1_82 VGND VGND VPWR VPWR sky130_fd_sc_hd__fill_1
Xaccumulator._1328_ accumulator.io_inMant\[9\] accumulator.io_inMant\[8\] accumulator._0415_
+ VGND VGND VPWR VPWR accumulator._0426_ sky130_fd_sc_hd__mux2_1
XFILLER_0_62_277 VGND VGND VPWR VPWR sky130_fd_sc_hd__fill_2
XFILLER_0_62_233 VPWR VGND VPWR VGND sky130_ef_sc_hd__decap_12
XFILLER_0_7_393 VPWR VGND VPWR VGND sky130_ef_sc_hd__decap_12
XTAP_TAPCELL_ROW_10_217 VGND VPWR sky130_fd_sc_hd__tapvpwrvgnd_1
Xhold51 accumulator.io_accOut\[15\] VGND VGND VPWR VPWR net114 sky130_fd_sc_hd__dlygate4sd3_1
XFILLER_0_53_266 VPWR VGND VPWR VGND sky130_ef_sc_hd__decap_12
XFILLER_0_42_27 VGND VGND VPWR VPWR sky130_fd_sc_hd__fill_1
XFILLER_0_67_57 VPWR VGND VPWR VGND sky130_ef_sc_hd__decap_12
Xrebuffer27 accumulator._0697_ VGND VGND VPWR VPWR net90 sky130_fd_sc_hd__dlygate4sd3_1
Xaccumulator._2300_ clknet_2_2__leaf_clock accumulator._0007_ VGND VGND VPWR VPWR
+ accumulator.io_accOut\[5\] sky130_fd_sc_hd__dfxtp_2
Xaccumulator._2231_ accumulator._0207_ accumulator._0212_ VGND VGND VPWR VPWR accumulator._0213_
+ sky130_fd_sc_hd__nor2_1
Xrebuffer16 accumulator._0269_ VGND VGND VPWR VPWR net79 sky130_fd_sc_hd__dlygate4sd1_1
XscaleAdd._316_ operator.io_outMant\[2\] VGND VGND VPWR VPWR scaleAdd._265_ sky130_fd_sc_hd__inv_2
Xaccumulator._2093_ accumulator._0078_ accumulator._0062_ accumulator._1096_ VGND
+ VGND VPWR VPWR accumulator._0079_ sky130_fd_sc_hd__mux2_4
Xaccumulator._2162_ accumulator._0061_ accumulator._0086_ VGND VGND VPWR VPWR accumulator._0146_
+ sky130_fd_sc_hd__or2b_1
Xrebuffer38 net100 VGND VGND VPWR VPWR net101 sky130_fd_sc_hd__dlygate4sd1_1
Xaccumulator._1946_ accumulator._0959_ accumulator._0964_ VGND VGND VPWR VPWR accumulator._1044_
+ sky130_fd_sc_hd__and2b_1
XFILLER_0_44_233 VGND VGND VPWR VPWR sky130_fd_sc_hd__fill_1
XTAP_TAPCELL_ROW_32_375 VGND VPWR sky130_fd_sc_hd__tapvpwrvgnd_1
XFILLER_0_4_363 VGND VGND VPWR VPWR sky130_fd_sc_hd__fill_1
Xoperator._064_ operator._006_ operator._007_ VGND VGND VPWR VPWR operator._008_ sky130_fd_sc_hd__xnor2_1
Xaccumulator._1877_ accumulator._0815_ accumulator._0727_ accumulator._0974_ VGND
+ VGND VPWR VPWR accumulator._0975_ sky130_fd_sc_hd__and3_1
XFILLER_0_12_141 VPWR VGND VPWR VGND sky130_ef_sc_hd__decap_12
XFILLER_0_35_211 VGND VGND VPWR VPWR sky130_fd_sc_hd__decap_4
XFILLER_0_35_200 VGND VGND VPWR VPWR sky130_fd_sc_hd__fill_2
Xoutput30 net30 VGND VGND VPWR VPWR io_accOut[10] sky130_fd_sc_hd__buf_2
Xoutput41 net41 VGND VGND VPWR VPWR io_accOut[20] sky130_fd_sc_hd__buf_2
Xoutput52 net52 VGND VGND VPWR VPWR io_accOut[30] sky130_fd_sc_hd__buf_2
XFILLER_0_37_27 VPWR VGND VPWR VGND sky130_ef_sc_hd__decap_12
XFILLER_0_53_15 VPWR VGND VPWR VGND sky130_ef_sc_hd__decap_12
XTAP_TAPCELL_ROW_46_467 VGND VPWR sky130_fd_sc_hd__tapvpwrvgnd_1
Xaccumulator._1800_ accumulator._0817_ accumulator._0410_ accumulator._0897_ VGND
+ VGND VPWR VPWR accumulator._0898_ sky130_fd_sc_hd__nand3_1
XFILLER_0_41_258 VPWR VGND VPWR VGND sky130_ef_sc_hd__decap_12
XFILLER_0_41_225 VPWR VGND VPWR VGND sky130_ef_sc_hd__decap_12
XFILLER_0_5_149 VPWR VGND VPWR VGND sky130_ef_sc_hd__decap_12
Xaccumulator._1662_ accumulator._0534_ accumulator._0749_ accumulator._0747_ VGND
+ VGND VPWR VPWR accumulator._0760_ sky130_fd_sc_hd__nand3_1
Xaccumulator._1731_ accumulator._0659_ accumulator._0828_ accumulator._0658_ VGND
+ VGND VPWR VPWR accumulator._0829_ sky130_fd_sc_hd__a21o_1
.ends
