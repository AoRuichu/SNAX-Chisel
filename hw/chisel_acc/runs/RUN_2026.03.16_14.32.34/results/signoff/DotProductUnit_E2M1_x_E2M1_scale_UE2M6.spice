* NGSPICE file created from DotProductUnit_E2M1_x_E2M1_scale_UE2M6.ext - technology: sky130A

* Black-box entry subcircuit for sky130_fd_sc_hd__xnor2_2 abstract view
.subckt sky130_fd_sc_hd__xnor2_2 A B VGND VNB VPB VPWR Y
.ends

* Black-box entry subcircuit for sky130_fd_sc_hd__tapvpwrvgnd_1 abstract view
.subckt sky130_fd_sc_hd__tapvpwrvgnd_1 VGND VPWR
.ends

* Black-box entry subcircuit for sky130_fd_sc_hd__dfxtp_2 abstract view
.subckt sky130_fd_sc_hd__dfxtp_2 CLK D VGND VNB VPB VPWR Q
.ends

* Black-box entry subcircuit for sky130_fd_sc_hd__nand2_1 abstract view
.subckt sky130_fd_sc_hd__nand2_1 A B VGND VNB VPB VPWR Y
.ends

* Black-box entry subcircuit for sky130_fd_sc_hd__fill_2 abstract view
.subckt sky130_fd_sc_hd__fill_2 VGND VNB VPB VPWR
.ends

* Black-box entry subcircuit for sky130_fd_sc_hd__mux2_4 abstract view
.subckt sky130_fd_sc_hd__mux2_4 A0 A1 S VGND VNB VPB VPWR X
.ends

* Black-box entry subcircuit for sky130_ef_sc_hd__decap_12 abstract view
.subckt sky130_ef_sc_hd__decap_12 VPWR VGND VPB VNB
.ends

* Black-box entry subcircuit for sky130_fd_sc_hd__clkbuf_1 abstract view
.subckt sky130_fd_sc_hd__clkbuf_1 A VGND VNB VPB VPWR X
.ends

* Black-box entry subcircuit for sky130_fd_sc_hd__decap_3 abstract view
.subckt sky130_fd_sc_hd__decap_3 VGND VNB VPB VPWR
.ends

* Black-box entry subcircuit for sky130_fd_sc_hd__fill_1 abstract view
.subckt sky130_fd_sc_hd__fill_1 VGND VNB VPB VPWR
.ends

* Black-box entry subcircuit for sky130_fd_sc_hd__nor2_1 abstract view
.subckt sky130_fd_sc_hd__nor2_1 A B VGND VNB VPB VPWR Y
.ends

* Black-box entry subcircuit for sky130_fd_sc_hd__a21oi_1 abstract view
.subckt sky130_fd_sc_hd__a21oi_1 A1 A2 B1 VGND VNB VPB VPWR Y
.ends

* Black-box entry subcircuit for sky130_fd_sc_hd__decap_4 abstract view
.subckt sky130_fd_sc_hd__decap_4 VGND VNB VPB VPWR
.ends

* Black-box entry subcircuit for sky130_fd_sc_hd__or2_1 abstract view
.subckt sky130_fd_sc_hd__or2_1 A B VGND VNB VPB VPWR X
.ends

* Black-box entry subcircuit for sky130_fd_sc_hd__decap_6 abstract view
.subckt sky130_fd_sc_hd__decap_6 VGND VNB VPB VPWR
.ends

* Black-box entry subcircuit for sky130_fd_sc_hd__or2b_1 abstract view
.subckt sky130_fd_sc_hd__or2b_1 A B_N VGND VNB VPB VPWR X
.ends

* Black-box entry subcircuit for sky130_fd_sc_hd__o32a_1 abstract view
.subckt sky130_fd_sc_hd__o32a_1 A1 A2 A3 B1 B2 VGND VNB VPB VPWR X
.ends

* Black-box entry subcircuit for sky130_fd_sc_hd__a31o_1 abstract view
.subckt sky130_fd_sc_hd__a31o_1 A1 A2 A3 B1 VGND VNB VPB VPWR X
.ends

* Black-box entry subcircuit for sky130_fd_sc_hd__and2_1 abstract view
.subckt sky130_fd_sc_hd__and2_1 A B VGND VNB VPB VPWR X
.ends

* Black-box entry subcircuit for sky130_fd_sc_hd__o21ba_1 abstract view
.subckt sky130_fd_sc_hd__o21ba_1 A1 A2 B1_N VGND VNB VPB VPWR X
.ends

* Black-box entry subcircuit for sky130_fd_sc_hd__o311a_1 abstract view
.subckt sky130_fd_sc_hd__o311a_1 A1 A2 A3 B1 C1 VGND VNB VPB VPWR X
.ends

* Black-box entry subcircuit for sky130_fd_sc_hd__a31oi_1 abstract view
.subckt sky130_fd_sc_hd__a31oi_1 A1 A2 A3 B1 VGND VNB VPB VPWR Y
.ends

* Black-box entry subcircuit for sky130_fd_sc_hd__decap_8 abstract view
.subckt sky130_fd_sc_hd__decap_8 VGND VNB VPB VPWR
.ends

* Black-box entry subcircuit for sky130_fd_sc_hd__mux2_1 abstract view
.subckt sky130_fd_sc_hd__mux2_1 A0 A1 S VGND VNB VPB VPWR X
.ends

* Black-box entry subcircuit for sky130_fd_sc_hd__xnor2_1 abstract view
.subckt sky130_fd_sc_hd__xnor2_1 A B VGND VNB VPB VPWR Y
.ends

* Black-box entry subcircuit for sky130_fd_sc_hd__o211ai_2 abstract view
.subckt sky130_fd_sc_hd__o211ai_2 A1 A2 B1 C1 VGND VNB VPB VPWR Y
.ends

* Black-box entry subcircuit for sky130_fd_sc_hd__dlygate4sd3_1 abstract view
.subckt sky130_fd_sc_hd__dlygate4sd3_1 A VGND VNB VPB VPWR X
.ends

* Black-box entry subcircuit for sky130_fd_sc_hd__a22o_1 abstract view
.subckt sky130_fd_sc_hd__a22o_1 A1 A2 B1 B2 VGND VNB VPB VPWR X
.ends

* Black-box entry subcircuit for sky130_fd_sc_hd__buf_2 abstract view
.subckt sky130_fd_sc_hd__buf_2 A VGND VNB VPB VPWR X
.ends

* Black-box entry subcircuit for sky130_fd_sc_hd__and3_1 abstract view
.subckt sky130_fd_sc_hd__and3_1 A B C VGND VNB VPB VPWR X
.ends

* Black-box entry subcircuit for sky130_fd_sc_hd__buf_8 abstract view
.subckt sky130_fd_sc_hd__buf_8 A VGND VNB VPB VPWR X
.ends

* Black-box entry subcircuit for sky130_fd_sc_hd__o2bb2a_1 abstract view
.subckt sky130_fd_sc_hd__o2bb2a_1 A1_N A2_N B1 B2 VGND VNB VPB VPWR X
.ends

* Black-box entry subcircuit for sky130_fd_sc_hd__o21a_1 abstract view
.subckt sky130_fd_sc_hd__o21a_1 A1 A2 B1 VGND VNB VPB VPWR X
.ends

* Black-box entry subcircuit for sky130_fd_sc_hd__inv_2 abstract view
.subckt sky130_fd_sc_hd__inv_2 A VGND VNB VPB VPWR Y
.ends

* Black-box entry subcircuit for sky130_fd_sc_hd__a21bo_4 abstract view
.subckt sky130_fd_sc_hd__a21bo_4 A1 A2 B1_N VGND VNB VPB VPWR X
.ends

* Black-box entry subcircuit for sky130_fd_sc_hd__o22a_1 abstract view
.subckt sky130_fd_sc_hd__o22a_1 A1 A2 B1 B2 VGND VNB VPB VPWR X
.ends

* Black-box entry subcircuit for sky130_fd_sc_hd__dlygate4sd1_1 abstract view
.subckt sky130_fd_sc_hd__dlygate4sd1_1 A VGND VNB VPB VPWR X
.ends

* Black-box entry subcircuit for sky130_fd_sc_hd__o211a_1 abstract view
.subckt sky130_fd_sc_hd__o211a_1 A1 A2 B1 C1 VGND VNB VPB VPWR X
.ends

* Black-box entry subcircuit for sky130_fd_sc_hd__and2b_1 abstract view
.subckt sky130_fd_sc_hd__and2b_1 A_N B VGND VNB VPB VPWR X
.ends

* Black-box entry subcircuit for sky130_fd_sc_hd__and2_4 abstract view
.subckt sky130_fd_sc_hd__and2_4 A B VGND VNB VPB VPWR X
.ends

* Black-box entry subcircuit for sky130_fd_sc_hd__xor2_1 abstract view
.subckt sky130_fd_sc_hd__xor2_1 A B VGND VNB VPB VPWR X
.ends

* Black-box entry subcircuit for sky130_fd_sc_hd__or3_1 abstract view
.subckt sky130_fd_sc_hd__or3_1 A B C VGND VNB VPB VPWR X
.ends

* Black-box entry subcircuit for sky130_fd_sc_hd__and4_1 abstract view
.subckt sky130_fd_sc_hd__and4_1 A B C D VGND VNB VPB VPWR X
.ends

* Black-box entry subcircuit for sky130_fd_sc_hd__o21ai_1 abstract view
.subckt sky130_fd_sc_hd__o21ai_1 A1 A2 B1 VGND VNB VPB VPWR Y
.ends

* Black-box entry subcircuit for sky130_fd_sc_hd__nand2b_1 abstract view
.subckt sky130_fd_sc_hd__nand2b_1 A_N B VGND VNB VPB VPWR Y
.ends

* Black-box entry subcircuit for sky130_fd_sc_hd__a211o_1 abstract view
.subckt sky130_fd_sc_hd__a211o_1 A1 A2 B1 C1 VGND VNB VPB VPWR X
.ends

* Black-box entry subcircuit for sky130_fd_sc_hd__a21o_1 abstract view
.subckt sky130_fd_sc_hd__a21o_1 A1 A2 B1 VGND VNB VPB VPWR X
.ends

* Black-box entry subcircuit for sky130_fd_sc_hd__o21ai_2 abstract view
.subckt sky130_fd_sc_hd__o21ai_2 A1 A2 B1 VGND VNB VPB VPWR Y
.ends

* Black-box entry subcircuit for sky130_fd_sc_hd__a21oi_4 abstract view
.subckt sky130_fd_sc_hd__a21oi_4 A1 A2 B1 VGND VNB VPB VPWR Y
.ends

* Black-box entry subcircuit for sky130_fd_sc_hd__or3_4 abstract view
.subckt sky130_fd_sc_hd__or3_4 A B C VGND VNB VPB VPWR X
.ends

* Black-box entry subcircuit for sky130_fd_sc_hd__clkbuf_4 abstract view
.subckt sky130_fd_sc_hd__clkbuf_4 A VGND VNB VPB VPWR X
.ends

* Black-box entry subcircuit for sky130_fd_sc_hd__xor2_4 abstract view
.subckt sky130_fd_sc_hd__xor2_4 A B VGND VNB VPB VPWR X
.ends

* Black-box entry subcircuit for sky130_fd_sc_hd__mux2_2 abstract view
.subckt sky130_fd_sc_hd__mux2_2 A0 A1 S VGND VNB VPB VPWR X
.ends

* Black-box entry subcircuit for sky130_fd_sc_hd__a31o_4 abstract view
.subckt sky130_fd_sc_hd__a31o_4 A1 A2 A3 B1 VGND VNB VPB VPWR X
.ends

* Black-box entry subcircuit for sky130_fd_sc_hd__nand3b_1 abstract view
.subckt sky130_fd_sc_hd__nand3b_1 A_N B C VGND VNB VPB VPWR Y
.ends

* Black-box entry subcircuit for sky130_fd_sc_hd__dfxtp_1 abstract view
.subckt sky130_fd_sc_hd__dfxtp_1 CLK D VGND VNB VPB VPWR Q
.ends

* Black-box entry subcircuit for sky130_fd_sc_hd__a21oi_2 abstract view
.subckt sky130_fd_sc_hd__a21oi_2 A1 A2 B1 VGND VNB VPB VPWR Y
.ends

* Black-box entry subcircuit for sky130_fd_sc_hd__o31ai_1 abstract view
.subckt sky130_fd_sc_hd__o31ai_1 A1 A2 A3 B1 VGND VNB VPB VPWR Y
.ends

* Black-box entry subcircuit for sky130_fd_sc_hd__xor2_2 abstract view
.subckt sky130_fd_sc_hd__xor2_2 A B VGND VNB VPB VPWR X
.ends

* Black-box entry subcircuit for sky130_fd_sc_hd__and4bb_1 abstract view
.subckt sky130_fd_sc_hd__and4bb_1 A_N B_N C D VGND VNB VPB VPWR X
.ends

* Black-box entry subcircuit for sky130_fd_sc_hd__or2b_2 abstract view
.subckt sky130_fd_sc_hd__or2b_2 A B_N VGND VNB VPB VPWR X
.ends

* Black-box entry subcircuit for sky130_fd_sc_hd__and3b_1 abstract view
.subckt sky130_fd_sc_hd__and3b_1 A_N B C VGND VNB VPB VPWR X
.ends

* Black-box entry subcircuit for sky130_fd_sc_hd__o32ai_4 abstract view
.subckt sky130_fd_sc_hd__o32ai_4 A1 A2 A3 B1 B2 VGND VNB VPB VPWR Y
.ends

* Black-box entry subcircuit for sky130_fd_sc_hd__nand2_2 abstract view
.subckt sky130_fd_sc_hd__nand2_2 A B VGND VNB VPB VPWR Y
.ends

* Black-box entry subcircuit for sky130_fd_sc_hd__a2111o_1 abstract view
.subckt sky130_fd_sc_hd__a2111o_1 A1 A2 B1 C1 D1 VGND VNB VPB VPWR X
.ends

* Black-box entry subcircuit for sky130_fd_sc_hd__or3_2 abstract view
.subckt sky130_fd_sc_hd__or3_2 A B C VGND VNB VPB VPWR X
.ends

* Black-box entry subcircuit for sky130_fd_sc_hd__nor2_4 abstract view
.subckt sky130_fd_sc_hd__nor2_4 A B VGND VNB VPB VPWR Y
.ends

* Black-box entry subcircuit for sky130_fd_sc_hd__clkbuf_16 abstract view
.subckt sky130_fd_sc_hd__clkbuf_16 A VGND VNB VPB VPWR X
.ends

* Black-box entry subcircuit for sky130_fd_sc_hd__nor2_2 abstract view
.subckt sky130_fd_sc_hd__nor2_2 A B VGND VNB VPB VPWR Y
.ends

* Black-box entry subcircuit for sky130_fd_sc_hd__o21bai_1 abstract view
.subckt sky130_fd_sc_hd__o21bai_1 A1 A2 B1_N VGND VNB VPB VPWR Y
.ends

* Black-box entry subcircuit for sky130_fd_sc_hd__nor3b_1 abstract view
.subckt sky130_fd_sc_hd__nor3b_1 A B C_N VGND VNB VPB VPWR Y
.ends

* Black-box entry subcircuit for sky130_fd_sc_hd__or3b_1 abstract view
.subckt sky130_fd_sc_hd__or3b_1 A B C_N VGND VNB VPB VPWR X
.ends

* Black-box entry subcircuit for sky130_fd_sc_hd__a311o_1 abstract view
.subckt sky130_fd_sc_hd__a311o_1 A1 A2 A3 B1 C1 VGND VNB VPB VPWR X
.ends

* Black-box entry subcircuit for sky130_fd_sc_hd__clkinvlp_2 abstract view
.subckt sky130_fd_sc_hd__clkinvlp_2 A VGND VNB VPB VPWR Y
.ends

* Black-box entry subcircuit for sky130_fd_sc_hd__o31a_2 abstract view
.subckt sky130_fd_sc_hd__o31a_2 A1 A2 A3 B1 VGND VNB VPB VPWR X
.ends

* Black-box entry subcircuit for sky130_fd_sc_hd__clkbuf_2 abstract view
.subckt sky130_fd_sc_hd__clkbuf_2 A VGND VNB VPB VPWR X
.ends

* Black-box entry subcircuit for sky130_fd_sc_hd__and2_2 abstract view
.subckt sky130_fd_sc_hd__and2_2 A B VGND VNB VPB VPWR X
.ends

* Black-box entry subcircuit for sky130_fd_sc_hd__or4_4 abstract view
.subckt sky130_fd_sc_hd__or4_4 A B C D VGND VNB VPB VPWR X
.ends

* Black-box entry subcircuit for sky130_fd_sc_hd__a221o_1 abstract view
.subckt sky130_fd_sc_hd__a221o_1 A1 A2 B1 B2 C1 VGND VNB VPB VPWR X
.ends

* Black-box entry subcircuit for sky130_fd_sc_hd__dfxtp_4 abstract view
.subckt sky130_fd_sc_hd__dfxtp_4 CLK D VGND VNB VPB VPWR Q
.ends

* Black-box entry subcircuit for sky130_fd_sc_hd__clkinvlp_4 abstract view
.subckt sky130_fd_sc_hd__clkinvlp_4 A VGND VNB VPB VPWR Y
.ends

* Black-box entry subcircuit for sky130_fd_sc_hd__o21bai_4 abstract view
.subckt sky130_fd_sc_hd__o21bai_4 A1 A2 B1_N VGND VNB VPB VPWR Y
.ends

* Black-box entry subcircuit for sky130_fd_sc_hd__a31oi_4 abstract view
.subckt sky130_fd_sc_hd__a31oi_4 A1 A2 A3 B1 VGND VNB VPB VPWR Y
.ends

* Black-box entry subcircuit for sky130_fd_sc_hd__o22ai_2 abstract view
.subckt sky130_fd_sc_hd__o22ai_2 A1 A2 B1 B2 VGND VNB VPB VPWR Y
.ends

* Black-box entry subcircuit for sky130_fd_sc_hd__or4_2 abstract view
.subckt sky130_fd_sc_hd__or4_2 A B C D VGND VNB VPB VPWR X
.ends

* Black-box entry subcircuit for sky130_fd_sc_hd__clkinv_1 abstract view
.subckt sky130_fd_sc_hd__clkinv_1 A VGND VNB VPB VPWR Y
.ends

* Black-box entry subcircuit for sky130_fd_sc_hd__a41oi_4 abstract view
.subckt sky130_fd_sc_hd__a41oi_4 A1 A2 A3 A4 B1 VGND VNB VPB VPWR Y
.ends

* Black-box entry subcircuit for sky130_fd_sc_hd__or3b_4 abstract view
.subckt sky130_fd_sc_hd__or3b_4 A B C_N VGND VNB VPB VPWR X
.ends

* Black-box entry subcircuit for sky130_fd_sc_hd__o221ai_1 abstract view
.subckt sky130_fd_sc_hd__o221ai_1 A1 A2 B1 B2 C1 VGND VNB VPB VPWR Y
.ends

* Black-box entry subcircuit for sky130_fd_sc_hd__nand2b_2 abstract view
.subckt sky130_fd_sc_hd__nand2b_2 A_N B VGND VNB VPB VPWR Y
.ends

* Black-box entry subcircuit for sky130_fd_sc_hd__a22o_2 abstract view
.subckt sky130_fd_sc_hd__a22o_2 A1 A2 B1 B2 VGND VNB VPB VPWR X
.ends

* Black-box entry subcircuit for sky130_fd_sc_hd__or2b_4 abstract view
.subckt sky130_fd_sc_hd__or2b_4 A B_N VGND VNB VPB VPWR X
.ends

* Black-box entry subcircuit for sky130_fd_sc_hd__xnor2_4 abstract view
.subckt sky130_fd_sc_hd__xnor2_4 A B VGND VNB VPB VPWR Y
.ends

* Black-box entry subcircuit for sky130_fd_sc_hd__or2_2 abstract view
.subckt sky130_fd_sc_hd__or2_2 A B VGND VNB VPB VPWR X
.ends

* Black-box entry subcircuit for sky130_fd_sc_hd__nand2_4 abstract view
.subckt sky130_fd_sc_hd__nand2_4 A B VGND VNB VPB VPWR Y
.ends

* Black-box entry subcircuit for sky130_fd_sc_hd__a21bo_1 abstract view
.subckt sky130_fd_sc_hd__a21bo_1 A1 A2 B1_N VGND VNB VPB VPWR X
.ends

* Black-box entry subcircuit for sky130_fd_sc_hd__o21ai_4 abstract view
.subckt sky130_fd_sc_hd__o21ai_4 A1 A2 B1 VGND VNB VPB VPWR Y
.ends

* Black-box entry subcircuit for sky130_fd_sc_hd__o31a_1 abstract view
.subckt sky130_fd_sc_hd__o31a_1 A1 A2 A3 B1 VGND VNB VPB VPWR X
.ends

* Black-box entry subcircuit for sky130_fd_sc_hd__buf_6 abstract view
.subckt sky130_fd_sc_hd__buf_6 A VGND VNB VPB VPWR X
.ends

* Black-box entry subcircuit for sky130_fd_sc_hd__a2bb2oi_1 abstract view
.subckt sky130_fd_sc_hd__a2bb2oi_1 A1_N A2_N B1 B2 VGND VNB VPB VPWR Y
.ends

* Black-box entry subcircuit for sky130_fd_sc_hd__nor2b_4 abstract view
.subckt sky130_fd_sc_hd__nor2b_4 A B_N VGND VNB VPB VPWR Y
.ends

* Black-box entry subcircuit for sky130_fd_sc_hd__a21o_4 abstract view
.subckt sky130_fd_sc_hd__a21o_4 A1 A2 B1 VGND VNB VPB VPWR X
.ends

* Black-box entry subcircuit for sky130_fd_sc_hd__buf_1 abstract view
.subckt sky130_fd_sc_hd__buf_1 A VGND VNB VPB VPWR X
.ends

* Black-box entry subcircuit for sky130_fd_sc_hd__a311oi_2 abstract view
.subckt sky130_fd_sc_hd__a311oi_2 A1 A2 A3 B1 C1 VGND VNB VPB VPWR Y
.ends

* Black-box entry subcircuit for sky130_fd_sc_hd__a32o_1 abstract view
.subckt sky130_fd_sc_hd__a32o_1 A1 A2 A3 B1 B2 VGND VNB VPB VPWR X
.ends

* Black-box entry subcircuit for sky130_fd_sc_hd__o22ai_1 abstract view
.subckt sky130_fd_sc_hd__o22ai_1 A1 A2 B1 B2 VGND VNB VPB VPWR Y
.ends

* Black-box entry subcircuit for sky130_fd_sc_hd__nor3_1 abstract view
.subckt sky130_fd_sc_hd__nor3_1 A B C VGND VNB VPB VPWR Y
.ends

* Black-box entry subcircuit for sky130_fd_sc_hd__dlymetal6s2s_1 abstract view
.subckt sky130_fd_sc_hd__dlymetal6s2s_1 A VGND VNB VPB VPWR X
.ends

* Black-box entry subcircuit for sky130_fd_sc_hd__o221a_4 abstract view
.subckt sky130_fd_sc_hd__o221a_4 A1 A2 B1 B2 C1 VGND VNB VPB VPWR X
.ends

* Black-box entry subcircuit for sky130_fd_sc_hd__o221a_1 abstract view
.subckt sky130_fd_sc_hd__o221a_1 A1 A2 B1 B2 C1 VGND VNB VPB VPWR X
.ends

* Black-box entry subcircuit for sky130_fd_sc_hd__o221ai_2 abstract view
.subckt sky130_fd_sc_hd__o221ai_2 A1 A2 B1 B2 C1 VGND VNB VPB VPWR Y
.ends

* Black-box entry subcircuit for sky130_fd_sc_hd__o211ai_4 abstract view
.subckt sky130_fd_sc_hd__o211ai_4 A1 A2 B1 C1 VGND VNB VPB VPWR Y
.ends

* Black-box entry subcircuit for sky130_fd_sc_hd__o31ai_2 abstract view
.subckt sky130_fd_sc_hd__o31ai_2 A1 A2 A3 B1 VGND VNB VPB VPWR Y
.ends

* Black-box entry subcircuit for sky130_fd_sc_hd__a2bb2o_1 abstract view
.subckt sky130_fd_sc_hd__a2bb2o_1 A1_N A2_N B1 B2 VGND VNB VPB VPWR X
.ends

* Black-box entry subcircuit for sky130_fd_sc_hd__o22a_2 abstract view
.subckt sky130_fd_sc_hd__o22a_2 A1 A2 B1 B2 VGND VNB VPB VPWR X
.ends

* Black-box entry subcircuit for sky130_fd_sc_hd__o2bb2a_4 abstract view
.subckt sky130_fd_sc_hd__o2bb2a_4 A1_N A2_N B1 B2 VGND VNB VPB VPWR X
.ends

* Black-box entry subcircuit for sky130_fd_sc_hd__a2bb2o_4 abstract view
.subckt sky130_fd_sc_hd__a2bb2o_4 A1_N A2_N B1 B2 VGND VNB VPB VPWR X
.ends

* Black-box entry subcircuit for sky130_fd_sc_hd__a21boi_1 abstract view
.subckt sky130_fd_sc_hd__a21boi_1 A1 A2 B1_N VGND VNB VPB VPWR Y
.ends

* Black-box entry subcircuit for sky130_fd_sc_hd__o2bb2a_2 abstract view
.subckt sky130_fd_sc_hd__o2bb2a_2 A1_N A2_N B1 B2 VGND VNB VPB VPWR X
.ends

* Black-box entry subcircuit for sky130_fd_sc_hd__a31oi_2 abstract view
.subckt sky130_fd_sc_hd__a31oi_2 A1 A2 A3 B1 VGND VNB VPB VPWR Y
.ends

* Black-box entry subcircuit for sky130_fd_sc_hd__or2_4 abstract view
.subckt sky130_fd_sc_hd__or2_4 A B VGND VNB VPB VPWR X
.ends

* Black-box entry subcircuit for sky130_fd_sc_hd__or3b_2 abstract view
.subckt sky130_fd_sc_hd__or3b_2 A B C_N VGND VNB VPB VPWR X
.ends

* Black-box entry subcircuit for sky130_fd_sc_hd__o2111a_1 abstract view
.subckt sky130_fd_sc_hd__o2111a_1 A1 A2 B1 C1 D1 VGND VNB VPB VPWR X
.ends

* Black-box entry subcircuit for sky130_fd_sc_hd__o311a_4 abstract view
.subckt sky130_fd_sc_hd__o311a_4 A1 A2 A3 B1 C1 VGND VNB VPB VPWR X
.ends

* Black-box entry subcircuit for sky130_fd_sc_hd__or4_1 abstract view
.subckt sky130_fd_sc_hd__or4_1 A B C D VGND VNB VPB VPWR X
.ends

* Black-box entry subcircuit for sky130_fd_sc_hd__or4b_1 abstract view
.subckt sky130_fd_sc_hd__or4b_1 A B C D_N VGND VNB VPB VPWR X
.ends

* Black-box entry subcircuit for sky130_fd_sc_hd__o31a_4 abstract view
.subckt sky130_fd_sc_hd__o31a_4 A1 A2 A3 B1 VGND VNB VPB VPWR X
.ends

* Black-box entry subcircuit for sky130_fd_sc_hd__o21ba_4 abstract view
.subckt sky130_fd_sc_hd__o21ba_4 A1 A2 B1_N VGND VNB VPB VPWR X
.ends

* Black-box entry subcircuit for sky130_fd_sc_hd__a21boi_2 abstract view
.subckt sky130_fd_sc_hd__a21boi_2 A1 A2 B1_N VGND VNB VPB VPWR Y
.ends

* Black-box entry subcircuit for sky130_fd_sc_hd__a211o_4 abstract view
.subckt sky130_fd_sc_hd__a211o_4 A1 A2 B1 C1 VGND VNB VPB VPWR X
.ends

* Black-box entry subcircuit for sky130_fd_sc_hd__a22oi_1 abstract view
.subckt sky130_fd_sc_hd__a22oi_1 A1 A2 B1 B2 VGND VNB VPB VPWR Y
.ends

* Black-box entry subcircuit for sky130_fd_sc_hd__a211oi_2 abstract view
.subckt sky130_fd_sc_hd__a211oi_2 A1 A2 B1 C1 VGND VNB VPB VPWR Y
.ends

* Black-box entry subcircuit for sky130_fd_sc_hd__nand2b_4 abstract view
.subckt sky130_fd_sc_hd__nand2b_4 A_N B VGND VNB VPB VPWR Y
.ends

* Black-box entry subcircuit for sky130_fd_sc_hd__nand3_2 abstract view
.subckt sky130_fd_sc_hd__nand3_2 A B C VGND VNB VPB VPWR Y
.ends

* Black-box entry subcircuit for sky130_fd_sc_hd__a211oi_1 abstract view
.subckt sky130_fd_sc_hd__a211oi_1 A1 A2 B1 C1 VGND VNB VPB VPWR Y
.ends

* Black-box entry subcircuit for sky130_fd_sc_hd__a41o_1 abstract view
.subckt sky130_fd_sc_hd__a41o_1 A1 A2 A3 A4 B1 VGND VNB VPB VPWR X
.ends

* Black-box entry subcircuit for sky130_fd_sc_hd__nand3_1 abstract view
.subckt sky130_fd_sc_hd__nand3_1 A B C VGND VNB VPB VPWR Y
.ends

* Black-box entry subcircuit for sky130_fd_sc_hd__nor2b_1 abstract view
.subckt sky130_fd_sc_hd__nor2b_1 A B_N VGND VNB VPB VPWR Y
.ends

* Black-box entry subcircuit for sky130_fd_sc_hd__a32oi_1 abstract view
.subckt sky130_fd_sc_hd__a32oi_1 A1 A2 A3 B1 B2 VGND VNB VPB VPWR Y
.ends

* Black-box entry subcircuit for sky130_fd_sc_hd__o311ai_4 abstract view
.subckt sky130_fd_sc_hd__o311ai_4 A1 A2 A3 B1 C1 VGND VNB VPB VPWR Y
.ends

* Black-box entry subcircuit for sky130_fd_sc_hd__nor3_2 abstract view
.subckt sky130_fd_sc_hd__nor3_2 A B C VGND VNB VPB VPWR Y
.ends

* Black-box entry subcircuit for sky130_fd_sc_hd__buf_4 abstract view
.subckt sky130_fd_sc_hd__buf_4 A VGND VNB VPB VPWR X
.ends

* Black-box entry subcircuit for sky130_fd_sc_hd__a2111o_4 abstract view
.subckt sky130_fd_sc_hd__a2111o_4 A1 A2 B1 C1 D1 VGND VNB VPB VPWR X
.ends

* Black-box entry subcircuit for sky130_fd_sc_hd__nor2b_2 abstract view
.subckt sky130_fd_sc_hd__nor2b_2 A B_N VGND VNB VPB VPWR Y
.ends

* Black-box entry subcircuit for sky130_fd_sc_hd__and4b_1 abstract view
.subckt sky130_fd_sc_hd__and4b_1 A_N B C D VGND VNB VPB VPWR X
.ends

* Black-box entry subcircuit for sky130_fd_sc_hd__and4_2 abstract view
.subckt sky130_fd_sc_hd__and4_2 A B C D VGND VNB VPB VPWR X
.ends

.subckt DotProductUnit_E2M1_x_E2M1_scale_UE2M6 VGND VPWR clock io_accOut[0] io_accOut[10]
+ io_accOut[11] io_accOut[12] io_accOut[13] io_accOut[14] io_accOut[15] io_accOut[16]
+ io_accOut[17] io_accOut[18] io_accOut[19] io_accOut[1] io_accOut[20] io_accOut[21]
+ io_accOut[22] io_accOut[23] io_accOut[24] io_accOut[25] io_accOut[26] io_accOut[27]
+ io_accOut[28] io_accOut[29] io_accOut[2] io_accOut[30] io_accOut[31] io_accOut[3]
+ io_accOut[4] io_accOut[5] io_accOut[6] io_accOut[7] io_accOut[8] io_accOut[9] io_done
+ io_inA[0] io_inA[1] io_inA[2] io_inA[3] io_inB[0] io_inB[1] io_inB[2] io_inB[3]
+ io_inScaleA[0] io_inScaleA[1] io_inScaleA[2] io_inScaleA[3] io_inScaleA[4] io_inScaleA[5]
+ io_inScaleA[6] io_inScaleA[7] io_inScaleB[0] io_inScaleB[1] io_inScaleB[2] io_inScaleB[3]
+ io_inScaleB[4] io_inScaleB[5] io_inScaleB[6] io_inScaleB[7] io_resetAcc io_start
+ reset
X_2106_ _1186_ _1189_ VGND VGND VPWR VPWR _1190_ sky130_fd_sc_hd__xnor2_2
XTAP_TAPCELL_ROW_37_412 VGND VPWR sky130_fd_sc_hd__tapvpwrvgnd_1
X_3086_ clknet_2_1__leaf_clock _0003_ VGND VGND VPWR VPWR net44 sky130_fd_sc_hd__dfxtp_2
X_2037_ _0647_ _0944_ VGND VGND VPWR VPWR _1121_ sky130_fd_sc_hd__nand2_1
XFILLER_0_64_306 VGND VGND VPWR VPWR sky130_fd_sc_hd__fill_2
X_2939_ _0536_ _0558_ _0458_ VGND VGND VPWR VPWR _0559_ sky130_fd_sc_hd__mux2_4
XFILLER_0_32_269 VPWR VGND VPWR VGND sky130_ef_sc_hd__decap_12
XFILLER_0_4_171 VGND VGND VPWR VPWR sky130_fd_sc_hd__fill_2
XFILLER_0_20_409 VGND VGND VPWR VPWR sky130_fd_sc_hd__fill_2
XTAP_TAPCELL_ROW_43_448 VGND VPWR sky130_fd_sc_hd__tapvpwrvgnd_1
XFILLER_0_63_361 VPWR VGND VPWR VGND sky130_ef_sc_hd__decap_12
Xrebuffer7 _1401_ VGND VGND VPWR VPWR net62 sky130_fd_sc_hd__clkbuf_1
XFILLER_0_23_225 VPWR VGND VPWR VGND sky130_ef_sc_hd__decap_12
XFILLER_0_48_37 VGND VGND VPWR VPWR sky130_fd_sc_hd__decap_3
XFILLER_0_48_15 VPWR VGND VPWR VGND sky130_ef_sc_hd__decap_12
XFILLER_0_3_28 VGND VGND VPWR VPWR sky130_fd_sc_hd__fill_1
X_2724_ net65 _0209_ VGND VGND VPWR VPWR _0336_ sky130_fd_sc_hd__nor2_1
X_2655_ _0181_ _0258_ _0259_ VGND VGND VPWR VPWR _0260_ sky130_fd_sc_hd__a21oi_1
XFILLER_0_54_372 VGND VGND VPWR VPWR sky130_fd_sc_hd__decap_3
XFILLER_0_22_280 VGND VGND VPWR VPWR sky130_fd_sc_hd__fill_1
X_1606_ _0353_ _0617_ VGND VGND VPWR VPWR _0627_ sky130_fd_sc_hd__nor2_1
X_2586_ _0113_ _0183_ VGND VGND VPWR VPWR _0184_ sky130_fd_sc_hd__xnor2_2
XFILLER_0_1_163 VGND VGND VPWR VPWR sky130_fd_sc_hd__decap_4
X_3069_ net43 _0441_ VGND VGND VPWR VPWR _0686_ sky130_fd_sc_hd__or2_1
XFILLER_0_52_309 VGND VGND VPWR VPWR sky130_fd_sc_hd__decap_4
XTAP_TAPCELL_ROW_40_429 VGND VPWR sky130_fd_sc_hd__tapvpwrvgnd_1
XFILLER_0_60_386 VPWR VGND VPWR VGND sky130_ef_sc_hd__decap_12
XTAP_TAPCELL_ROW_56_540 VGND VPWR sky130_fd_sc_hd__tapvpwrvgnd_1
XTAP_TAPCELL_ROW_5_184 VGND VPWR sky130_fd_sc_hd__tapvpwrvgnd_1
XFILLER_0_18_29 VGND VGND VPWR VPWR sky130_fd_sc_hd__decap_6
XFILLER_0_50_27 VGND VGND VPWR VPWR sky130_fd_sc_hd__fill_1
XFILLER_0_63_180 VPWR VGND VPWR VGND sky130_ef_sc_hd__decap_12
X_2440_ _1528_ _1529_ VGND VGND VPWR VPWR _1531_ sky130_fd_sc_hd__nor2_1
XFILLER_0_55_169 VPWR VGND VPWR VGND sky130_ef_sc_hd__decap_12
XFILLER_0_51_364 VPWR VGND VPWR VGND sky130_ef_sc_hd__decap_12
XFILLER_0_59_69 VPWR VGND VPWR VGND sky130_ef_sc_hd__decap_12
X_2371_ _1453_ _1455_ VGND VGND VPWR VPWR _1456_ sky130_fd_sc_hd__or2b_1
XTAP_TAPCELL_ROW_19_286 VGND VPWR sky130_fd_sc_hd__tapvpwrvgnd_1
XTAP_TAPCELL_ROW_62_587 VGND VPWR sky130_fd_sc_hd__tapvpwrvgnd_1
XPHY_EDGE_ROW_49_Left_119 VGND VGND VPWR VPWR sky130_fd_sc_hd__decap_3
XFILLER_0_34_309 VGND VGND VPWR VPWR sky130_fd_sc_hd__fill_1
XFILLER_0_6_266 VPWR VGND VPWR VGND sky130_ef_sc_hd__decap_12
X_2638_ _0181_ _1495_ _0112_ _0239_ _0240_ VGND VGND VPWR VPWR _0241_ sky130_fd_sc_hd__o32a_1
X_2707_ _0316_ _0256_ VGND VGND VPWR VPWR _0317_ sky130_fd_sc_hd__xnor2_2
XFILLER_0_49_80 VPWR VGND VPWR VGND sky130_ef_sc_hd__decap_12
X_2569_ _0158_ _0160_ _0163_ _0164_ VGND VGND VPWR VPWR _0165_ sky130_fd_sc_hd__a31o_1
XFILLER_0_42_375 VGND VGND VPWR VPWR sky130_fd_sc_hd__decap_6
XPHY_EDGE_ROW_58_Left_128 VGND VGND VPWR VPWR sky130_fd_sc_hd__decap_3
XTAP_TAPCELL_ROW_2_165 VGND VPWR sky130_fd_sc_hd__tapvpwrvgnd_1
XFILLER_0_10_272 VPWR VGND VPWR VGND sky130_ef_sc_hd__decap_12
XPHY_EDGE_ROW_67_Left_137 VGND VGND VPWR VPWR sky130_fd_sc_hd__decap_3
XTAP_TAPCELL_ROW_53_521 VGND VPWR sky130_fd_sc_hd__tapvpwrvgnd_1
XFILLER_0_60_150 VPWR VGND VPWR VGND sky130_ef_sc_hd__decap_12
XFILLER_0_52_139 VGND VGND VPWR VPWR sky130_fd_sc_hd__fill_1
XFILLER_0_52_117 VPWR VGND VPWR VGND sky130_ef_sc_hd__decap_12
XFILLER_0_37_169 VGND VGND VPWR VPWR sky130_fd_sc_hd__decap_4
XFILLER_0_68_250 VGND VGND VPWR VPWR sky130_fd_sc_hd__fill_2
XFILLER_0_61_15 VPWR VGND VPWR VGND sky130_ef_sc_hd__decap_12
XFILLER_0_45_27 VPWR VGND VPWR VGND sky130_ef_sc_hd__decap_12
XFILLER_0_0_29 VPWR VGND VPWR VGND sky130_ef_sc_hd__decap_12
XFILLER_0_28_147 VGND VGND VPWR VPWR sky130_fd_sc_hd__fill_1
X_1940_ _0998_ _1022_ VGND VGND VPWR VPWR _1024_ sky130_fd_sc_hd__and2_1
X_1871_ _0940_ _0953_ _0954_ VGND VGND VPWR VPWR _0955_ sky130_fd_sc_hd__o21ba_1
XFILLER_0_16_309 VGND VGND VPWR VPWR sky130_fd_sc_hd__decap_6
X_2423_ _1510_ _1511_ VGND VGND VPWR VPWR _1513_ sky130_fd_sc_hd__or2_1
XFILLER_0_24_331 VPWR VGND VPWR VGND sky130_ef_sc_hd__decap_12
XFILLER_0_3_225 VGND VGND VPWR VPWR sky130_fd_sc_hd__fill_2
XFILLER_0_10_85 VPWR VGND VPWR VGND sky130_ef_sc_hd__decap_12
X_2354_ _1323_ _1295_ _1408_ _1437_ _1268_ VGND VGND VPWR VPWR _1438_ sky130_fd_sc_hd__o311a_1
X_2285_ net47 _1108_ _1367_ _1368_ VGND VGND VPWR VPWR _1369_ sky130_fd_sc_hd__a31oi_1
XFILLER_0_19_83 VPWR VGND VPWR VGND sky130_ef_sc_hd__decap_12
XFILLER_0_59_272 VGND VGND VPWR VPWR sky130_fd_sc_hd__decap_8
XTAP_TAPCELL_ROW_50_502 VGND VPWR sky130_fd_sc_hd__tapvpwrvgnd_1
XFILLER_0_62_404 VGND VGND VPWR VPWR sky130_fd_sc_hd__decap_8
XFILLER_0_30_323 VGND VGND VPWR VPWR sky130_fd_sc_hd__decap_3
XFILLER_0_19_169 VGND VGND VPWR VPWR sky130_fd_sc_hd__decap_4
XTAP_TAPCELL_ROW_7_202 VGND VPWR sky130_fd_sc_hd__tapvpwrvgnd_1
XFILLER_0_31_18 VPWR VGND VPWR VGND sky130_ef_sc_hd__decap_12
XFILLER_0_21_312 VGND VGND VPWR VPWR sky130_fd_sc_hd__decap_4
XFILLER_0_56_15 VPWR VGND VPWR VGND sky130_ef_sc_hd__decap_12
X_2070_ _1138_ _1121_ _1044_ VGND VGND VPWR VPWR _1154_ sky130_fd_sc_hd__mux2_1
X_2972_ _0401_ _0577_ _0590_ VGND VGND VPWR VPWR _0591_ sky130_fd_sc_hd__a21oi_1
XFILLER_0_48_209 VGND VGND VPWR VPWR sky130_fd_sc_hd__decap_6
XFILLER_0_56_253 VPWR VGND VPWR VGND sky130_ef_sc_hd__decap_12
XFILLER_0_24_161 VGND VGND VPWR VPWR sky130_fd_sc_hd__decap_3
X_1785_ _0866_ _0868_ VGND VGND VPWR VPWR _0869_ sky130_fd_sc_hd__xnor2_2
X_1854_ _0937_ _0916_ VGND VGND VPWR VPWR _0938_ sky130_fd_sc_hd__xnor2_1
X_1923_ _1004_ _1006_ VGND VGND VPWR VPWR _1007_ sky130_fd_sc_hd__or2b_1
X_2406_ _1490_ _1491_ VGND VGND VPWR VPWR _1494_ sky130_fd_sc_hd__or2_1
XFILLER_0_12_389 VPWR VGND VPWR VGND sky130_ef_sc_hd__decap_12
X_2268_ _1103_ _1185_ _1294_ _1351_ _1098_ VGND VGND VPWR VPWR _1352_ sky130_fd_sc_hd__o32a_1
X_2337_ _1297_ _1419_ _1420_ _1361_ VGND VGND VPWR VPWR _1421_ sky130_fd_sc_hd__o211ai_2
XFILLER_0_34_3 VPWR VGND VPWR VGND sky130_ef_sc_hd__decap_12
X_2199_ net23 _1282_ _1091_ VGND VGND VPWR VPWR _1283_ sky130_fd_sc_hd__mux2_4
XFILLER_0_47_264 VPWR VGND VPWR VGND sky130_ef_sc_hd__decap_12
XTAP_TAPCELL_ROW_35_395 VGND VPWR sky130_fd_sc_hd__tapvpwrvgnd_1
XFILLER_0_62_278 VPWR VGND VPWR VGND sky130_ef_sc_hd__decap_12
XFILLER_0_62_234 VGND VGND VPWR VPWR sky130_fd_sc_hd__fill_1
XFILLER_0_30_153 VGND VGND VPWR VPWR sky130_fd_sc_hd__decap_3
XFILLER_0_30_120 VGND VGND VPWR VPWR sky130_fd_sc_hd__decap_3
XFILLER_0_22_109 VPWR VGND VPWR VGND sky130_ef_sc_hd__decap_12
XFILLER_0_7_361 VPWR VGND VPWR VGND sky130_ef_sc_hd__decap_12
XTAP_TAPCELL_ROW_10_218 VGND VPWR sky130_fd_sc_hd__tapvpwrvgnd_1
Xhold30 net51 VGND VGND VPWR VPWR net85 sky130_fd_sc_hd__dlygate4sd3_1
XFILLER_0_30_197 VGND VGND VPWR VPWR sky130_fd_sc_hd__decap_6
XFILLER_0_30_186 VGND VGND VPWR VPWR sky130_fd_sc_hd__fill_2
XFILLER_0_30_175 VGND VGND VPWR VPWR sky130_fd_sc_hd__fill_1
XFILLER_0_26_29 VPWR VGND VPWR VGND sky130_ef_sc_hd__decap_12
XFILLER_0_26_18 VGND VGND VPWR VPWR sky130_fd_sc_hd__decap_8
XFILLER_0_53_223 VGND VGND VPWR VPWR sky130_fd_sc_hd__fill_1
XFILLER_0_67_69 VPWR VGND VPWR VGND sky130_ef_sc_hd__decap_12
X_1570_ _0199_ net13 _0210_ _0243_ VGND VGND VPWR VPWR _0254_ sky130_fd_sc_hd__a22o_1
Xrebuffer17 _1096_ VGND VGND VPWR VPWR net72 sky130_fd_sc_hd__buf_2
X_2122_ _1176_ _1197_ _1205_ VGND VGND VPWR VPWR _1206_ sky130_fd_sc_hd__and3_1
Xrebuffer28 _0925_ VGND VGND VPWR VPWR net83 sky130_fd_sc_hd__buf_8
X_2053_ _0993_ _1136_ _1009_ _0963_ VGND VGND VPWR VPWR _1137_ sky130_fd_sc_hd__o2bb2a_1
XFILLER_0_20_9 VGND VGND VPWR VPWR sky130_fd_sc_hd__decap_3
X_2955_ _0376_ _0464_ _0554_ _0504_ _0510_ VGND VGND VPWR VPWR _0575_ sky130_fd_sc_hd__o32a_1
XFILLER_0_29_275 VGND VGND VPWR VPWR sky130_fd_sc_hd__decap_4
X_2886_ _0447_ _0485_ VGND VGND VPWR VPWR _0507_ sky130_fd_sc_hd__or2_1
XTAP_TAPCELL_ROW_32_376 VGND VPWR sky130_fd_sc_hd__tapvpwrvgnd_1
X_1906_ _0988_ _0989_ VGND VGND VPWR VPWR _0990_ sky130_fd_sc_hd__nor2_1
X_1837_ _0812_ _0815_ _0816_ VGND VGND VPWR VPWR _0921_ sky130_fd_sc_hd__o21a_1
X_1768_ _0133_ _0851_ VGND VGND VPWR VPWR _0852_ sky130_fd_sc_hd__or2_1
X_1699_ _0752_ _0755_ VGND VGND VPWR VPWR _0783_ sky130_fd_sc_hd__xnor2_1
XFILLER_0_12_175 VPWR VGND VPWR VGND sky130_ef_sc_hd__decap_12
XFILLER_0_12_197 VPWR VGND VPWR VGND sky130_ef_sc_hd__decap_12
XFILLER_0_67_337 VPWR VGND VPWR VGND sky130_ef_sc_hd__decap_12
XFILLER_0_35_223 VGND VGND VPWR VPWR sky130_fd_sc_hd__fill_1
XTAP_TAPCELL_ROW_23_310 VGND VPWR sky130_fd_sc_hd__tapvpwrvgnd_1
Xoutput53 net53 VGND VGND VPWR VPWR io_accOut[9] sky130_fd_sc_hd__buf_2
Xoutput31 net31 VGND VGND VPWR VPWR io_accOut[18] sky130_fd_sc_hd__buf_2
Xoutput42 net42 VGND VGND VPWR VPWR io_accOut[28] sky130_fd_sc_hd__buf_2
XFILLER_0_53_27 VPWR VGND VPWR VGND sky130_ef_sc_hd__decap_12
XFILLER_0_37_39 VGND VGND VPWR VPWR sky130_fd_sc_hd__fill_2
X_2740_ _0352_ VGND VGND VPWR VPWR _0354_ sky130_fd_sc_hd__inv_2
X_2671_ _0169_ _0277_ VGND VGND VPWR VPWR _0278_ sky130_fd_sc_hd__nor2_1
XFILLER_0_41_204 VGND VGND VPWR VPWR sky130_fd_sc_hd__decap_3
XFILLER_0_26_245 VGND VGND VPWR VPWR sky130_fd_sc_hd__decap_6
X_1622_ _0511_ _0530_ _0705_ VGND VGND VPWR VPWR _0706_ sky130_fd_sc_hd__a21bo_4
X_1553_ net6 _0045_ net2 _0056_ VGND VGND VPWR VPWR _0067_ sky130_fd_sc_hd__o22a_1
X_3085_ clknet_2_1__leaf_clock _0002_ VGND VGND VPWR VPWR net33 sky130_fd_sc_hd__dfxtp_2
X_2105_ net35 _1165_ _1188_ VGND VGND VPWR VPWR _1189_ sky130_fd_sc_hd__mux2_1
X_2036_ _0947_ _1119_ _1044_ VGND VGND VPWR VPWR _1120_ sky130_fd_sc_hd__mux2_1
X_2938_ _0321_ _0323_ _0505_ VGND VGND VPWR VPWR _0558_ sky130_fd_sc_hd__mux2_4
XFILLER_0_17_223 VGND VGND VPWR VPWR sky130_fd_sc_hd__fill_1
X_2869_ _0488_ _0489_ _0477_ VGND VGND VPWR VPWR _0490_ sky130_fd_sc_hd__mux2_4
XFILLER_0_67_123 VGND VGND VPWR VPWR sky130_fd_sc_hd__decap_8
XTAP_TAPCELL_ROW_43_449 VGND VPWR sky130_fd_sc_hd__tapvpwrvgnd_1
XFILLER_0_63_373 VGND VGND VPWR VPWR sky130_fd_sc_hd__fill_1
Xrebuffer8 _0084_ VGND VGND VPWR VPWR net63 sky130_fd_sc_hd__dlygate4sd1_1
XFILLER_0_48_27 VGND VGND VPWR VPWR sky130_fd_sc_hd__fill_1
XFILLER_0_64_15 VPWR VGND VPWR VGND sky130_ef_sc_hd__decap_12
XTAP_TAPCELL_ROW_59_560 VGND VPWR sky130_fd_sc_hd__tapvpwrvgnd_1
X_2723_ _0329_ _0334_ VGND VGND VPWR VPWR _0335_ sky130_fd_sc_hd__nand2_1
XFILLER_0_46_307 VGND VGND VPWR VPWR sky130_fd_sc_hd__fill_1
X_2585_ _0136_ _0170_ _0173_ _0182_ VGND VGND VPWR VPWR _0183_ sky130_fd_sc_hd__o22a_1
X_2654_ _0251_ _0252_ _0125_ _0137_ VGND VGND VPWR VPWR _0259_ sky130_fd_sc_hd__o211a_1
XFILLER_0_1_175 VPWR VGND VPWR VGND sky130_ef_sc_hd__decap_12
X_1605_ _0320_ _0243_ VGND VGND VPWR VPWR _0617_ sky130_fd_sc_hd__and2b_1
XFILLER_0_64_115 VGND VGND VPWR VPWR sky130_fd_sc_hd__fill_1
X_2019_ _1102_ VGND VGND VPWR VPWR _1103_ sky130_fd_sc_hd__buf_2
XFILLER_0_49_123 VGND VGND VPWR VPWR sky130_fd_sc_hd__decap_8
XFILLER_0_37_307 VPWR VGND VPWR VGND sky130_ef_sc_hd__decap_12
X_3068_ _0683_ _0684_ VGND VGND VPWR VPWR _0685_ sky130_fd_sc_hd__and2_4
XFILLER_0_60_365 VGND VGND VPWR VPWR sky130_fd_sc_hd__decap_4
XFILLER_0_60_343 VGND VGND VPWR VPWR sky130_fd_sc_hd__fill_1
XFILLER_0_60_398 VPWR VGND VPWR VGND sky130_ef_sc_hd__decap_12
XFILLER_0_20_218 VPWR VGND VPWR VGND sky130_ef_sc_hd__decap_12
XTAP_TAPCELL_ROW_56_541 VGND VPWR sky130_fd_sc_hd__tapvpwrvgnd_1
XFILLER_0_34_29 VPWR VGND VPWR VGND sky130_ef_sc_hd__decap_12
XTAP_TAPCELL_ROW_5_185 VGND VPWR sky130_fd_sc_hd__tapvpwrvgnd_1
XFILLER_0_63_192 VPWR VGND VPWR VGND sky130_ef_sc_hd__decap_12
XFILLER_0_59_15 VPWR VGND VPWR VGND sky130_ef_sc_hd__decap_12
XFILLER_0_51_376 VGND VGND VPWR VPWR sky130_fd_sc_hd__decap_4
XFILLER_0_51_310 VGND VGND VPWR VPWR sky130_fd_sc_hd__decap_3
X_2370_ net47 _1093_ VGND VGND VPWR VPWR _1455_ sky130_fd_sc_hd__nand2_1
XFILLER_0_61_129 VGND VGND VPWR VPWR sky130_fd_sc_hd__fill_1
X_2706_ _0169_ _0250_ VGND VGND VPWR VPWR _0316_ sky130_fd_sc_hd__or2_1
XFILLER_0_54_192 VGND VGND VPWR VPWR sky130_fd_sc_hd__decap_4
XFILLER_0_54_170 VPWR VGND VPWR VGND sky130_ef_sc_hd__decap_12
XFILLER_0_42_365 VGND VGND VPWR VPWR sky130_fd_sc_hd__fill_1
XFILLER_0_40_61 VPWR VGND VPWR VGND sky130_ef_sc_hd__decap_12
XFILLER_0_6_234 VGND VGND VPWR VPWR sky130_fd_sc_hd__fill_1
XFILLER_0_6_245 VGND VGND VPWR VPWR sky130_fd_sc_hd__decap_6
XFILLER_0_6_278 VGND VGND VPWR VPWR sky130_fd_sc_hd__decap_4
X_2637_ _0181_ _1524_ VGND VGND VPWR VPWR _0240_ sky130_fd_sc_hd__nand2_1
XFILLER_0_64_3 VPWR VGND VPWR VGND sky130_ef_sc_hd__decap_12
X_2499_ _1471_ VGND VGND VPWR VPWR _0088_ sky130_fd_sc_hd__inv_2
XFILLER_0_49_92 VPWR VGND VPWR VGND sky130_ef_sc_hd__decap_12
XFILLER_0_49_70 VGND VGND VPWR VPWR sky130_fd_sc_hd__decap_4
X_2568_ _0136_ _0151_ _0145_ _0162_ VGND VGND VPWR VPWR _0164_ sky130_fd_sc_hd__a31oi_1
XFILLER_0_10_284 VPWR VGND VPWR VGND sky130_ef_sc_hd__decap_12
XPHY_EDGE_ROW_12_Right_12 VGND VGND VPWR VPWR sky130_fd_sc_hd__decap_3
XPHY_EDGE_ROW_21_Right_21 VGND VGND VPWR VPWR sky130_fd_sc_hd__decap_3
XTAP_TAPCELL_ROW_2_166 VGND VPWR sky130_fd_sc_hd__tapvpwrvgnd_1
XFILLER_0_65_413 VGND VGND VPWR VPWR sky130_fd_sc_hd__fill_2
XTAP_TAPCELL_ROW_53_522 VGND VPWR sky130_fd_sc_hd__tapvpwrvgnd_1
XFILLER_0_37_126 VGND VGND VPWR VPWR sky130_fd_sc_hd__fill_1
XFILLER_0_60_162 VPWR VGND VPWR VGND sky130_ef_sc_hd__decap_12
XFILLER_0_52_129 VGND VGND VPWR VPWR sky130_fd_sc_hd__decap_3
XPHY_EDGE_ROW_30_Right_30 VGND VGND VPWR VPWR sky130_fd_sc_hd__decap_3
XFILLER_0_29_18 VPWR VGND VPWR VGND sky130_ef_sc_hd__decap_12
XFILLER_0_68_273 VGND VGND VPWR VPWR sky130_fd_sc_hd__decap_3
XFILLER_0_61_27 VPWR VGND VPWR VGND sky130_ef_sc_hd__decap_12
XFILLER_0_56_402 VPWR VGND VPWR VGND sky130_ef_sc_hd__decap_12
XFILLER_0_45_39 VPWR VGND VPWR VGND sky130_ef_sc_hd__decap_12
XFILLER_0_28_104 VPWR VGND VPWR VGND sky130_ef_sc_hd__decap_12
XFILLER_0_24_343 VGND VGND VPWR VPWR sky130_fd_sc_hd__decap_8
X_1870_ _0873_ _0914_ VGND VGND VPWR VPWR _0954_ sky130_fd_sc_hd__xor2_1
XFILLER_0_9_39 VGND VGND VPWR VPWR sky130_fd_sc_hd__decap_3
X_2422_ _1510_ _1511_ VGND VGND VPWR VPWR _1512_ sky130_fd_sc_hd__and2_1
X_2353_ _1105_ _1271_ _1381_ VGND VGND VPWR VPWR _1437_ sky130_fd_sc_hd__or3_1
XFILLER_0_10_97 VGND VGND VPWR VPWR sky130_fd_sc_hd__decap_8
XFILLER_0_19_40 VGND VGND VPWR VPWR sky130_fd_sc_hd__fill_1
X_2284_ net44 _1078_ _1170_ _1112_ VGND VGND VPWR VPWR _1368_ sky130_fd_sc_hd__and4_1
XFILLER_0_29_6 VPWR VGND VPWR VGND sky130_ef_sc_hd__decap_12
XFILLER_0_19_95 VPWR VGND VPWR VGND sky130_ef_sc_hd__decap_12
XTAP_TAPCELL_ROW_50_503 VGND VPWR sky130_fd_sc_hd__tapvpwrvgnd_1
XFILLER_0_19_137 VPWR VGND VPWR VGND sky130_ef_sc_hd__decap_12
XFILLER_0_42_195 VGND VGND VPWR VPWR sky130_fd_sc_hd__fill_1
X_1999_ _0968_ _1056_ net37 VGND VGND VPWR VPWR _1083_ sky130_fd_sc_hd__o21ai_1
XFILLER_0_27_181 VGND VGND VPWR VPWR sky130_fd_sc_hd__decap_4
XFILLER_0_25_118 VGND VGND VPWR VPWR sky130_fd_sc_hd__decap_8
XTAP_TAPCELL_ROW_13_238 VGND VPWR sky130_fd_sc_hd__tapvpwrvgnd_1
XFILLER_0_18_170 VGND VGND VPWR VPWR sky130_fd_sc_hd__decap_4
XFILLER_0_21_335 VGND VGND VPWR VPWR sky130_fd_sc_hd__fill_1
XFILLER_0_56_27 VGND VGND VPWR VPWR sky130_fd_sc_hd__fill_1
XFILLER_0_56_265 VGND VGND VPWR VPWR sky130_fd_sc_hd__decap_3
XFILLER_0_56_221 VGND VGND VPWR VPWR sky130_fd_sc_hd__decap_4
X_2971_ _0401_ _0589_ VGND VGND VPWR VPWR _0590_ sky130_fd_sc_hd__nor2_1
X_1922_ _1005_ _0970_ VGND VGND VPWR VPWR _1006_ sky130_fd_sc_hd__and2_1
XFILLER_0_56_276 VGND VGND VPWR VPWR sky130_fd_sc_hd__fill_1
XFILLER_0_24_195 VGND VGND VPWR VPWR sky130_fd_sc_hd__fill_1
X_1784_ _0867_ _0853_ VGND VGND VPWR VPWR _0868_ sky130_fd_sc_hd__xnor2_2
X_1853_ _0917_ _0861_ VGND VGND VPWR VPWR _0937_ sky130_fd_sc_hd__nand2b_1
XFILLER_0_21_41 VGND VGND VPWR VPWR sky130_fd_sc_hd__fill_1
X_2405_ _1492_ VGND VGND VPWR VPWR _1493_ sky130_fd_sc_hd__inv_2
X_2336_ _1109_ _1145_ _1167_ _1271_ VGND VGND VPWR VPWR _1420_ sky130_fd_sc_hd__a211o_1
X_2267_ _1270_ _1338_ _1350_ VGND VGND VPWR VPWR _1351_ sky130_fd_sc_hd__o21ai_1
X_2198_ _1128_ _1124_ _1240_ _1127_ VGND VGND VPWR VPWR _1282_ sky130_fd_sc_hd__o211a_1
XFILLER_0_1_51 VGND VGND VPWR VPWR sky130_fd_sc_hd__decap_4
XFILLER_0_1_62 VGND VGND VPWR VPWR sky130_fd_sc_hd__decap_8
XFILLER_0_62_246 VGND VGND VPWR VPWR sky130_fd_sc_hd__decap_6
XFILLER_0_62_224 VGND VGND VPWR VPWR sky130_fd_sc_hd__decap_3
XFILLER_0_47_276 VGND VGND VPWR VPWR sky130_fd_sc_hd__decap_4
XTAP_TAPCELL_ROW_35_396 VGND VPWR sky130_fd_sc_hd__tapvpwrvgnd_1
XFILLER_0_7_373 VPWR VGND VPWR VGND sky130_ef_sc_hd__decap_12
XTAP_TAPCELL_ROW_10_219 VGND VPWR sky130_fd_sc_hd__tapvpwrvgnd_1
XFILLER_0_50_408 VGND VGND VPWR VPWR sky130_fd_sc_hd__decap_3
XFILLER_0_30_165 VGND VGND VPWR VPWR sky130_fd_sc_hd__decap_6
Xhold31 net28 VGND VGND VPWR VPWR net86 sky130_fd_sc_hd__dlygate4sd3_1
XFILLER_0_42_29 VGND VGND VPWR VPWR sky130_fd_sc_hd__decap_8
XTAP_TAPCELL_ROW_26_330 VGND VPWR sky130_fd_sc_hd__tapvpwrvgnd_1
XFILLER_0_38_287 VGND VGND VPWR VPWR sky130_fd_sc_hd__fill_2
XFILLER_0_67_15 VPWR VGND VPWR VGND sky130_ef_sc_hd__decap_12
XFILLER_0_6_29 VGND VGND VPWR VPWR sky130_fd_sc_hd__decap_4
Xrebuffer29 _0434_ VGND VGND VPWR VPWR net84 sky130_fd_sc_hd__clkbuf_1
X_2121_ _1193_ _1204_ _1108_ VGND VGND VPWR VPWR _1205_ sky130_fd_sc_hd__a21o_1
X_2052_ _0961_ _1115_ _1135_ VGND VGND VPWR VPWR _1136_ sky130_fd_sc_hd__o21ai_1
XFILLER_0_16_85 VGND VGND VPWR VPWR sky130_fd_sc_hd__fill_2
X_2885_ _0352_ _0349_ _0505_ VGND VGND VPWR VPWR _0506_ sky130_fd_sc_hd__mux2_4
X_2954_ net86 _1487_ VGND VGND VPWR VPWR _0574_ sky130_fd_sc_hd__nand2_1
XTAP_TAPCELL_ROW_32_377 VGND VPWR sky130_fd_sc_hd__tapvpwrvgnd_1
X_1905_ _0983_ _0987_ VGND VGND VPWR VPWR _0989_ sky130_fd_sc_hd__and2_1
XFILLER_0_17_405 VGND VGND VPWR VPWR sky130_fd_sc_hd__decap_6
XFILLER_0_4_365 VPWR VGND VPWR VGND sky130_ef_sc_hd__decap_12
XFILLER_0_4_321 VPWR VGND VPWR VGND sky130_ef_sc_hd__decap_12
X_1698_ _0780_ _0781_ _0758_ VGND VGND VPWR VPWR _0782_ sky130_fd_sc_hd__o21ai_2
X_1836_ _0847_ _0918_ _0919_ VGND VGND VPWR VPWR _0920_ sky130_fd_sc_hd__a21oi_4
XPHY_EDGE_ROW_6_Right_6 VGND VGND VPWR VPWR sky130_fd_sc_hd__decap_3
XFILLER_0_12_154 VGND VGND VPWR VPWR sky130_fd_sc_hd__decap_3
XFILLER_0_12_187 VGND VGND VPWR VPWR sky130_fd_sc_hd__decap_8
X_1767_ _0849_ _0850_ VGND VGND VPWR VPWR _0851_ sky130_fd_sc_hd__xnor2_2
XFILLER_0_57_81 VGND VGND VPWR VPWR sky130_fd_sc_hd__decap_4
X_2319_ _1401_ _1400_ _1392_ VGND VGND VPWR VPWR _1403_ sky130_fd_sc_hd__a21o_1
XFILLER_0_67_349 VPWR VGND VPWR VGND sky130_ef_sc_hd__decap_12
XTAP_TAPCELL_ROW_23_311 VGND VPWR sky130_fd_sc_hd__tapvpwrvgnd_1
Xoutput32 net32 VGND VGND VPWR VPWR io_accOut[19] sky130_fd_sc_hd__buf_2
Xoutput54 net54 VGND VGND VPWR VPWR io_done sky130_fd_sc_hd__buf_2
Xoutput43 net43 VGND VGND VPWR VPWR io_accOut[29] sky130_fd_sc_hd__buf_2
XFILLER_0_53_39 VPWR VGND VPWR VGND sky130_ef_sc_hd__decap_12
XPHY_EDGE_ROW_59_Right_59 VGND VGND VPWR VPWR sky130_fd_sc_hd__decap_3
XTAP_TAPCELL_ROW_46_469 VGND VPWR sky130_fd_sc_hd__tapvpwrvgnd_1
XFILLER_0_5_107 VGND VGND VPWR VPWR sky130_fd_sc_hd__decap_4
X_2670_ _0268_ _0272_ _0275_ VGND VGND VPWR VPWR _0277_ sky130_fd_sc_hd__and3_1
XFILLER_0_41_216 VGND VGND VPWR VPWR sky130_fd_sc_hd__decap_8
X_1552_ net3 VGND VGND VPWR VPWR _0056_ sky130_fd_sc_hd__inv_2
XFILLER_0_1_335 VGND VGND VPWR VPWR sky130_fd_sc_hd__fill_1
X_1621_ _0480_ _0540_ _0491_ VGND VGND VPWR VPWR _0705_ sky130_fd_sc_hd__or3_4
XPHY_EDGE_ROW_68_Right_68 VGND VGND VPWR VPWR sky130_fd_sc_hd__decap_3
X_2104_ _1187_ VGND VGND VPWR VPWR _1188_ sky130_fd_sc_hd__clkbuf_4
XFILLER_0_49_349 VGND VGND VPWR VPWR sky130_fd_sc_hd__fill_1
XFILLER_0_49_305 VPWR VGND VPWR VGND sky130_ef_sc_hd__decap_12
XFILLER_0_43_61 VGND VGND VPWR VPWR sky130_fd_sc_hd__fill_1
X_3084_ clknet_2_1__leaf_clock _0001_ VGND VGND VPWR VPWR net22 sky130_fd_sc_hd__dfxtp_2
XFILLER_0_9_413 VGND VGND VPWR VPWR sky130_fd_sc_hd__fill_2
X_2035_ _0943_ VGND VGND VPWR VPWR _1119_ sky130_fd_sc_hd__inv_2
X_2868_ _0374_ _0449_ VGND VGND VPWR VPWR _0489_ sky130_fd_sc_hd__nor2_1
X_2937_ _0504_ VGND VGND VPWR VPWR _0557_ sky130_fd_sc_hd__inv_2
XFILLER_0_17_257 VGND VGND VPWR VPWR sky130_fd_sc_hd__fill_1
XFILLER_0_17_279 VGND VGND VPWR VPWR sky130_fd_sc_hd__fill_1
X_2799_ _0317_ VGND VGND VPWR VPWR _0418_ sky130_fd_sc_hd__inv_2
XFILLER_0_32_249 VGND VGND VPWR VPWR sky130_fd_sc_hd__decap_3
XFILLER_0_4_184 VPWR VGND VPWR VGND sky130_ef_sc_hd__decap_12
X_1819_ _0901_ _0902_ VGND VGND VPWR VPWR _0903_ sky130_fd_sc_hd__nand2_1
XFILLER_0_55_308 VGND VGND VPWR VPWR sky130_fd_sc_hd__decap_8
Xrebuffer9 _0167_ VGND VGND VPWR VPWR net64 sky130_fd_sc_hd__buf_2
XFILLER_0_64_27 VGND VGND VPWR VPWR sky130_fd_sc_hd__fill_1
XTAP_TAPCELL_ROW_59_561 VGND VPWR sky130_fd_sc_hd__tapvpwrvgnd_1
X_2722_ _0205_ _0333_ VGND VGND VPWR VPWR _0334_ sky130_fd_sc_hd__xnor2_1
XFILLER_0_54_396 VGND VGND VPWR VPWR sky130_fd_sc_hd__decap_3
XFILLER_0_39_393 VGND VGND VPWR VPWR sky130_fd_sc_hd__fill_2
XFILLER_0_13_97 VGND VGND VPWR VPWR sky130_fd_sc_hd__decap_6
X_2584_ _0181_ _0174_ VGND VGND VPWR VPWR _0182_ sky130_fd_sc_hd__or2_1
X_2653_ net74 _0051_ VGND VGND VPWR VPWR _0258_ sky130_fd_sc_hd__nand2_1
XFILLER_0_1_110 VGND VGND VPWR VPWR sky130_fd_sc_hd__fill_2
X_1604_ _0408_ _0598_ VGND VGND VPWR VPWR _0608_ sky130_fd_sc_hd__and2_1
XFILLER_0_14_249 VGND VGND VPWR VPWR sky130_fd_sc_hd__decap_3
X_3067_ _0680_ _0682_ VGND VGND VPWR VPWR _0684_ sky130_fd_sc_hd__or2_1
XFILLER_0_64_149 VPWR VGND VPWR VGND sky130_ef_sc_hd__decap_12
XFILLER_0_49_146 VPWR VGND VPWR VGND sky130_ef_sc_hd__decap_12
X_2018_ _1101_ VGND VGND VPWR VPWR _1102_ sky130_fd_sc_hd__buf_2
XFILLER_0_37_319 VGND VGND VPWR VPWR sky130_fd_sc_hd__decap_8
XFILLER_0_9_221 VGND VGND VPWR VPWR sky130_fd_sc_hd__decap_3
XFILLER_0_45_363 VGND VGND VPWR VPWR sky130_fd_sc_hd__fill_2
XFILLER_0_13_260 VPWR VGND VPWR VGND sky130_ef_sc_hd__decap_12
XTAP_TAPCELL_ROW_56_542 VGND VPWR sky130_fd_sc_hd__tapvpwrvgnd_1
XTAP_TAPCELL_ROW_5_186 VGND VPWR sky130_fd_sc_hd__tapvpwrvgnd_1
XFILLER_0_55_127 VGND VGND VPWR VPWR sky130_fd_sc_hd__decap_8
XFILLER_0_55_105 VGND VGND VPWR VPWR sky130_fd_sc_hd__decap_6
XFILLER_0_50_29 VPWR VGND VPWR VGND sky130_ef_sc_hd__decap_12
XFILLER_0_36_396 VGND VGND VPWR VPWR sky130_fd_sc_hd__fill_1
XFILLER_0_59_27 VPWR VGND VPWR VGND sky130_ef_sc_hd__decap_12
XFILLER_0_51_333 VGND VGND VPWR VPWR sky130_fd_sc_hd__decap_3
XFILLER_0_11_219 VGND VGND VPWR VPWR sky130_fd_sc_hd__decap_4
XFILLER_0_46_138 VGND VGND VPWR VPWR sky130_fd_sc_hd__fill_2
XFILLER_0_46_127 VGND VGND VPWR VPWR sky130_fd_sc_hd__decap_3
XFILLER_0_24_85 VPWR VGND VPWR VGND sky130_ef_sc_hd__decap_12
XFILLER_0_24_41 VPWR VGND VPWR VGND sky130_ef_sc_hd__decap_12
X_2636_ _1496_ _0194_ VGND VGND VPWR VPWR _0239_ sky130_fd_sc_hd__and2b_1
XFILLER_0_54_182 VGND VGND VPWR VPWR sky130_fd_sc_hd__decap_3
XFILLER_0_40_95 VPWR VGND VPWR VGND sky130_ef_sc_hd__decap_12
XFILLER_0_40_73 VGND VGND VPWR VPWR sky130_fd_sc_hd__decap_4
X_2705_ _0314_ VGND VGND VPWR VPWR _0315_ sky130_fd_sc_hd__buf_2
X_2498_ _1482_ _1483_ VGND VGND VPWR VPWR _0087_ sky130_fd_sc_hd__or2_1
XFILLER_0_57_3 VPWR VGND VPWR VGND sky130_ef_sc_hd__decap_12
X_2567_ _0162_ VGND VGND VPWR VPWR _0163_ sky130_fd_sc_hd__inv_2
XFILLER_0_10_296 VPWR VGND VPWR VGND sky130_ef_sc_hd__decap_12
XFILLER_0_65_81 VGND VGND VPWR VPWR sky130_fd_sc_hd__fill_2
XTAP_TAPCELL_ROW_53_523 VGND VPWR sky130_fd_sc_hd__tapvpwrvgnd_1
XTAP_TAPCELL_ROW_2_167 VGND VPWR sky130_fd_sc_hd__tapvpwrvgnd_1
XFILLER_0_52_108 VGND VGND VPWR VPWR sky130_fd_sc_hd__fill_1
XFILLER_0_18_363 VGND VGND VPWR VPWR sky130_fd_sc_hd__fill_1
XFILLER_0_60_174 VPWR VGND VPWR VGND sky130_ef_sc_hd__decap_12
XFILLER_0_61_39 VPWR VGND VPWR VGND sky130_ef_sc_hd__decap_12
XFILLER_0_56_414 VGND VGND VPWR VPWR sky130_fd_sc_hd__fill_1
XFILLER_0_28_116 VGND VGND VPWR VPWR sky130_fd_sc_hd__decap_8
XFILLER_0_51_163 VGND VGND VPWR VPWR sky130_fd_sc_hd__decap_4
XFILLER_0_36_171 VGND VGND VPWR VPWR sky130_fd_sc_hd__fill_1
XFILLER_0_3_238 VPWR VGND VPWR VGND sky130_ef_sc_hd__decap_12
XFILLER_0_10_54 VGND VGND VPWR VPWR sky130_fd_sc_hd__fill_1
X_2352_ _1107_ _1435_ VGND VGND VPWR VPWR _1436_ sky130_fd_sc_hd__nand2_1
X_2283_ net56 _1112_ VGND VGND VPWR VPWR _1367_ sky130_fd_sc_hd__and2_1
X_2421_ net23 _1282_ _1078_ VGND VGND VPWR VPWR _1511_ sky130_fd_sc_hd__mux2_1
XFILLER_0_35_51 VGND VGND VPWR VPWR sky130_fd_sc_hd__decap_4
XFILLER_0_51_94 VGND VGND VPWR VPWR sky130_fd_sc_hd__decap_8
XFILLER_0_19_149 VGND VGND VPWR VPWR sky130_fd_sc_hd__decap_8
X_2619_ _1473_ _0219_ VGND VGND VPWR VPWR _0220_ sky130_fd_sc_hd__xnor2_2
XFILLER_0_42_185 VGND VGND VPWR VPWR sky130_fd_sc_hd__fill_1
XFILLER_0_42_141 VGND VGND VPWR VPWR sky130_fd_sc_hd__decap_8
X_1998_ _1049_ _1053_ VGND VGND VPWR VPWR _1082_ sky130_fd_sc_hd__xor2_4
XFILLER_0_15_355 VGND VGND VPWR VPWR sky130_fd_sc_hd__fill_1
XFILLER_0_65_233 VPWR VGND VPWR VGND sky130_ef_sc_hd__decap_12
XFILLER_0_65_277 VGND VGND VPWR VPWR sky130_fd_sc_hd__decap_3
XFILLER_0_33_152 VPWR VGND VPWR VGND sky130_ef_sc_hd__decap_12
XTAP_TAPCELL_ROW_13_239 VGND VPWR sky130_fd_sc_hd__tapvpwrvgnd_1
XTAP_TAPCELL_ROW_21_294 VGND VPWR sky130_fd_sc_hd__tapvpwrvgnd_1
XFILLER_0_21_347 VGND VGND VPWR VPWR sky130_fd_sc_hd__fill_2
XTAP_TAPCELL_ROW_29_350 VGND VPWR sky130_fd_sc_hd__tapvpwrvgnd_1
X_2970_ _0305_ _0311_ net66 VGND VGND VPWR VPWR _0589_ sky130_fd_sc_hd__mux2_1
XFILLER_0_29_403 VGND VGND VPWR VPWR sky130_fd_sc_hd__decap_8
XPHY_EDGE_ROW_28_Left_98 VGND VGND VPWR VPWR sky130_fd_sc_hd__decap_3
X_1852_ _0834_ _0920_ VGND VGND VPWR VPWR _0936_ sky130_fd_sc_hd__xnor2_2
X_1921_ _0952_ _0941_ VGND VGND VPWR VPWR _1005_ sky130_fd_sc_hd__nor2_1
XFILLER_0_24_141 VPWR VGND VPWR VGND sky130_ef_sc_hd__decap_12
XFILLER_0_24_130 VGND VGND VPWR VPWR sky130_fd_sc_hd__decap_8
X_1783_ _0806_ _0735_ _0763_ VGND VGND VPWR VPWR _0867_ sky130_fd_sc_hd__and3_1
XFILLER_0_12_303 VGND VGND VPWR VPWR sky130_fd_sc_hd__fill_1
XFILLER_0_21_64 VGND VGND VPWR VPWR sky130_fd_sc_hd__decap_8
X_2404_ _1490_ _1491_ VGND VGND VPWR VPWR _1492_ sky130_fd_sc_hd__nand2_1
X_2266_ _1107_ _1343_ _1349_ _1102_ VGND VGND VPWR VPWR _1350_ sky130_fd_sc_hd__a211o_1
X_2335_ _1324_ _1325_ VGND VGND VPWR VPWR _1419_ sky130_fd_sc_hd__nand2_1
XFILLER_0_46_83 VGND VGND VPWR VPWR sky130_fd_sc_hd__fill_1
X_2197_ _1207_ _1280_ _1196_ VGND VGND VPWR VPWR _1281_ sky130_fd_sc_hd__a21o_1
XFILLER_0_47_288 VGND VGND VPWR VPWR sky130_fd_sc_hd__decap_3
XFILLER_0_47_233 VPWR VGND VPWR VGND sky130_ef_sc_hd__decap_12
XTAP_TAPCELL_ROW_35_397 VGND VPWR sky130_fd_sc_hd__tapvpwrvgnd_1
XFILLER_0_7_385 VGND VGND VPWR VPWR sky130_fd_sc_hd__decap_6
XFILLER_0_15_152 VPWR VGND VPWR VGND sky130_ef_sc_hd__decap_12
XFILLER_0_30_111 VGND VGND VPWR VPWR sky130_fd_sc_hd__fill_1
XFILLER_0_30_100 VGND VGND VPWR VPWR sky130_fd_sc_hd__decap_3
XFILLER_0_11_391 VGND VGND VPWR VPWR sky130_fd_sc_hd__fill_1
Xhold32 net23 VGND VGND VPWR VPWR net87 sky130_fd_sc_hd__dlygate4sd3_1
XTAP_TAPCELL_ROW_26_331 VGND VPWR sky130_fd_sc_hd__tapvpwrvgnd_1
XFILLER_0_53_247 VGND VGND VPWR VPWR sky130_fd_sc_hd__decap_8
XFILLER_0_41_409 VGND VGND VPWR VPWR sky130_fd_sc_hd__fill_2
XFILLER_0_21_155 VGND VGND VPWR VPWR sky130_fd_sc_hd__decap_3
XFILLER_0_67_27 VPWR VGND VPWR VGND sky130_ef_sc_hd__decap_12
X_2120_ net25 _1203_ _1092_ VGND VGND VPWR VPWR _1204_ sky130_fd_sc_hd__mux2_2
Xrebuffer19 _0047_ VGND VGND VPWR VPWR net74 sky130_fd_sc_hd__dlygate4sd1_1
X_2051_ _0935_ _1115_ VGND VGND VPWR VPWR _1135_ sky130_fd_sc_hd__nand2_1
X_2953_ _0376_ _0538_ _0572_ _0315_ VGND VGND VPWR VPWR _0573_ sky130_fd_sc_hd__a211o_1
XFILLER_0_32_41 VGND VGND VPWR VPWR sky130_fd_sc_hd__decap_8
X_2884_ _0426_ VGND VGND VPWR VPWR _0505_ sky130_fd_sc_hd__buf_8
X_1904_ _0983_ _0987_ VGND VGND VPWR VPWR _0988_ sky130_fd_sc_hd__nor2_1
X_1835_ _0846_ _0845_ VGND VGND VPWR VPWR _0919_ sky130_fd_sc_hd__and2b_1
XFILLER_0_4_333 VPWR VGND VPWR VGND sky130_ef_sc_hd__decap_12
XFILLER_0_4_377 VPWR VGND VPWR VGND sky130_ef_sc_hd__decap_12
X_1697_ _0735_ _0769_ _0744_ _0743_ VGND VGND VPWR VPWR _0781_ sky130_fd_sc_hd__a31o_4
XFILLER_0_12_100 VGND VGND VPWR VPWR sky130_fd_sc_hd__decap_8
X_1766_ _0627_ _0636_ VGND VGND VPWR VPWR _0850_ sky130_fd_sc_hd__xor2_1
X_2318_ _1392_ _1400_ _1401_ VGND VGND VPWR VPWR _1402_ sky130_fd_sc_hd__nand3b_1
X_2249_ _1331_ _1332_ _1271_ VGND VGND VPWR VPWR _1333_ sky130_fd_sc_hd__a21o_1
XFILLER_0_67_317 VGND VGND VPWR VPWR sky130_fd_sc_hd__fill_1
XTAP_TAPCELL_ROW_23_312 VGND VPWR sky130_fd_sc_hd__tapvpwrvgnd_1
XFILLER_0_35_225 VPWR VGND VPWR VGND sky130_ef_sc_hd__decap_12
XFILLER_0_7_182 VPWR VGND VPWR VGND sky130_ef_sc_hd__decap_12
Xoutput44 net44 VGND VGND VPWR VPWR io_accOut[2] sky130_fd_sc_hd__clkbuf_4
Xoutput33 net33 VGND VGND VPWR VPWR io_accOut[1] sky130_fd_sc_hd__clkbuf_4
Xoutput22 net22 VGND VGND VPWR VPWR io_accOut[0] sky130_fd_sc_hd__buf_2
XFILLER_0_9_3 VGND VGND VPWR VPWR sky130_fd_sc_hd__fill_2
XFILLER_0_58_317 VGND VGND VPWR VPWR sky130_fd_sc_hd__decap_3
XFILLER_0_14_409 VGND VGND VPWR VPWR sky130_fd_sc_hd__fill_2
X_1551_ net7 VGND VGND VPWR VPWR _0045_ sky130_fd_sc_hd__inv_2
X_1620_ _0460_ _0480_ VGND VGND VPWR VPWR _0704_ sky130_fd_sc_hd__or2_1
X_2103_ _1078_ VGND VGND VPWR VPWR _1187_ sky130_fd_sc_hd__clkbuf_4
X_3083_ clknet_2_3__leaf_clock _0000_ VGND VGND VPWR VPWR accumulator.state\[0\] sky130_fd_sc_hd__dfxtp_1
XFILLER_0_27_30 VPWR VGND VPWR VGND sky130_ef_sc_hd__decap_12
XFILLER_0_64_309 VPWR VGND VPWR VGND sky130_ef_sc_hd__decap_12
XFILLER_0_49_317 VPWR VGND VPWR VGND sky130_ef_sc_hd__decap_12
XFILLER_0_43_51 VGND VGND VPWR VPWR sky130_fd_sc_hd__decap_4
XFILLER_0_17_203 VPWR VGND VPWR VGND sky130_ef_sc_hd__decap_12
X_2034_ _1116_ _1117_ _0993_ VGND VGND VPWR VPWR _1118_ sky130_fd_sc_hd__mux2_1
X_2798_ _0416_ _0319_ _0323_ VGND VGND VPWR VPWR _0417_ sky130_fd_sc_hd__a21o_1
X_2867_ _0374_ _0444_ _0487_ VGND VGND VPWR VPWR _0488_ sky130_fd_sc_hd__a21oi_2
X_2936_ _0376_ _0449_ _0554_ _0555_ VGND VGND VPWR VPWR _0556_ sky130_fd_sc_hd__o31ai_1
XFILLER_0_4_163 VGND VGND VPWR VPWR sky130_fd_sc_hd__decap_8
XFILLER_0_4_141 VGND VGND VPWR VPWR sky130_fd_sc_hd__decap_6
X_1818_ _0899_ _0900_ VGND VGND VPWR VPWR _0902_ sky130_fd_sc_hd__or2_1
XFILLER_0_17_225 VPWR VGND VPWR VGND sky130_ef_sc_hd__decap_12
X_1749_ _0830_ _0831_ VGND VGND VPWR VPWR _0833_ sky130_fd_sc_hd__nor2_1
XPHY_EDGE_ROW_15_Left_85 VGND VGND VPWR VPWR sky130_fd_sc_hd__decap_3
XFILLER_0_67_169 VGND VGND VPWR VPWR sky130_fd_sc_hd__fill_2
XFILLER_0_48_29 VGND VGND VPWR VPWR sky130_fd_sc_hd__decap_8
XTAP_TAPCELL_ROW_59_562 VGND VPWR sky130_fd_sc_hd__tapvpwrvgnd_1
XFILLER_0_58_158 VGND VGND VPWR VPWR sky130_fd_sc_hd__decap_4
XFILLER_0_58_114 VPWR VGND VPWR VGND sky130_ef_sc_hd__decap_12
XFILLER_0_46_309 VPWR VGND VPWR VGND sky130_ef_sc_hd__decap_12
XFILLER_0_39_361 VPWR VGND VPWR VGND sky130_ef_sc_hd__decap_12
XFILLER_0_66_180 VGND VGND VPWR VPWR sky130_fd_sc_hd__fill_2
X_2652_ _0250_ _0256_ VGND VGND VPWR VPWR _0257_ sky130_fd_sc_hd__and2_1
XFILLER_0_54_331 VGND VGND VPWR VPWR sky130_fd_sc_hd__decap_4
X_2721_ _0330_ _0332_ net64 VGND VGND VPWR VPWR _0333_ sky130_fd_sc_hd__a21oi_1
XFILLER_0_13_54 VGND VGND VPWR VPWR sky130_fd_sc_hd__fill_2
XFILLER_0_14_206 VGND VGND VPWR VPWR sky130_fd_sc_hd__fill_2
X_2583_ _0180_ VGND VGND VPWR VPWR _0181_ sky130_fd_sc_hd__buf_2
XFILLER_0_22_294 VGND VGND VPWR VPWR sky130_fd_sc_hd__fill_1
XFILLER_0_1_199 VGND VGND VPWR VPWR sky130_fd_sc_hd__fill_2
XFILLER_0_10_401 VPWR VGND VPWR VGND sky130_ef_sc_hd__decap_12
X_1603_ _0588_ _0419_ VGND VGND VPWR VPWR _0598_ sky130_fd_sc_hd__xor2_2
XFILLER_0_54_83 VGND VGND VPWR VPWR sky130_fd_sc_hd__fill_1
X_2017_ _1080_ _1100_ VGND VGND VPWR VPWR _1101_ sky130_fd_sc_hd__xor2_4
X_3066_ _0680_ _0682_ VGND VGND VPWR VPWR _0683_ sky130_fd_sc_hd__nand2_1
XFILLER_0_64_139 VGND VGND VPWR VPWR sky130_fd_sc_hd__fill_1
XFILLER_0_49_158 VGND VGND VPWR VPWR sky130_fd_sc_hd__fill_1
X_2919_ _0508_ _0538_ _0509_ VGND VGND VPWR VPWR _0539_ sky130_fd_sc_hd__mux2_1
XFILLER_0_9_233 VGND VGND VPWR VPWR sky130_fd_sc_hd__fill_1
XFILLER_0_9_277 VGND VGND VPWR VPWR sky130_fd_sc_hd__decap_3
XFILLER_0_60_323 VGND VGND VPWR VPWR sky130_fd_sc_hd__fill_2
XFILLER_0_13_272 VGND VGND VPWR VPWR sky130_fd_sc_hd__decap_8
XTAP_TAPCELL_ROW_5_187 VGND VPWR sky130_fd_sc_hd__tapvpwrvgnd_1
XFILLER_0_68_401 VPWR VGND VPWR VGND sky130_ef_sc_hd__decap_12
XTAP_TAPCELL_ROW_56_543 VGND VPWR sky130_fd_sc_hd__tapvpwrvgnd_1
XFILLER_0_28_309 VPWR VGND VPWR VGND sky130_ef_sc_hd__decap_12
XFILLER_0_36_386 VGND VGND VPWR VPWR sky130_fd_sc_hd__fill_1
XFILLER_0_36_375 VGND VGND VPWR VPWR sky130_fd_sc_hd__decap_3
XFILLER_0_59_39 VPWR VGND VPWR VGND sky130_ef_sc_hd__decap_12
XFILLER_0_39_180 VGND VGND VPWR VPWR sky130_fd_sc_hd__decap_3
XFILLER_0_24_97 VGND VGND VPWR VPWR sky130_fd_sc_hd__decap_6
X_2635_ _0190_ _0193_ _0197_ _0237_ VGND VGND VPWR VPWR _0238_ sky130_fd_sc_hd__and4bb_1
XFILLER_0_40_85 VGND VGND VPWR VPWR sky130_fd_sc_hd__fill_2
X_2704_ _1465_ _0313_ VGND VGND VPWR VPWR _0314_ sky130_fd_sc_hd__or2_1
X_2497_ _1531_ _0085_ _1532_ VGND VGND VPWR VPWR _0086_ sky130_fd_sc_hd__o21a_1
XFILLER_0_49_61 VGND VGND VPWR VPWR sky130_fd_sc_hd__fill_1
X_2566_ _0148_ _0161_ _0136_ VGND VGND VPWR VPWR _0162_ sky130_fd_sc_hd__o21a_1
XFILLER_0_4_85 VPWR VGND VPWR VGND sky130_ef_sc_hd__decap_12
XFILLER_0_10_253 VGND VGND VPWR VPWR sky130_fd_sc_hd__decap_4
XFILLER_0_69_209 VPWR VGND VPWR VGND sky130_ef_sc_hd__decap_12
XTAP_TAPCELL_ROW_53_524 VGND VPWR sky130_fd_sc_hd__tapvpwrvgnd_1
X_3049_ _0664_ _0665_ VGND VGND VPWR VPWR _0666_ sky130_fd_sc_hd__nand2_1
XPHY_EDGE_ROW_36_Left_106 VGND VGND VPWR VPWR sky130_fd_sc_hd__decap_3
XFILLER_0_33_323 VPWR VGND VPWR VGND sky130_ef_sc_hd__decap_12
XFILLER_0_60_197 VGND VGND VPWR VPWR sky130_fd_sc_hd__decap_3
XFILLER_0_60_186 VGND VGND VPWR VPWR sky130_fd_sc_hd__decap_4
XPHY_EDGE_ROW_45_Left_115 VGND VGND VPWR VPWR sky130_fd_sc_hd__decap_3
XFILLER_0_68_253 VPWR VGND VPWR VGND sky130_ef_sc_hd__decap_12
XPHY_EDGE_ROW_54_Left_124 VGND VGND VPWR VPWR sky130_fd_sc_hd__decap_3
XTAP_TAPCELL_ROW_16_259 VGND VPWR sky130_fd_sc_hd__tapvpwrvgnd_1
X_2420_ _1270_ _1358_ _1508_ _1192_ VGND VGND VPWR VPWR _1510_ sky130_fd_sc_hd__o211a_1
XFILLER_0_51_186 VPWR VGND VPWR VGND sky130_ef_sc_hd__decap_12
XFILLER_0_10_77 VGND VGND VPWR VPWR sky130_fd_sc_hd__decap_6
XTAP_TAPCELL_ROW_67_616 VGND VPWR sky130_fd_sc_hd__tapvpwrvgnd_1
XPHY_EDGE_ROW_63_Left_133 VGND VGND VPWR VPWR sky130_fd_sc_hd__decap_3
X_2351_ _1347_ _1434_ _1271_ VGND VGND VPWR VPWR _1435_ sky130_fd_sc_hd__mux2_1
X_2282_ _1109_ _1364_ _1365_ VGND VGND VPWR VPWR _1366_ sky130_fd_sc_hd__o21ai_1
XFILLER_0_35_96 VPWR VGND VPWR VGND sky130_ef_sc_hd__decap_12
XFILLER_0_51_51 VGND VGND VPWR VPWR sky130_fd_sc_hd__decap_4
X_1997_ _1048_ _1047_ VGND VGND VPWR VPWR _1081_ sky130_fd_sc_hd__or2b_2
XFILLER_0_27_194 VGND VGND VPWR VPWR sky130_fd_sc_hd__decap_4
X_2618_ _0217_ _0218_ VGND VGND VPWR VPWR _0219_ sky130_fd_sc_hd__nand2_1
XFILLER_0_42_197 VGND VGND VPWR VPWR sky130_fd_sc_hd__decap_6
X_2549_ _0140_ _0141_ VGND VGND VPWR VPWR _0143_ sky130_fd_sc_hd__nand2_1
XFILLER_0_30_359 VGND VGND VPWR VPWR sky130_fd_sc_hd__decap_4
XFILLER_0_65_223 VGND VGND VPWR VPWR sky130_fd_sc_hd__fill_1
XFILLER_0_33_164 VGND VGND VPWR VPWR sky130_fd_sc_hd__decap_4
XFILLER_0_21_337 VGND VGND VPWR VPWR sky130_fd_sc_hd__fill_1
XFILLER_0_0_209 VGND VGND VPWR VPWR sky130_fd_sc_hd__decap_6
XFILLER_0_18_183 VPWR VGND VPWR VGND sky130_ef_sc_hd__decap_12
XTAP_TAPCELL_ROW_21_295 VGND VPWR sky130_fd_sc_hd__tapvpwrvgnd_1
XFILLER_0_56_29 VPWR VGND VPWR VGND sky130_ef_sc_hd__decap_12
XPHY_EDGE_ROW_3_Left_73 VGND VGND VPWR VPWR sky130_fd_sc_hd__decap_3
XTAP_TAPCELL_ROW_29_351 VGND VPWR sky130_fd_sc_hd__tapvpwrvgnd_1
XFILLER_0_56_234 VPWR VGND VPWR VGND sky130_ef_sc_hd__decap_12
XFILLER_0_56_212 VGND VGND VPWR VPWR sky130_fd_sc_hd__decap_6
XFILLER_0_8_309 VPWR VGND VPWR VGND sky130_ef_sc_hd__decap_12
X_1851_ _0805_ _0934_ VGND VGND VPWR VPWR _0935_ sky130_fd_sc_hd__xnor2_1
X_1920_ _0972_ _0973_ _0943_ VGND VGND VPWR VPWR _1004_ sky130_fd_sc_hd__and3b_1
X_2403_ net24 _1279_ _1078_ VGND VGND VPWR VPWR _1491_ sky130_fd_sc_hd__mux2_1
XFILLER_0_24_153 VGND VGND VPWR VPWR sky130_fd_sc_hd__decap_8
X_1782_ _0823_ _0865_ _0763_ VGND VGND VPWR VPWR _0866_ sky130_fd_sc_hd__and3b_1
X_2334_ _1097_ _1413_ _1415_ _1294_ _1417_ VGND VGND VPWR VPWR _1418_ sky130_fd_sc_hd__o32ai_4
X_2265_ _1222_ _1345_ _1348_ _1248_ VGND VGND VPWR VPWR _1349_ sky130_fd_sc_hd__o211a_1
X_2196_ net24 _1279_ _1091_ VGND VGND VPWR VPWR _1280_ sky130_fd_sc_hd__mux2_4
XFILLER_0_62_83 VGND VGND VPWR VPWR sky130_fd_sc_hd__fill_1
XFILLER_0_47_245 VGND VGND VPWR VPWR sky130_fd_sc_hd__fill_1
XTAP_TAPCELL_ROW_35_398 VGND VPWR sky130_fd_sc_hd__tapvpwrvgnd_1
XFILLER_0_7_331 VGND VGND VPWR VPWR sky130_fd_sc_hd__decap_4
XFILLER_0_15_120 VGND VGND VPWR VPWR sky130_fd_sc_hd__decap_8
XFILLER_0_15_131 VGND VGND VPWR VPWR sky130_fd_sc_hd__decap_3
XFILLER_0_15_164 VGND VGND VPWR VPWR sky130_fd_sc_hd__decap_4
Xhold33 accumulator.state\[0\] VGND VGND VPWR VPWR net88 sky130_fd_sc_hd__dlygate4sd3_1
XFILLER_0_53_204 VPWR VGND VPWR VGND sky130_ef_sc_hd__decap_12
XFILLER_0_38_267 VPWR VGND VPWR VGND sky130_ef_sc_hd__decap_12
XFILLER_0_38_256 VGND VGND VPWR VPWR sky130_fd_sc_hd__decap_4
XTAP_TAPCELL_ROW_26_332 VGND VPWR sky130_fd_sc_hd__tapvpwrvgnd_1
XFILLER_0_67_39 VPWR VGND VPWR VGND sky130_ef_sc_hd__decap_12
XFILLER_0_61_281 VPWR VGND VPWR VGND sky130_ef_sc_hd__decap_12
XFILLER_0_21_167 VGND VGND VPWR VPWR sky130_fd_sc_hd__fill_1
X_2050_ _1128_ _1133_ VGND VGND VPWR VPWR _1134_ sky130_fd_sc_hd__nand2_1
X_2952_ _0376_ _0571_ VGND VGND VPWR VPWR _0572_ sky130_fd_sc_hd__nor2_1
XFILLER_0_29_223 VGND VGND VPWR VPWR sky130_fd_sc_hd__fill_1
XFILLER_0_16_65 VPWR VGND VPWR VGND sky130_ef_sc_hd__decap_12
X_2883_ _0503_ VGND VGND VPWR VPWR _0504_ sky130_fd_sc_hd__buf_2
X_1903_ _1530_ _0986_ VGND VGND VPWR VPWR _0987_ sky130_fd_sc_hd__xnor2_1
XFILLER_0_4_345 VPWR VGND VPWR VGND sky130_ef_sc_hd__decap_12
X_1834_ _0861_ _0916_ _0917_ VGND VGND VPWR VPWR _0918_ sky130_fd_sc_hd__a21o_1
XFILLER_0_8_139 VGND VGND VPWR VPWR sky130_fd_sc_hd__fill_1
XFILLER_0_12_112 VPWR VGND VPWR VGND sky130_ef_sc_hd__decap_12
X_1765_ _0677_ _0696_ VGND VGND VPWR VPWR _0849_ sky130_fd_sc_hd__or2_1
XFILLER_0_4_389 VPWR VGND VPWR VGND sky130_ef_sc_hd__decap_12
X_1696_ _0758_ _0779_ VGND VGND VPWR VPWR _0780_ sky130_fd_sc_hd__nand2_1
X_2179_ _1192_ _1262_ VGND VGND VPWR VPWR _1263_ sky130_fd_sc_hd__nand2_2
XFILLER_0_57_94 VPWR VGND VPWR VGND sky130_ef_sc_hd__decap_12
X_2317_ _1260_ _1361_ _1101_ _1294_ _1266_ VGND VGND VPWR VPWR _1401_ sky130_fd_sc_hd__a2111o_1
X_2248_ _1207_ _1215_ _1219_ VGND VGND VPWR VPWR _1332_ sky130_fd_sc_hd__a21o_1
XFILLER_0_32_3 VPWR VGND VPWR VGND sky130_ef_sc_hd__decap_12
XFILLER_0_35_237 VPWR VGND VPWR VGND sky130_ef_sc_hd__decap_12
XTAP_TAPCELL_ROW_23_313 VGND VPWR sky130_fd_sc_hd__tapvpwrvgnd_1
Xoutput23 net23 VGND VGND VPWR VPWR io_accOut[10] sky130_fd_sc_hd__buf_2
Xoutput34 net34 VGND VGND VPWR VPWR io_accOut[20] sky130_fd_sc_hd__buf_2
XFILLER_0_43_281 VGND VGND VPWR VPWR sky130_fd_sc_hd__decap_8
XFILLER_0_7_194 VGND VGND VPWR VPWR sky130_fd_sc_hd__decap_8
Xoutput45 net45 VGND VGND VPWR VPWR io_accOut[30] sky130_fd_sc_hd__buf_2
XFILLER_0_22_410 VGND VGND VPWR VPWR sky130_fd_sc_hd__fill_1
X_1550_ net6 net2 net3 net7 VGND VGND VPWR VPWR _0034_ sky130_fd_sc_hd__and4bb_1
XFILLER_0_1_337 VPWR VGND VPWR VGND sky130_ef_sc_hd__decap_12
X_2102_ _1099_ _1103_ _1185_ VGND VGND VPWR VPWR _1186_ sky130_fd_sc_hd__or3_2
X_3082_ _0501_ _1322_ _0134_ _0482_ _0697_ VGND VGND VPWR VPWR _0033_ sky130_fd_sc_hd__o311a_1
XFILLER_0_27_42 VPWR VGND VPWR VGND sky130_ef_sc_hd__decap_12
X_2033_ _0949_ _0941_ _1044_ VGND VGND VPWR VPWR _1117_ sky130_fd_sc_hd__mux2_1
XFILLER_0_49_329 VGND VGND VPWR VPWR sky130_fd_sc_hd__decap_6
X_2935_ net26 _1487_ VGND VGND VPWR VPWR _0555_ sky130_fd_sc_hd__nand2_1
XFILLER_0_17_215 VGND VGND VPWR VPWR sky130_fd_sc_hd__decap_8
XFILLER_0_17_237 VPWR VGND VPWR VGND sky130_ef_sc_hd__decap_12
X_2797_ _0415_ _0403_ _0363_ VGND VGND VPWR VPWR _0416_ sky130_fd_sc_hd__a21o_1
X_2866_ _0486_ _0373_ VGND VGND VPWR VPWR _0487_ sky130_fd_sc_hd__nor2_4
XFILLER_0_25_281 VPWR VGND VPWR VGND sky130_ef_sc_hd__decap_12
X_1748_ _0830_ _0831_ VGND VGND VPWR VPWR _0832_ sky130_fd_sc_hd__and2_4
XFILLER_0_4_197 VPWR VGND VPWR VGND sky130_ef_sc_hd__decap_12
X_1817_ _0899_ _0900_ VGND VGND VPWR VPWR _0901_ sky130_fd_sc_hd__nand2_1
X_1679_ net1 net5 VGND VGND VPWR VPWR _0763_ sky130_fd_sc_hd__and2_1
XFILLER_0_31_251 VPWR VGND VPWR VGND sky130_ef_sc_hd__decap_12
XFILLER_0_64_29 VPWR VGND VPWR VGND sky130_ef_sc_hd__decap_12
XTAP_TAPCELL_ROW_59_563 VGND VPWR sky130_fd_sc_hd__tapvpwrvgnd_1
XFILLER_0_58_126 VPWR VGND VPWR VGND sky130_ef_sc_hd__decap_12
XFILLER_0_58_104 VGND VGND VPWR VPWR sky130_fd_sc_hd__decap_6
XTAP_TAPCELL_ROW_42_441 VGND VPWR sky130_fd_sc_hd__tapvpwrvgnd_1
XFILLER_0_39_373 VGND VGND VPWR VPWR sky130_fd_sc_hd__decap_4
X_2651_ _0251_ _0255_ VGND VGND VPWR VPWR _0256_ sky130_fd_sc_hd__xnor2_2
X_2720_ _1403_ _1404_ VGND VGND VPWR VPWR _0332_ sky130_fd_sc_hd__nand2_1
X_2582_ net46 _0134_ VGND VGND VPWR VPWR _0180_ sky130_fd_sc_hd__xor2_4
XFILLER_0_22_240 VPWR VGND VPWR VGND sky130_ef_sc_hd__decap_12
XFILLER_0_13_77 VGND VGND VPWR VPWR sky130_fd_sc_hd__fill_2
X_1602_ _0430_ _0579_ VGND VGND VPWR VPWR _0588_ sky130_fd_sc_hd__xnor2_2
XFILLER_0_38_52 VPWR VGND VPWR VGND sky130_ef_sc_hd__decap_12
XFILLER_0_38_41 VGND VGND VPWR VPWR sky130_fd_sc_hd__decap_6
XFILLER_0_1_167 VGND VGND VPWR VPWR sky130_fd_sc_hd__fill_1
XFILLER_0_10_413 VGND VGND VPWR VPWR sky130_fd_sc_hd__fill_2
XFILLER_0_49_104 VGND VGND VPWR VPWR sky130_fd_sc_hd__decap_8
Xclkbuf_0_clock clock VGND VGND VPWR VPWR clknet_0_clock sky130_fd_sc_hd__clkbuf_16
X_2016_ _1093_ net55 VGND VGND VPWR VPWR _1100_ sky130_fd_sc_hd__nor2_2
X_3065_ _0679_ _0681_ VGND VGND VPWR VPWR _0682_ sky130_fd_sc_hd__xor2_1
XFILLER_0_64_107 VGND VGND VPWR VPWR sky130_fd_sc_hd__decap_8
X_2918_ _0401_ _0536_ _0537_ VGND VGND VPWR VPWR _0538_ sky130_fd_sc_hd__o21bai_1
XFILLER_0_9_201 VPWR VGND VPWR VGND sky130_ef_sc_hd__decap_12
X_2849_ _1465_ _0468_ VGND VGND VPWR VPWR _0469_ sky130_fd_sc_hd__or2_1
XTAP_TAPCELL_ROW_5_188 VGND VPWR sky130_fd_sc_hd__tapvpwrvgnd_1
XFILLER_0_68_413 VGND VGND VPWR VPWR sky130_fd_sc_hd__fill_2
XTAP_TAPCELL_ROW_56_544 VGND VPWR sky130_fd_sc_hd__tapvpwrvgnd_1
XFILLER_0_36_321 VPWR VGND VPWR VGND sky130_ef_sc_hd__decap_12
XFILLER_0_63_162 VGND VGND VPWR VPWR sky130_fd_sc_hd__decap_6
XFILLER_0_51_302 VGND VGND VPWR VPWR sky130_fd_sc_hd__decap_8
XFILLER_0_59_413 VGND VGND VPWR VPWR sky130_fd_sc_hd__fill_2
XFILLER_0_39_192 VPWR VGND VPWR VGND sky130_ef_sc_hd__decap_12
XFILLER_0_27_321 VGND VGND VPWR VPWR sky130_fd_sc_hd__decap_4
XFILLER_0_6_226 VGND VGND VPWR VPWR sky130_fd_sc_hd__fill_1
X_2634_ _0227_ _0233_ _0236_ VGND VGND VPWR VPWR _0237_ sky130_fd_sc_hd__and3_1
XFILLER_0_49_51 VGND VGND VPWR VPWR sky130_fd_sc_hd__decap_4
X_2703_ _0300_ _0312_ VGND VGND VPWR VPWR _0313_ sky130_fd_sc_hd__nor2_1
XFILLER_0_42_324 VGND VGND VPWR VPWR sky130_fd_sc_hd__decap_6
X_2565_ _0150_ _0140_ _0141_ VGND VGND VPWR VPWR _0161_ sky130_fd_sc_hd__nor3b_1
X_2496_ _1099_ _1417_ _0040_ VGND VGND VPWR VPWR _0085_ sky130_fd_sc_hd__or3b_1
XFILLER_0_4_97 VPWR VGND VPWR VGND sky130_ef_sc_hd__decap_12
XFILLER_0_65_405 VGND VGND VPWR VPWR sky130_fd_sc_hd__decap_8
X_3048_ _0663_ _0468_ VGND VGND VPWR VPWR _0665_ sky130_fd_sc_hd__or2b_1
XTAP_TAPCELL_ROW_61_580 VGND VPWR sky130_fd_sc_hd__tapvpwrvgnd_1
XFILLER_0_45_173 VGND VGND VPWR VPWR sky130_fd_sc_hd__decap_6
XFILLER_0_33_335 VGND VGND VPWR VPWR sky130_fd_sc_hd__fill_1
XFILLER_0_5_281 VPWR VGND VPWR VGND sky130_ef_sc_hd__decap_12
XFILLER_0_68_265 VGND VGND VPWR VPWR sky130_fd_sc_hd__decap_8
XFILLER_0_51_198 VPWR VGND VPWR VGND sky130_ef_sc_hd__decap_12
XFILLER_0_10_23 VGND VGND VPWR VPWR sky130_fd_sc_hd__decap_4
XTAP_TAPCELL_ROW_67_617 VGND VPWR sky130_fd_sc_hd__tapvpwrvgnd_1
X_2350_ _1323_ _1364_ _1382_ VGND VGND VPWR VPWR _1434_ sky130_fd_sc_hd__o21a_1
X_2281_ net49 net56 _1112_ _1170_ VGND VGND VPWR VPWR _1365_ sky130_fd_sc_hd__a31o_1
XFILLER_0_19_54 VGND VGND VPWR VPWR sky130_fd_sc_hd__fill_2
XFILLER_0_59_210 VPWR VGND VPWR VGND sky130_ef_sc_hd__decap_12
XFILLER_0_35_75 VGND VGND VPWR VPWR sky130_fd_sc_hd__fill_1
XFILLER_0_19_107 VGND VGND VPWR VPWR sky130_fd_sc_hd__fill_2
XFILLER_0_51_85 VGND VGND VPWR VPWR sky130_fd_sc_hd__fill_1
XFILLER_0_27_162 VGND VGND VPWR VPWR sky130_fd_sc_hd__decap_6
X_1996_ _1055_ _1079_ VGND VGND VPWR VPWR _1080_ sky130_fd_sc_hd__xor2_4
XFILLER_0_15_335 VGND VGND VPWR VPWR sky130_fd_sc_hd__fill_1
XFILLER_0_62_3 VPWR VGND VPWR VGND sky130_ef_sc_hd__decap_12
X_2617_ _1456_ _0090_ _0097_ _0098_ _0180_ VGND VGND VPWR VPWR _0218_ sky130_fd_sc_hd__a311o_1
XFILLER_0_42_165 VPWR VGND VPWR VGND sky130_ef_sc_hd__decap_12
X_2548_ _0140_ _0141_ VGND VGND VPWR VPWR _0142_ sky130_fd_sc_hd__nor2_1
X_2479_ _1192_ _1388_ _0065_ VGND VGND VPWR VPWR _0066_ sky130_fd_sc_hd__and3_1
XFILLER_0_65_257 VPWR VGND VPWR VGND sky130_ef_sc_hd__decap_12
Xclkload0 clknet_2_0__leaf_clock VGND VGND VPWR VPWR clkload0/Y sky130_fd_sc_hd__clkinvlp_2
XFILLER_0_21_316 VGND VGND VPWR VPWR sky130_fd_sc_hd__fill_1
XFILLER_0_18_195 VGND VGND VPWR VPWR sky130_fd_sc_hd__fill_1
XTAP_TAPCELL_ROW_21_296 VGND VPWR sky130_fd_sc_hd__tapvpwrvgnd_1
XTAP_TAPCELL_ROW_29_352 VGND VPWR sky130_fd_sc_hd__tapvpwrvgnd_1
XFILLER_0_56_246 VGND VGND VPWR VPWR sky130_fd_sc_hd__decap_6
XFILLER_0_24_110 VGND VGND VPWR VPWR sky130_fd_sc_hd__decap_3
X_1850_ _0817_ _0924_ VGND VGND VPWR VPWR _0934_ sky130_fd_sc_hd__nor2_1
X_1781_ _0767_ _0864_ VGND VGND VPWR VPWR _0865_ sky130_fd_sc_hd__nor2_1
XFILLER_0_21_55 VGND VGND VPWR VPWR sky130_fd_sc_hd__fill_1
X_2402_ _1270_ _1447_ _1489_ _1192_ VGND VGND VPWR VPWR _1490_ sky130_fd_sc_hd__o211a_1
X_2333_ _1101_ _1300_ _1303_ _1416_ VGND VGND VPWR VPWR _1417_ sky130_fd_sc_hd__o31a_2
XFILLER_0_20_360 VGND VGND VPWR VPWR sky130_fd_sc_hd__fill_1
XFILLER_0_46_74 VGND VGND VPWR VPWR sky130_fd_sc_hd__fill_1
XFILLER_0_46_41 VGND VGND VPWR VPWR sky130_fd_sc_hd__decap_8
X_2264_ _1173_ _1347_ VGND VGND VPWR VPWR _1348_ sky130_fd_sc_hd__or2_1
X_2195_ net81 _1234_ VGND VGND VPWR VPWR _1279_ sky130_fd_sc_hd__nor2_1
XFILLER_0_27_6 VPWR VGND VPWR VGND sky130_ef_sc_hd__decap_12
XFILLER_0_1_98 VPWR VGND VPWR VGND sky130_ef_sc_hd__decap_12
XFILLER_0_62_238 VGND VGND VPWR VPWR sky130_fd_sc_hd__decap_3
XFILLER_0_62_216 VGND VGND VPWR VPWR sky130_fd_sc_hd__decap_8
X_1979_ _1041_ _1062_ VGND VGND VPWR VPWR _1063_ sky130_fd_sc_hd__nand2_1
XFILLER_0_15_110 VGND VGND VPWR VPWR sky130_fd_sc_hd__fill_2
Xhold34 net27 VGND VGND VPWR VPWR net89 sky130_fd_sc_hd__dlygate4sd3_1
XFILLER_0_11_393 VPWR VGND VPWR VGND sky130_ef_sc_hd__decap_12
XTAP_TAPCELL_ROW_26_333 VGND VPWR sky130_fd_sc_hd__tapvpwrvgnd_1
XFILLER_0_38_279 VGND VGND VPWR VPWR sky130_fd_sc_hd__decap_8
XFILLER_0_61_293 VGND VGND VPWR VPWR sky130_fd_sc_hd__decap_4
XFILLER_0_61_260 VGND VGND VPWR VPWR sky130_fd_sc_hd__fill_1
XFILLER_0_21_113 VPWR VGND VPWR VGND sky130_ef_sc_hd__decap_12
XFILLER_0_21_135 VGND VGND VPWR VPWR sky130_fd_sc_hd__fill_2
XFILLER_0_69_393 VPWR VGND VPWR VGND sky130_ef_sc_hd__decap_12
X_2951_ _0558_ _0570_ _0458_ VGND VGND VPWR VPWR _0571_ sky130_fd_sc_hd__mux2_4
XFILLER_0_29_279 VGND VGND VPWR VPWR sky130_fd_sc_hd__fill_1
X_1902_ _0984_ _0985_ VGND VGND VPWR VPWR _0986_ sky130_fd_sc_hd__or2_1
XFILLER_0_16_77 VGND VGND VPWR VPWR sky130_fd_sc_hd__decap_6
XFILLER_0_44_227 VGND VGND VPWR VPWR sky130_fd_sc_hd__fill_1
XFILLER_0_40_400 VGND VGND VPWR VPWR sky130_fd_sc_hd__decap_8
X_2882_ _0469_ _0476_ VGND VGND VPWR VPWR _0503_ sky130_fd_sc_hd__or2_1
XFILLER_0_4_357 VGND VGND VPWR VPWR sky130_fd_sc_hd__decap_6
X_1833_ _0856_ _0859_ _0860_ VGND VGND VPWR VPWR _0917_ sky130_fd_sc_hd__o21a_1
XFILLER_0_12_124 VGND VGND VPWR VPWR sky130_fd_sc_hd__fill_1
X_1764_ _0766_ VGND VGND VPWR VPWR _0848_ sky130_fd_sc_hd__inv_2
XFILLER_0_57_51 VGND VGND VPWR VPWR sky130_fd_sc_hd__decap_4
X_2316_ _1287_ _1286_ _1101_ _1097_ _1399_ VGND VGND VPWR VPWR _1400_ sky130_fd_sc_hd__a311o_1
X_1695_ _0740_ _0757_ VGND VGND VPWR VPWR _0779_ sky130_fd_sc_hd__nand2_1
X_2178_ _1251_ _1261_ _1103_ VGND VGND VPWR VPWR _1262_ sky130_fd_sc_hd__mux2_1
X_2247_ _1207_ _1231_ _1323_ VGND VGND VPWR VPWR _1331_ sky130_fd_sc_hd__a21o_1
XFILLER_0_35_249 VGND VGND VPWR VPWR sky130_fd_sc_hd__decap_6
XFILLER_0_35_205 VPWR VGND VPWR VGND sky130_ef_sc_hd__decap_12
XTAP_TAPCELL_ROW_23_314 VGND VPWR sky130_fd_sc_hd__tapvpwrvgnd_1
Xoutput35 net35 VGND VGND VPWR VPWR io_accOut[21] sky130_fd_sc_hd__buf_2
Xoutput24 net24 VGND VGND VPWR VPWR io_accOut[11] sky130_fd_sc_hd__buf_2
Xoutput46 net46 VGND VGND VPWR VPWR io_accOut[31] sky130_fd_sc_hd__buf_2
XFILLER_0_66_363 VGND VGND VPWR VPWR sky130_fd_sc_hd__fill_1
XPHY_EDGE_ROW_19_Right_19 VGND VGND VPWR VPWR sky130_fd_sc_hd__decap_3
XFILLER_0_1_305 VPWR VGND VPWR VGND sky130_ef_sc_hd__decap_12
XPHY_EDGE_ROW_28_Right_28 VGND VGND VPWR VPWR sky130_fd_sc_hd__decap_3
XFILLER_0_1_349 VPWR VGND VPWR VGND sky130_ef_sc_hd__decap_12
X_2101_ _1184_ VGND VGND VPWR VPWR _1185_ sky130_fd_sc_hd__inv_2
XPHY_EDGE_ROW_37_Right_37 VGND VGND VPWR VPWR sky130_fd_sc_hd__decap_3
XTAP_TAPCELL_ROW_37_406 VGND VPWR sky130_fd_sc_hd__tapvpwrvgnd_1
X_3081_ _0543_ _1188_ net46 VGND VGND VPWR VPWR _0697_ sky130_fd_sc_hd__a21o_1
XFILLER_0_27_54 VGND VGND VPWR VPWR sky130_fd_sc_hd__fill_2
X_2032_ _0952_ _0940_ _1115_ VGND VGND VPWR VPWR _1116_ sky130_fd_sc_hd__mux2_1
X_2865_ _0459_ _0485_ _0446_ VGND VGND VPWR VPWR _0486_ sky130_fd_sc_hd__mux2_4
XFILLER_0_43_97 VGND VGND VPWR VPWR sky130_fd_sc_hd__decap_8
X_2934_ _1465_ _0544_ VGND VGND VPWR VPWR _0554_ sky130_fd_sc_hd__or2_1
XFILLER_0_9_405 VGND VGND VPWR VPWR sky130_fd_sc_hd__decap_8
XFILLER_0_17_249 VGND VGND VPWR VPWR sky130_fd_sc_hd__decap_8
X_2796_ _0413_ _0357_ _0414_ VGND VGND VPWR VPWR _0415_ sky130_fd_sc_hd__a21o_1
XPHY_EDGE_ROW_46_Right_46 VGND VGND VPWR VPWR sky130_fd_sc_hd__decap_3
XFILLER_0_40_241 VGND VGND VPWR VPWR sky130_fd_sc_hd__decap_8
XFILLER_0_25_293 VPWR VGND VPWR VGND sky130_ef_sc_hd__decap_12
X_1678_ _0760_ _0761_ VGND VGND VPWR VPWR _0762_ sky130_fd_sc_hd__xor2_2
X_1747_ _0814_ _0813_ VGND VGND VPWR VPWR _0831_ sky130_fd_sc_hd__xnor2_1
X_1816_ _0852_ _0888_ VGND VGND VPWR VPWR _0900_ sky130_fd_sc_hd__xor2_1
XFILLER_0_68_83 VGND VGND VPWR VPWR sky130_fd_sc_hd__fill_1
XPHY_EDGE_ROW_55_Right_55 VGND VGND VPWR VPWR sky130_fd_sc_hd__decap_3
XFILLER_0_0_393 VPWR VGND VPWR VGND sky130_ef_sc_hd__decap_12
XFILLER_0_48_363 VGND VGND VPWR VPWR sky130_fd_sc_hd__fill_1
XPHY_EDGE_ROW_64_Right_64 VGND VGND VPWR VPWR sky130_fd_sc_hd__decap_3
XFILLER_0_31_263 VPWR VGND VPWR VGND sky130_ef_sc_hd__decap_12
XTAP_TAPCELL_ROW_59_564 VGND VPWR sky130_fd_sc_hd__tapvpwrvgnd_1
XFILLER_0_58_149 VGND VGND VPWR VPWR sky130_fd_sc_hd__fill_2
XFILLER_0_58_138 VGND VGND VPWR VPWR sky130_fd_sc_hd__fill_2
XTAP_TAPCELL_ROW_42_442 VGND VPWR sky130_fd_sc_hd__tapvpwrvgnd_1
X_2581_ _1533_ _0178_ VGND VGND VPWR VPWR _0179_ sky130_fd_sc_hd__xor2_2
X_2650_ _0252_ _0253_ _0181_ VGND VGND VPWR VPWR _0255_ sky130_fd_sc_hd__mux2_1
XFILLER_0_1_113 VGND VGND VPWR VPWR sky130_fd_sc_hd__decap_4
X_1601_ _0440_ _0569_ VGND VGND VPWR VPWR _0579_ sky130_fd_sc_hd__xnor2_2
XFILLER_0_38_64 VGND VGND VPWR VPWR sky130_fd_sc_hd__decap_8
X_2015_ _1098_ VGND VGND VPWR VPWR _1099_ sky130_fd_sc_hd__clkbuf_2
XFILLER_0_54_96 VPWR VGND VPWR VGND sky130_ef_sc_hd__decap_12
XFILLER_0_54_41 VPWR VGND VPWR VGND sky130_ef_sc_hd__decap_12
XFILLER_0_9_213 VGND VGND VPWR VPWR sky130_fd_sc_hd__decap_8
X_3064_ net43 _1322_ _0149_ VGND VGND VPWR VPWR _0681_ sky130_fd_sc_hd__a21oi_1
X_2917_ _0447_ _0525_ VGND VGND VPWR VPWR _0537_ sky130_fd_sc_hd__nor2_1
XFILLER_0_45_355 VGND VGND VPWR VPWR sky130_fd_sc_hd__decap_8
XFILLER_0_45_333 VGND VGND VPWR VPWR sky130_fd_sc_hd__decap_3
X_2848_ _0467_ _0313_ VGND VGND VPWR VPWR _0468_ sky130_fd_sc_hd__and2_2
X_2779_ _0367_ _0395_ _0324_ VGND VGND VPWR VPWR _0396_ sky130_fd_sc_hd__o21bai_1
XTAP_TAPCELL_ROW_56_545 VGND VPWR sky130_fd_sc_hd__tapvpwrvgnd_1
XFILLER_0_63_141 VGND VGND VPWR VPWR sky130_fd_sc_hd__fill_1
XFILLER_0_51_325 VGND VGND VPWR VPWR sky130_fd_sc_hd__decap_8
XFILLER_0_54_141 VGND VGND VPWR VPWR sky130_fd_sc_hd__decap_8
X_2702_ _0302_ _0305_ _0308_ _0311_ VGND VGND VPWR VPWR _0312_ sky130_fd_sc_hd__or4_4
XFILLER_0_46_119 VGND VGND VPWR VPWR sky130_fd_sc_hd__decap_8
XFILLER_0_27_377 VGND VGND VPWR VPWR sky130_fd_sc_hd__fill_1
XFILLER_0_27_333 VGND VGND VPWR VPWR sky130_fd_sc_hd__decap_3
XFILLER_0_27_311 VGND VGND VPWR VPWR sky130_fd_sc_hd__decap_6
XFILLER_0_27_300 VGND VGND VPWR VPWR sky130_fd_sc_hd__fill_2
X_2633_ _0105_ _0235_ VGND VGND VPWR VPWR _0236_ sky130_fd_sc_hd__xor2_2
XFILLER_0_49_74 VGND VGND VPWR VPWR sky130_fd_sc_hd__fill_1
X_2564_ _0120_ _0127_ _0129_ _0123_ _0159_ VGND VGND VPWR VPWR _0160_ sky130_fd_sc_hd__a221o_1
X_2495_ _0077_ _0081_ _0083_ VGND VGND VPWR VPWR _0084_ sky130_fd_sc_hd__and3_1
XFILLER_0_65_51 VGND VGND VPWR VPWR sky130_fd_sc_hd__decap_4
X_3116_ clknet_2_0__leaf_clock _0033_ VGND VGND VPWR VPWR net46 sky130_fd_sc_hd__dfxtp_4
X_3047_ _0468_ _0663_ VGND VGND VPWR VPWR _0664_ sky130_fd_sc_hd__or2b_1
XFILLER_0_45_152 VGND VGND VPWR VPWR sky130_fd_sc_hd__fill_2
XFILLER_0_5_293 VPWR VGND VPWR VGND sky130_ef_sc_hd__decap_12
XFILLER_0_18_355 VGND VGND VPWR VPWR sky130_fd_sc_hd__decap_8
XFILLER_0_36_141 VGND VGND VPWR VPWR sky130_fd_sc_hd__decap_8
XFILLER_0_51_177 VGND VGND VPWR VPWR sky130_fd_sc_hd__decap_4
XFILLER_0_10_13 VGND VGND VPWR VPWR sky130_fd_sc_hd__decap_6
XFILLER_0_10_35 VGND VGND VPWR VPWR sky130_fd_sc_hd__fill_1
XFILLER_0_10_46 VGND VGND VPWR VPWR sky130_fd_sc_hd__decap_8
XTAP_TAPCELL_ROW_67_618 VGND VPWR sky130_fd_sc_hd__tapvpwrvgnd_1
X_2280_ net48 net56 _1112_ VGND VGND VPWR VPWR _1364_ sky130_fd_sc_hd__and3_1
XFILLER_0_59_233 VGND VGND VPWR VPWR sky130_fd_sc_hd__fill_1
XFILLER_0_59_222 VGND VGND VPWR VPWR sky130_fd_sc_hd__fill_2
X_2616_ _1459_ _1469_ _0135_ _1477_ VGND VGND VPWR VPWR _0217_ sky130_fd_sc_hd__a211o_1
XFILLER_0_42_177 VGND VGND VPWR VPWR sky130_fd_sc_hd__decap_8
X_1995_ _1060_ _1059_ VGND VGND VPWR VPWR _1079_ sky130_fd_sc_hd__and2_1
XFILLER_0_55_3 VPWR VGND VPWR VGND sky130_ef_sc_hd__decap_12
X_2478_ net30 _1224_ _1187_ VGND VGND VPWR VPWR _0065_ sky130_fd_sc_hd__mux2_1
X_2547_ net36 _1143_ _1188_ VGND VGND VPWR VPWR _0141_ sky130_fd_sc_hd__mux2_1
XFILLER_0_2_285 VPWR VGND VPWR VGND sky130_ef_sc_hd__decap_12
XFILLER_0_2_263 VGND VGND VPWR VPWR sky130_fd_sc_hd__decap_3
XFILLER_0_65_269 VGND VGND VPWR VPWR sky130_fd_sc_hd__decap_8
XFILLER_0_65_225 VGND VGND VPWR VPWR sky130_fd_sc_hd__decap_4
Xclkload1 clknet_2_2__leaf_clock VGND VGND VPWR VPWR clkload1/Y sky130_fd_sc_hd__clkinvlp_4
XFILLER_0_33_144 VGND VGND VPWR VPWR sky130_fd_sc_hd__fill_1
XTAP_TAPCELL_ROW_21_297 VGND VPWR sky130_fd_sc_hd__tapvpwrvgnd_1
XFILLER_0_56_225 VGND VGND VPWR VPWR sky130_fd_sc_hd__fill_1
XFILLER_0_56_203 VGND VGND VPWR VPWR sky130_fd_sc_hd__fill_1
XTAP_TAPCELL_ROW_29_353 VGND VPWR sky130_fd_sc_hd__tapvpwrvgnd_1
XFILLER_0_44_409 VGND VGND VPWR VPWR sky130_fd_sc_hd__fill_2
XTAP_TAPCELL_ROW_12_231 VGND VPWR sky130_fd_sc_hd__tapvpwrvgnd_1
X_1780_ _0849_ _0863_ VGND VGND VPWR VPWR _0864_ sky130_fd_sc_hd__or2_1
XFILLER_0_21_12 VGND VGND VPWR VPWR sky130_fd_sc_hd__fill_1
X_2401_ _1249_ _1430_ _1448_ _1102_ VGND VGND VPWR VPWR _1489_ sky130_fd_sc_hd__a211o_1
X_2332_ _1268_ net70 _1295_ VGND VGND VPWR VPWR _1416_ sky130_fd_sc_hd__or3_1
X_2194_ _1271_ _1274_ _1277_ VGND VGND VPWR VPWR _1278_ sky130_fd_sc_hd__and3_1
X_2263_ _1108_ net73 _1313_ _1346_ VGND VGND VPWR VPWR _1347_ sky130_fd_sc_hd__a31o_1
XFILLER_0_1_55 VGND VGND VPWR VPWR sky130_fd_sc_hd__fill_1
XFILLER_0_62_85 VGND VGND VPWR VPWR sky130_fd_sc_hd__fill_2
XFILLER_0_62_41 VPWR VGND VPWR VGND sky130_ef_sc_hd__decap_12
XFILLER_0_30_147 VGND VGND VPWR VPWR sky130_fd_sc_hd__decap_3
X_1978_ _1015_ _1030_ VGND VGND VPWR VPWR _1062_ sky130_fd_sc_hd__nand2_1
XFILLER_0_11_361 VPWR VGND VPWR VGND sky130_ef_sc_hd__decap_12
XTAP_TAPCELL_ROW_26_334 VGND VPWR sky130_fd_sc_hd__tapvpwrvgnd_1
XFILLER_0_21_125 VGND VGND VPWR VPWR sky130_fd_sc_hd__decap_4
XFILLER_0_21_147 VGND VGND VPWR VPWR sky130_fd_sc_hd__decap_8
XFILLER_0_21_169 VPWR VGND VPWR VGND sky130_ef_sc_hd__decap_12
XFILLER_0_69_361 VGND VGND VPWR VPWR sky130_fd_sc_hd__decap_3
X_2950_ _0326_ _0418_ net82 VGND VGND VPWR VPWR _0570_ sky130_fd_sc_hd__mux2_4
XFILLER_0_44_239 VGND VGND VPWR VPWR sky130_fd_sc_hd__decap_6
XFILLER_0_32_66 VPWR VGND VPWR VGND sky130_ef_sc_hd__decap_12
X_2881_ net85 _0501_ VGND VGND VPWR VPWR _0502_ sky130_fd_sc_hd__nand2_1
XFILLER_0_29_225 VGND VGND VPWR VPWR sky130_fd_sc_hd__fill_1
X_1901_ net18 net16 VGND VGND VPWR VPWR _0985_ sky130_fd_sc_hd__and2_1
X_1832_ _0914_ _0873_ _0915_ VGND VGND VPWR VPWR _0916_ sky130_fd_sc_hd__o21bai_4
X_1763_ _0845_ _0846_ VGND VGND VPWR VPWR _0847_ sky130_fd_sc_hd__or2b_1
X_1694_ _0777_ VGND VGND VPWR VPWR _0778_ sky130_fd_sc_hd__clkbuf_4
X_2246_ _1326_ _1329_ _1248_ VGND VGND VPWR VPWR _1330_ sky130_fd_sc_hd__a21oi_1
X_2315_ _1398_ _1397_ _1394_ _1101_ VGND VGND VPWR VPWR _1399_ sky130_fd_sc_hd__a31oi_4
XFILLER_0_20_191 VGND VGND VPWR VPWR sky130_fd_sc_hd__decap_4
XFILLER_0_67_309 VGND VGND VPWR VPWR sky130_fd_sc_hd__decap_8
X_2177_ _1107_ _1260_ VGND VGND VPWR VPWR _1261_ sky130_fd_sc_hd__nor2_1
XFILLER_0_18_3 VGND VGND VPWR VPWR sky130_fd_sc_hd__fill_2
XFILLER_0_50_209 VGND VGND VPWR VPWR sky130_fd_sc_hd__decap_3
XFILLER_0_35_217 VGND VGND VPWR VPWR sky130_fd_sc_hd__decap_6
XTAP_TAPCELL_ROW_31_370 VGND VPWR sky130_fd_sc_hd__tapvpwrvgnd_1
XFILLER_0_28_280 VGND VGND VPWR VPWR sky130_fd_sc_hd__fill_1
Xoutput47 net47 VGND VGND VPWR VPWR io_accOut[3] sky130_fd_sc_hd__clkbuf_4
Xoutput36 net36 VGND VGND VPWR VPWR io_accOut[22] sky130_fd_sc_hd__buf_2
XFILLER_0_3_391 VGND VGND VPWR VPWR sky130_fd_sc_hd__fill_1
Xoutput25 net25 VGND VGND VPWR VPWR io_accOut[12] sky130_fd_sc_hd__buf_2
XFILLER_0_58_309 VGND VGND VPWR VPWR sky130_fd_sc_hd__decap_8
XFILLER_0_1_317 VPWR VGND VPWR VGND sky130_ef_sc_hd__decap_12
X_2100_ _1107_ _1183_ VGND VGND VPWR VPWR _1184_ sky130_fd_sc_hd__nor2_1
X_3080_ _0695_ VGND VGND VPWR VPWR _0032_ sky130_fd_sc_hd__clkbuf_1
XTAP_TAPCELL_ROW_45_462 VGND VPWR sky130_fd_sc_hd__tapvpwrvgnd_1
XTAP_TAPCELL_ROW_37_407 VGND VPWR sky130_fd_sc_hd__tapvpwrvgnd_1
X_2031_ _1044_ VGND VGND VPWR VPWR _1115_ sky130_fd_sc_hd__buf_2
X_2795_ _0360_ VGND VGND VPWR VPWR _0414_ sky130_fd_sc_hd__inv_2
X_2864_ _0484_ _0346_ net68 VGND VGND VPWR VPWR _0485_ sky130_fd_sc_hd__mux2_4
X_2933_ net25 _0543_ _0482_ _0553_ VGND VGND VPWR VPWR _0013_ sky130_fd_sc_hd__o211a_1
XFILLER_0_25_261 VPWR VGND VPWR VGND sky130_ef_sc_hd__decap_12
X_1815_ _0791_ _0864_ VGND VGND VPWR VPWR _0899_ sky130_fd_sc_hd__nor2_1
X_1677_ _0166_ _0750_ VGND VGND VPWR VPWR _0761_ sky130_fd_sc_hd__nand2_1
X_1746_ _0818_ _0828_ _0829_ VGND VGND VPWR VPWR _0830_ sky130_fd_sc_hd__a21o_1
XFILLER_0_0_361 VGND VGND VPWR VPWR sky130_fd_sc_hd__decap_3
XFILLER_0_7_32 VGND VGND VPWR VPWR sky130_fd_sc_hd__decap_6
X_2229_ net50 _1312_ net57 VGND VGND VPWR VPWR _1313_ sky130_fd_sc_hd__mux2_1
XFILLER_0_48_375 VGND VGND VPWR VPWR sky130_fd_sc_hd__fill_2
XFILLER_0_63_345 VGND VGND VPWR VPWR sky130_fd_sc_hd__fill_1
XFILLER_0_31_275 VGND VGND VPWR VPWR sky130_fd_sc_hd__decap_4
XFILLER_0_7_3 VPWR VGND VPWR VGND sky130_ef_sc_hd__decap_12
XTAP_TAPCELL_ROW_59_565 VGND VPWR sky130_fd_sc_hd__tapvpwrvgnd_1
XFILLER_0_66_161 VGND VGND VPWR VPWR sky130_fd_sc_hd__decap_4
XTAP_TAPCELL_ROW_42_443 VGND VPWR sky130_fd_sc_hd__tapvpwrvgnd_1
XFILLER_0_39_331 VGND VGND VPWR VPWR sky130_fd_sc_hd__decap_4
XFILLER_0_13_57 VPWR VGND VPWR VGND sky130_ef_sc_hd__decap_12
X_2580_ _0137_ _0171_ _0172_ _0176_ VGND VGND VPWR VPWR _0178_ sky130_fd_sc_hd__o22a_1
XFILLER_0_22_253 VPWR VGND VPWR VGND sky130_ef_sc_hd__decap_12
X_1600_ _0560_ _0550_ VGND VGND VPWR VPWR _0569_ sky130_fd_sc_hd__xnor2_2
X_3063_ _0663_ _0679_ _0673_ _0675_ VGND VGND VPWR VPWR _0680_ sky130_fd_sc_hd__o22ai_2
XFILLER_0_54_53 VPWR VGND VPWR VGND sky130_ef_sc_hd__decap_12
X_2014_ _1097_ VGND VGND VPWR VPWR _1098_ sky130_fd_sc_hd__buf_2
XFILLER_0_9_225 VGND VGND VPWR VPWR sky130_fd_sc_hd__decap_8
XPHY_EDGE_ROW_19_Left_89 VGND VGND VPWR VPWR sky130_fd_sc_hd__decap_3
X_2778_ _0350_ _0354_ _0394_ _0361_ VGND VGND VPWR VPWR _0395_ sky130_fd_sc_hd__a31oi_1
X_2916_ _0366_ _0363_ net82 VGND VGND VPWR VPWR _0536_ sky130_fd_sc_hd__mux2_2
XFILLER_0_60_337 VGND VGND VPWR VPWR sky130_fd_sc_hd__decap_6
XFILLER_0_60_315 VGND VGND VPWR VPWR sky130_fd_sc_hd__decap_4
X_2847_ _0317_ _0327_ _0368_ VGND VGND VPWR VPWR _0467_ sky130_fd_sc_hd__and3_1
XFILLER_0_57_194 VGND VGND VPWR VPWR sky130_fd_sc_hd__decap_4
XFILLER_0_45_389 VGND VGND VPWR VPWR sky130_fd_sc_hd__decap_3
XFILLER_0_9_269 VGND VGND VPWR VPWR sky130_fd_sc_hd__decap_8
X_1729_ _0792_ _0784_ VGND VGND VPWR VPWR _0813_ sky130_fd_sc_hd__or2_1
XFILLER_0_13_253 VGND VGND VPWR VPWR sky130_fd_sc_hd__fill_1
XFILLER_0_39_150 VGND VGND VPWR VPWR sky130_fd_sc_hd__fill_2
X_2632_ _0180_ _0185_ _0234_ VGND VGND VPWR VPWR _0235_ sky130_fd_sc_hd__o21ai_1
XFILLER_0_54_197 VGND VGND VPWR VPWR sky130_fd_sc_hd__decap_4
XFILLER_0_54_164 VGND VGND VPWR VPWR sky130_fd_sc_hd__decap_3
XFILLER_0_54_120 VGND VGND VPWR VPWR sky130_fd_sc_hd__fill_2
X_2701_ _0272_ _0310_ VGND VGND VPWR VPWR _0311_ sky130_fd_sc_hd__xnor2_2
XFILLER_0_39_172 VGND VGND VPWR VPWR sky130_fd_sc_hd__decap_8
XFILLER_0_40_77 VGND VGND VPWR VPWR sky130_fd_sc_hd__fill_1
XFILLER_0_27_345 VGND VGND VPWR VPWR sky130_fd_sc_hd__decap_3
XFILLER_0_2_401 VPWR VGND VPWR VGND sky130_ef_sc_hd__decap_12
X_2563_ _0063_ _1190_ VGND VGND VPWR VPWR _0159_ sky130_fd_sc_hd__nand2_1
X_2494_ _0062_ _0082_ _0061_ VGND VGND VPWR VPWR _0083_ sky130_fd_sc_hd__o21ba_1
X_3115_ clknet_2_3__leaf_clock _0032_ VGND VGND VPWR VPWR accumulator.state\[1\] sky130_fd_sc_hd__dfxtp_1
X_3046_ _0662_ _1064_ _1188_ VGND VGND VPWR VPWR _0663_ sky130_fd_sc_hd__mux2_1
XFILLER_0_33_337 VPWR VGND VPWR VGND sky130_ef_sc_hd__decap_12
XFILLER_0_5_261 VPWR VGND VPWR VGND sky130_ef_sc_hd__decap_12
XFILLER_0_68_289 VGND VGND VPWR VPWR sky130_fd_sc_hd__decap_3
XFILLER_0_68_212 VGND VGND VPWR VPWR sky130_fd_sc_hd__fill_2
XTAP_TAPCELL_ROW_1_160 VGND VPWR sky130_fd_sc_hd__tapvpwrvgnd_1
XFILLER_0_36_131 VGND VGND VPWR VPWR sky130_fd_sc_hd__decap_8
XFILLER_0_51_167 VGND VGND VPWR VPWR sky130_fd_sc_hd__fill_1
XTAP_TAPCELL_ROW_67_619 VGND VPWR sky130_fd_sc_hd__tapvpwrvgnd_1
XFILLER_0_35_55 VGND VGND VPWR VPWR sky130_fd_sc_hd__fill_1
XPHY_EDGE_ROW_32_Left_102 VGND VGND VPWR VPWR sky130_fd_sc_hd__decap_3
XFILLER_0_59_267 VGND VGND VPWR VPWR sky130_fd_sc_hd__fill_2
X_1994_ net60 VGND VGND VPWR VPWR _1078_ sky130_fd_sc_hd__clkbuf_4
X_2615_ _0211_ _0215_ VGND VGND VPWR VPWR _0216_ sky130_fd_sc_hd__nor2_1
XPHY_EDGE_ROW_41_Left_111 VGND VGND VPWR VPWR sky130_fd_sc_hd__decap_3
XFILLER_0_15_315 VPWR VGND VPWR VGND sky130_ef_sc_hd__decap_12
XFILLER_0_15_337 VPWR VGND VPWR VGND sky130_ef_sc_hd__decap_12
X_2477_ _0058_ _0063_ VGND VGND VPWR VPWR _0064_ sky130_fd_sc_hd__nor2_1
XPHY_EDGE_ROW_50_Left_120 VGND VGND VPWR VPWR sky130_fd_sc_hd__decap_3
XFILLER_0_48_3 VPWR VGND VPWR VGND sky130_ef_sc_hd__decap_12
X_2546_ _1099_ _1103_ _1259_ _1295_ VGND VGND VPWR VPWR _0140_ sky130_fd_sc_hd__or4_2
XFILLER_0_2_297 VGND VGND VPWR VPWR sky130_fd_sc_hd__decap_8
XFILLER_0_65_215 VGND VGND VPWR VPWR sky130_fd_sc_hd__decap_8
X_3029_ net39 _0441_ VGND VGND VPWR VPWR _0646_ sky130_fd_sc_hd__or2_1
Xclkload2 clknet_2_3__leaf_clock VGND VGND VPWR VPWR clkload2/Y sky130_fd_sc_hd__clkinv_1
XFILLER_0_18_131 VGND VGND VPWR VPWR sky130_fd_sc_hd__decap_8
XFILLER_0_18_197 VGND VGND VPWR VPWR sky130_fd_sc_hd__decap_8
XFILLER_0_33_189 VGND VGND VPWR VPWR sky130_fd_sc_hd__decap_3
XFILLER_0_33_178 VGND VGND VPWR VPWR sky130_fd_sc_hd__fill_2
XTAP_TAPCELL_ROW_21_298 VGND VPWR sky130_fd_sc_hd__tapvpwrvgnd_1
XTAP_TAPCELL_ROW_29_354 VGND VPWR sky130_fd_sc_hd__tapvpwrvgnd_1
X_2400_ _1478_ _1355_ _1293_ _1485_ _1486_ VGND VGND VPWR VPWR _1488_ sky130_fd_sc_hd__a41oi_4
XFILLER_0_24_189 VGND VGND VPWR VPWR sky130_fd_sc_hd__decap_6
XTAP_TAPCELL_ROW_12_232 VGND VPWR sky130_fd_sc_hd__tapvpwrvgnd_1
XFILLER_0_21_35 VGND VGND VPWR VPWR sky130_fd_sc_hd__decap_6
XFILLER_0_21_57 VGND VGND VPWR VPWR sky130_fd_sc_hd__decap_3
X_2331_ _1249_ _1370_ _1414_ VGND VGND VPWR VPWR _1415_ sky130_fd_sc_hd__o21ba_1
X_2262_ net49 net56 _1170_ _1112_ VGND VGND VPWR VPWR _1346_ sky130_fd_sc_hd__and4_1
XFILLER_0_20_373 VGND VGND VPWR VPWR sky130_fd_sc_hd__decap_4
XFILLER_0_62_53 VPWR VGND VPWR VGND sky130_ef_sc_hd__decap_12
X_2193_ _1193_ _1276_ _1219_ VGND VGND VPWR VPWR _1277_ sky130_fd_sc_hd__a21o_1
XFILLER_0_55_281 VGND VGND VPWR VPWR sky130_fd_sc_hd__decap_4
X_1977_ _1055_ _1059_ _1060_ VGND VGND VPWR VPWR _1061_ sky130_fd_sc_hd__a21bo_4
XFILLER_0_15_145 VGND VGND VPWR VPWR sky130_fd_sc_hd__fill_1
X_2529_ _0070_ _0071_ VGND VGND VPWR VPWR _0121_ sky130_fd_sc_hd__or2b_1
XFILLER_0_11_373 VPWR VGND VPWR VGND sky130_ef_sc_hd__decap_12
XFILLER_0_38_248 VGND VGND VPWR VPWR sky130_fd_sc_hd__decap_4
XFILLER_0_38_226 VGND VGND VPWR VPWR sky130_fd_sc_hd__decap_4
XTAP_TAPCELL_ROW_26_335 VGND VPWR sky130_fd_sc_hd__tapvpwrvgnd_1
XTAP_TAPCELL_ROW_34_390 VGND VPWR sky130_fd_sc_hd__tapvpwrvgnd_1
XPHY_EDGE_ROW_7_Left_77 VGND VGND VPWR VPWR sky130_fd_sc_hd__decap_3
XFILLER_0_16_35 VGND VGND VPWR VPWR sky130_fd_sc_hd__fill_1
XFILLER_0_16_46 VGND VGND VPWR VPWR sky130_fd_sc_hd__decap_6
XFILLER_0_32_78 VGND VGND VPWR VPWR sky130_fd_sc_hd__decap_6
X_2880_ _1476_ VGND VGND VPWR VPWR _0501_ sky130_fd_sc_hd__clkbuf_4
X_1900_ net18 net16 VGND VGND VPWR VPWR _0984_ sky130_fd_sc_hd__nor2_1
X_1831_ _0872_ _0871_ VGND VGND VPWR VPWR _0915_ sky130_fd_sc_hd__and2b_1
XFILLER_0_4_304 VGND VGND VPWR VPWR sky130_fd_sc_hd__decap_4
XFILLER_0_8_109 VPWR VGND VPWR VGND sky130_ef_sc_hd__decap_12
X_1762_ _0818_ _0828_ VGND VGND VPWR VPWR _0846_ sky130_fd_sc_hd__xnor2_1
X_1693_ _0133_ _0766_ VGND VGND VPWR VPWR _0777_ sky130_fd_sc_hd__nand2_2
X_2245_ _1327_ _1328_ _1174_ VGND VGND VPWR VPWR _1329_ sky130_fd_sc_hd__a21o_1
X_2176_ _1258_ _1259_ _1174_ VGND VGND VPWR VPWR _1260_ sky130_fd_sc_hd__mux2_4
X_2314_ _1105_ _1176_ _1369_ VGND VGND VPWR VPWR _1398_ sky130_fd_sc_hd__or3b_4
XFILLER_0_20_170 VPWR VGND VPWR VGND sky130_ef_sc_hd__decap_12
XFILLER_0_7_120 VPWR VGND VPWR VGND sky130_ef_sc_hd__decap_12
XFILLER_0_16_410 VGND VGND VPWR VPWR sky130_fd_sc_hd__fill_1
Xoutput48 net48 VGND VGND VPWR VPWR io_accOut[4] sky130_fd_sc_hd__buf_2
Xoutput26 net26 VGND VGND VPWR VPWR io_accOut[13] sky130_fd_sc_hd__buf_2
XPHY_EDGE_ROW_1_Right_1 VGND VGND VPWR VPWR sky130_fd_sc_hd__decap_3
Xoutput37 net37 VGND VGND VPWR VPWR io_accOut[23] sky130_fd_sc_hd__buf_2
XFILLER_0_66_365 VPWR VGND VPWR VGND sky130_ef_sc_hd__decap_12
XFILLER_0_66_332 VPWR VGND VPWR VGND sky130_ef_sc_hd__decap_12
XFILLER_0_19_281 VGND VGND VPWR VPWR sky130_fd_sc_hd__decap_6
XFILLER_0_1_329 VGND VGND VPWR VPWR sky130_fd_sc_hd__decap_6
X_2030_ _1016_ _1019_ VGND VGND VPWR VPWR _1114_ sky130_fd_sc_hd__nand2_1
XFILLER_0_69_181 VPWR VGND VPWR VGND sky130_ef_sc_hd__decap_12
XTAP_TAPCELL_ROW_45_463 VGND VPWR sky130_fd_sc_hd__tapvpwrvgnd_1
XFILLER_0_43_88 VGND VGND VPWR VPWR sky130_fd_sc_hd__fill_2
XFILLER_0_43_55 VGND VGND VPWR VPWR sky130_fd_sc_hd__fill_1
X_2932_ _0474_ _0544_ _0551_ _0552_ _0543_ VGND VGND VPWR VPWR _0553_ sky130_fd_sc_hd__o221ai_1
XTAP_TAPCELL_ROW_37_408 VGND VPWR sky130_fd_sc_hd__tapvpwrvgnd_1
X_2794_ _0412_ _0354_ _0349_ VGND VGND VPWR VPWR _0413_ sky130_fd_sc_hd__a21o_1
X_2863_ _0344_ VGND VGND VPWR VPWR _0484_ sky130_fd_sc_hd__inv_2
XFILLER_0_25_273 VGND VGND VPWR VPWR sky130_fd_sc_hd__decap_6
XFILLER_0_25_240 VGND VGND VPWR VPWR sky130_fd_sc_hd__decap_4
X_1745_ _0825_ _0827_ VGND VGND VPWR VPWR _0829_ sky130_fd_sc_hd__nor2_1
XFILLER_0_13_413 VGND VGND VPWR VPWR sky130_fd_sc_hd__fill_2
X_1814_ _0896_ _0897_ VGND VGND VPWR VPWR _0898_ sky130_fd_sc_hd__nand2b_2
XFILLER_0_68_85 VPWR VGND VPWR VGND sky130_ef_sc_hd__decap_12
XFILLER_0_68_41 VPWR VGND VPWR VGND sky130_ef_sc_hd__decap_12
X_1676_ _0746_ _0265_ _0752_ _0759_ VGND VGND VPWR VPWR _0760_ sky130_fd_sc_hd__a22o_2
XFILLER_0_7_44 VGND VGND VPWR VPWR sky130_fd_sc_hd__fill_1
X_2228_ net81 _1141_ VGND VGND VPWR VPWR _1312_ sky130_fd_sc_hd__nor2_1
X_2159_ _1241_ _1242_ VGND VGND VPWR VPWR _1243_ sky130_fd_sc_hd__or2_1
XFILLER_0_48_398 VGND VGND VPWR VPWR sky130_fd_sc_hd__fill_2
XFILLER_0_48_365 VGND VGND VPWR VPWR sky130_fd_sc_hd__fill_1
XFILLER_0_31_221 VGND VGND VPWR VPWR sky130_fd_sc_hd__decap_3
XTAP_TAPCELL_ROW_59_566 VGND VPWR sky130_fd_sc_hd__tapvpwrvgnd_1
XTAP_TAPCELL_ROW_42_444 VGND VPWR sky130_fd_sc_hd__tapvpwrvgnd_1
XFILLER_0_13_69 VGND VGND VPWR VPWR sky130_fd_sc_hd__decap_8
XFILLER_0_22_265 VPWR VGND VPWR VGND sky130_ef_sc_hd__decap_12
XFILLER_0_1_148 VGND VGND VPWR VPWR sky130_fd_sc_hd__fill_2
XFILLER_0_54_65 VPWR VGND VPWR VGND sky130_ef_sc_hd__decap_12
X_2013_ _1088_ _1096_ VGND VGND VPWR VPWR _1097_ sky130_fd_sc_hd__or2b_4
XFILLER_0_38_99 VGND VGND VPWR VPWR sky130_fd_sc_hd__decap_8
X_3062_ _0468_ _0674_ VGND VGND VPWR VPWR _0679_ sky130_fd_sc_hd__or2b_1
X_2915_ _0529_ _0535_ _0439_ VGND VGND VPWR VPWR _0011_ sky130_fd_sc_hd__a21oi_1
X_2777_ _0337_ _0379_ _0392_ _0393_ VGND VGND VPWR VPWR _0394_ sky130_fd_sc_hd__a31o_1
XFILLER_0_60_305 VGND VGND VPWR VPWR sky130_fd_sc_hd__decap_3
XFILLER_0_45_368 VGND VGND VPWR VPWR sky130_fd_sc_hd__decap_3
X_2846_ _0439_ _0466_ VGND VGND VPWR VPWR _0004_ sky130_fd_sc_hd__nor2_1
X_1728_ _0809_ _0811_ VGND VGND VPWR VPWR _0812_ sky130_fd_sc_hd__nor2_1
X_1659_ _0731_ _0742_ VGND VGND VPWR VPWR _0743_ sky130_fd_sc_hd__nor2_1
XFILLER_0_0_181 VPWR VGND VPWR VGND sky130_ef_sc_hd__decap_12
XFILLER_0_48_162 VGND VGND VPWR VPWR sky130_fd_sc_hd__decap_6
XFILLER_0_51_349 VGND VGND VPWR VPWR sky130_fd_sc_hd__decap_6
XFILLER_0_59_405 VGND VGND VPWR VPWR sky130_fd_sc_hd__decap_8
XTAP_TAPCELL_ROW_4_180 VGND VPWR sky130_fd_sc_hd__tapvpwrvgnd_1
X_2631_ _0228_ _0229_ _0135_ _1484_ VGND VGND VPWR VPWR _0234_ sky130_fd_sc_hd__a211o_1
X_2700_ _0169_ _0268_ VGND VGND VPWR VPWR _0310_ sky130_fd_sc_hd__nor2_1
X_2562_ _0156_ _0131_ _0157_ VGND VGND VPWR VPWR _0158_ sky130_fd_sc_hd__o21a_1
XFILLER_0_42_305 VGND VGND VPWR VPWR sky130_fd_sc_hd__decap_3
XFILLER_0_2_413 VGND VGND VPWR VPWR sky130_fd_sc_hd__fill_2
XFILLER_0_50_382 VPWR VGND VPWR VGND sky130_ef_sc_hd__decap_12
XFILLER_0_49_65 VGND VGND VPWR VPWR sky130_fd_sc_hd__fill_1
X_2493_ _1099_ _0052_ _0054_ VGND VGND VPWR VPWR _0082_ sky130_fd_sc_hd__o21ai_1
XFILLER_0_10_224 VGND VGND VPWR VPWR sky130_fd_sc_hd__decap_4
X_3114_ clknet_2_0__leaf_clock _0031_ VGND VGND VPWR VPWR net45 sky130_fd_sc_hd__dfxtp_2
X_3045_ net41 VGND VGND VPWR VPWR _0662_ sky130_fd_sc_hd__inv_2
XFILLER_0_45_132 VPWR VGND VPWR VGND sky130_ef_sc_hd__decap_12
XFILLER_0_45_110 VGND VGND VPWR VPWR sky130_fd_sc_hd__fill_2
XFILLER_0_18_368 VPWR VGND VPWR VGND sky130_ef_sc_hd__decap_12
XFILLER_0_60_124 VPWR VGND VPWR VGND sky130_ef_sc_hd__decap_12
XFILLER_0_45_198 VGND VGND VPWR VPWR sky130_fd_sc_hd__decap_3
X_2829_ _0444_ _0449_ _0374_ VGND VGND VPWR VPWR _0450_ sky130_fd_sc_hd__mux2_2
XFILLER_0_33_349 VPWR VGND VPWR VGND sky130_ef_sc_hd__decap_12
XFILLER_0_5_273 VGND VGND VPWR VPWR sky130_fd_sc_hd__decap_6
XFILLER_0_68_235 VGND VGND VPWR VPWR sky130_fd_sc_hd__fill_2
XFILLER_0_51_135 VPWR VGND VPWR VGND sky130_ef_sc_hd__decap_12
XFILLER_0_51_124 VGND VGND VPWR VPWR sky130_fd_sc_hd__decap_4
XFILLER_0_51_102 VGND VGND VPWR VPWR sky130_fd_sc_hd__decap_3
XFILLER_0_10_59 VGND VGND VPWR VPWR sky130_fd_sc_hd__decap_4
XFILLER_0_19_57 VGND VGND VPWR VPWR sky130_fd_sc_hd__decap_4
XFILLER_0_19_46 VGND VGND VPWR VPWR sky130_fd_sc_hd__decap_8
XFILLER_0_19_68 VGND VGND VPWR VPWR sky130_fd_sc_hd__decap_4
XFILLER_0_35_67 VGND VGND VPWR VPWR sky130_fd_sc_hd__decap_8
XFILLER_0_51_55 VGND VGND VPWR VPWR sky130_fd_sc_hd__fill_1
X_1993_ _1069_ net90 VGND VGND VPWR VPWR _1077_ sky130_fd_sc_hd__xnor2_4
XTAP_TAPCELL_ROW_15_252 VGND VPWR sky130_fd_sc_hd__tapvpwrvgnd_1
XFILLER_0_15_327 VGND VGND VPWR VPWR sky130_fd_sc_hd__decap_8
X_2614_ _0090_ _0214_ VGND VGND VPWR VPWR _0215_ sky130_fd_sc_hd__xnor2_2
X_2545_ _1190_ _0138_ VGND VGND VPWR VPWR _0139_ sky130_fd_sc_hd__xnor2_2
XFILLER_0_23_393 VPWR VGND VPWR VGND sky130_ef_sc_hd__decap_12
XFILLER_0_15_349 VGND VGND VPWR VPWR sky130_fd_sc_hd__decap_6
X_2476_ _0061_ _0062_ VGND VGND VPWR VPWR _0063_ sky130_fd_sc_hd__or2_2
X_3028_ _0633_ _0644_ VGND VGND VPWR VPWR _0645_ sky130_fd_sc_hd__xnor2_1
XFILLER_0_33_124 VPWR VGND VPWR VGND sky130_ef_sc_hd__decap_12
XTAP_TAPCELL_ROW_21_299 VGND VPWR sky130_fd_sc_hd__tapvpwrvgnd_1
XFILLER_0_14_360 VGND VGND VPWR VPWR sky130_fd_sc_hd__decap_4
XTAP_TAPCELL_ROW_29_355 VGND VPWR sky130_fd_sc_hd__tapvpwrvgnd_1
XTAP_TAPCELL_ROW_12_233 VGND VPWR sky130_fd_sc_hd__tapvpwrvgnd_1
XFILLER_0_12_319 VGND VGND VPWR VPWR sky130_fd_sc_hd__decap_3
X_2330_ _1248_ _1297_ _1396_ _1101_ VGND VGND VPWR VPWR _1414_ sky130_fd_sc_hd__a31o_1
X_2192_ net52 _1275_ net58 VGND VGND VPWR VPWR _1276_ sky130_fd_sc_hd__mux2_2
X_2261_ _1109_ _1146_ _1276_ _1344_ VGND VGND VPWR VPWR _1345_ sky130_fd_sc_hd__a31o_1
XFILLER_0_20_385 VPWR VGND VPWR VGND sky130_ef_sc_hd__decap_12
XFILLER_0_62_98 VGND VGND VPWR VPWR sky130_fd_sc_hd__decap_3
XFILLER_0_62_65 VPWR VGND VPWR VGND sky130_ef_sc_hd__decap_12
XFILLER_0_46_88 VGND VGND VPWR VPWR sky130_fd_sc_hd__fill_2
XFILLER_0_1_57 VGND VGND VPWR VPWR sky130_fd_sc_hd__fill_2
XPHY_EDGE_ROW_23_Left_93 VGND VGND VPWR VPWR sky130_fd_sc_hd__decap_3
XFILLER_0_7_335 VGND VGND VPWR VPWR sky130_fd_sc_hd__fill_1
X_1976_ net40 _1058_ VGND VGND VPWR VPWR _1060_ sky130_fd_sc_hd__nand2_1
XFILLER_0_60_3 VPWR VGND VPWR VGND sky130_ef_sc_hd__decap_12
X_2528_ _0086_ _0118_ _0119_ VGND VGND VPWR VPWR _0120_ sky130_fd_sc_hd__a21o_1
XFILLER_0_11_385 VGND VGND VPWR VPWR sky130_fd_sc_hd__decap_6
X_2459_ _0038_ _0043_ VGND VGND VPWR VPWR _0044_ sky130_fd_sc_hd__nor2_1
XTAP_TAPCELL_ROW_34_391 VGND VPWR sky130_fd_sc_hd__tapvpwrvgnd_1
XFILLER_0_61_252 VGND VGND VPWR VPWR sky130_fd_sc_hd__decap_8
XFILLER_0_29_205 VGND VGND VPWR VPWR sky130_fd_sc_hd__fill_1
XFILLER_0_16_14 VGND VGND VPWR VPWR sky130_fd_sc_hd__decap_3
XFILLER_0_32_57 VGND VGND VPWR VPWR sky130_fd_sc_hd__decap_3
X_1761_ _0841_ _0844_ VGND VGND VPWR VPWR _0845_ sky130_fd_sc_hd__nand2_1
X_1830_ _0912_ _0908_ _0913_ VGND VGND VPWR VPWR _0914_ sky130_fd_sc_hd__a21oi_4
X_2313_ _1105_ _1173_ _1396_ VGND VGND VPWR VPWR _1397_ sky130_fd_sc_hd__or3_1
X_1692_ _0144_ _0775_ VGND VGND VPWR VPWR _0776_ sky130_fd_sc_hd__or2_1
XFILLER_0_20_182 VGND VGND VPWR VPWR sky130_fd_sc_hd__decap_4
X_2244_ _1146_ _1225_ _1219_ VGND VGND VPWR VPWR _1328_ sky130_fd_sc_hd__a21o_1
X_2175_ _1145_ _1181_ _1219_ VGND VGND VPWR VPWR _1259_ sky130_fd_sc_hd__mux2_4
XTAP_TAPCELL_ROW_48_483 VGND VPWR sky130_fd_sc_hd__tapvpwrvgnd_1
XFILLER_0_7_132 VPWR VGND VPWR VGND sky130_ef_sc_hd__decap_12
X_1959_ net37 _0968_ _1042_ VGND VGND VPWR VPWR _1043_ sky130_fd_sc_hd__or3_4
Xoutput49 net49 VGND VGND VPWR VPWR io_accOut[5] sky130_fd_sc_hd__buf_2
Xoutput27 net27 VGND VGND VPWR VPWR io_accOut[14] sky130_fd_sc_hd__buf_2
Xoutput38 net38 VGND VGND VPWR VPWR io_accOut[24] sky130_fd_sc_hd__buf_2
XFILLER_0_3_393 VPWR VGND VPWR VGND sky130_ef_sc_hd__decap_12
XFILLER_0_11_182 VGND VGND VPWR VPWR sky130_fd_sc_hd__fill_1
XFILLER_0_66_377 VPWR VGND VPWR VGND sky130_ef_sc_hd__decap_12
XFILLER_0_66_355 VGND VGND VPWR VPWR sky130_fd_sc_hd__decap_8
XFILLER_0_66_344 VGND VGND VPWR VPWR sky130_fd_sc_hd__decap_8
XTAP_TAPCELL_ROW_37_409 VGND VPWR sky130_fd_sc_hd__tapvpwrvgnd_1
XFILLER_0_27_57 VPWR VGND VPWR VGND sky130_ef_sc_hd__decap_12
XFILLER_0_69_193 VGND VGND VPWR VPWR sky130_fd_sc_hd__decap_3
XFILLER_0_57_388 VGND VGND VPWR VPWR sky130_fd_sc_hd__decap_4
XTAP_TAPCELL_ROW_45_464 VGND VPWR sky130_fd_sc_hd__tapvpwrvgnd_1
X_2931_ _0477_ _0473_ VGND VGND VPWR VPWR _0552_ sky130_fd_sc_hd__and2_1
X_2793_ _0411_ _0344_ _0346_ VGND VGND VPWR VPWR _0412_ sky130_fd_sc_hd__a21o_1
XFILLER_0_57_399 VPWR VGND VPWR VGND sky130_ef_sc_hd__decap_12
X_2862_ _0469_ VGND VGND VPWR VPWR _0483_ sky130_fd_sc_hd__inv_2
X_1744_ _0825_ _0827_ VGND VGND VPWR VPWR _0828_ sky130_fd_sc_hd__xor2_1
X_1813_ _0887_ _0778_ _0864_ _0144_ VGND VGND VPWR VPWR _0897_ sky130_fd_sc_hd__o22ai_2
XFILLER_0_68_97 VGND VGND VPWR VPWR sky130_fd_sc_hd__decap_8
XFILLER_0_68_53 VPWR VGND VPWR VGND sky130_ef_sc_hd__decap_12
XFILLER_0_40_299 VGND VGND VPWR VPWR sky130_fd_sc_hd__decap_8
X_1675_ _0755_ _0758_ VGND VGND VPWR VPWR _0759_ sky130_fd_sc_hd__nand2_1
XPHY_EDGE_ROW_15_Right_15 VGND VGND VPWR VPWR sky130_fd_sc_hd__decap_3
X_2227_ _1193_ _1310_ _1196_ VGND VGND VPWR VPWR _1311_ sky130_fd_sc_hd__a21o_1
X_2089_ _1169_ _1172_ VGND VGND VPWR VPWR _1173_ sky130_fd_sc_hd__nand2_2
XPHY_EDGE_ROW_24_Right_24 VGND VGND VPWR VPWR sky130_fd_sc_hd__decap_3
X_2158_ _1133_ _1118_ _1128_ VGND VGND VPWR VPWR _1242_ sky130_fd_sc_hd__mux2_1
XFILLER_0_23_3 VGND VGND VPWR VPWR sky130_fd_sc_hd__decap_3
XPHY_EDGE_ROW_33_Right_33 VGND VGND VPWR VPWR sky130_fd_sc_hd__decap_3
XPHY_EDGE_ROW_10_Left_80 VGND VGND VPWR VPWR sky130_fd_sc_hd__decap_3
XPHY_EDGE_ROW_42_Right_42 VGND VGND VPWR VPWR sky130_fd_sc_hd__decap_3
XTAP_TAPCELL_ROW_42_445 VGND VPWR sky130_fd_sc_hd__tapvpwrvgnd_1
XFILLER_0_39_377 VGND VGND VPWR VPWR sky130_fd_sc_hd__fill_1
XFILLER_0_62_380 VPWR VGND VPWR VGND sky130_ef_sc_hd__decap_12
XFILLER_0_54_358 VGND VGND VPWR VPWR sky130_fd_sc_hd__decap_6
XPHY_EDGE_ROW_51_Right_51 VGND VGND VPWR VPWR sky130_fd_sc_hd__decap_3
XFILLER_0_38_78 VGND VGND VPWR VPWR sky130_fd_sc_hd__fill_1
XPHY_EDGE_ROW_60_Right_60 VGND VGND VPWR VPWR sky130_fd_sc_hd__decap_3
XFILLER_0_54_77 VGND VGND VPWR VPWR sky130_fd_sc_hd__decap_6
X_2012_ _1095_ _1090_ VGND VGND VPWR VPWR _1096_ sky130_fd_sc_hd__xnor2_2
X_3061_ net42 _0543_ _0482_ _0678_ VGND VGND VPWR VPWR _0029_ sky130_fd_sc_hd__o211a_1
X_2914_ _0456_ _0504_ _0534_ _0315_ VGND VGND VPWR VPWR _0535_ sky130_fd_sc_hd__o22a_1
X_2845_ net47 _1487_ _0315_ _0465_ VGND VGND VPWR VPWR _0466_ sky130_fd_sc_hd__o2bb2a_1
X_2776_ _0344_ _0347_ VGND VGND VPWR VPWR _0393_ sky130_fd_sc_hd__nand2_1
XFILLER_0_60_328 VGND VGND VPWR VPWR sky130_fd_sc_hd__decap_6
X_1658_ _0740_ _0741_ VGND VGND VPWR VPWR _0742_ sky130_fd_sc_hd__and2_1
X_1727_ _0774_ _0810_ VGND VGND VPWR VPWR _0811_ sky130_fd_sc_hd__nand2_4
XFILLER_0_0_193 VGND VGND VPWR VPWR sky130_fd_sc_hd__decap_3
X_1589_ _0243_ net12 net13 VGND VGND VPWR VPWR _0460_ sky130_fd_sc_hd__and3_1
XTAP_TAPCELL_ROW_4_181 VGND VPWR sky130_fd_sc_hd__tapvpwrvgnd_1
XFILLER_0_24_58 VPWR VGND VPWR VGND sky130_ef_sc_hd__decap_12
X_2630_ _0228_ _0231_ VGND VGND VPWR VPWR _0233_ sky130_fd_sc_hd__xnor2_2
XFILLER_0_50_394 VGND VGND VPWR VPWR sky130_fd_sc_hd__fill_2
X_2492_ _0064_ _0080_ VGND VGND VPWR VPWR _0081_ sky130_fd_sc_hd__nand2_1
XFILLER_0_49_55 VGND VGND VPWR VPWR sky130_fd_sc_hd__fill_1
X_2561_ _1186_ _1189_ VGND VGND VPWR VPWR _0157_ sky130_fd_sc_hd__or2b_1
XFILLER_0_10_214 VGND VGND VPWR VPWR sky130_fd_sc_hd__decap_4
XFILLER_0_4_68 VPWR VGND VPWR VGND sky130_ef_sc_hd__decap_12
X_3113_ clknet_2_2__leaf_clock _0030_ VGND VGND VPWR VPWR net43 sky130_fd_sc_hd__dfxtp_1
XFILLER_0_65_98 VGND VGND VPWR VPWR sky130_fd_sc_hd__decap_8
XTAP_TAPCELL_ROW_53_518 VGND VPWR sky130_fd_sc_hd__tapvpwrvgnd_1
X_3044_ _0655_ _0649_ _0656_ VGND VGND VPWR VPWR _0661_ sky130_fd_sc_hd__a21bo_1
XFILLER_0_60_136 VGND VGND VPWR VPWR sky130_fd_sc_hd__decap_4
XFILLER_0_60_103 VGND VGND VPWR VPWR sky130_fd_sc_hd__decap_8
X_2828_ _0447_ _0448_ VGND VGND VPWR VPWR _0449_ sky130_fd_sc_hd__nand2_1
XFILLER_0_45_144 VGND VGND VPWR VPWR sky130_fd_sc_hd__decap_8
XFILLER_0_5_252 VGND VGND VPWR VPWR sky130_fd_sc_hd__decap_3
X_2759_ _0373_ VGND VGND VPWR VPWR _0374_ sky130_fd_sc_hd__buf_2
XFILLER_0_41_361 VGND VGND VPWR VPWR sky130_fd_sc_hd__decap_8
XTAP_TAPCELL_ROW_69_640 VGND VPWR sky130_fd_sc_hd__tapvpwrvgnd_1
XFILLER_0_51_147 VGND VGND VPWR VPWR sky130_fd_sc_hd__decap_4
XFILLER_0_24_306 VGND VGND VPWR VPWR sky130_fd_sc_hd__fill_2
XFILLER_0_10_27 VGND VGND VPWR VPWR sky130_fd_sc_hd__fill_1
XFILLER_0_17_391 VGND VGND VPWR VPWR sky130_fd_sc_hd__fill_1
XFILLER_0_19_36 VGND VGND VPWR VPWR sky130_fd_sc_hd__decap_4
XFILLER_0_59_225 VGND VGND VPWR VPWR sky130_fd_sc_hd__decap_8
XFILLER_0_35_57 VGND VGND VPWR VPWR sky130_fd_sc_hd__decap_4
XFILLER_0_51_78 VGND VGND VPWR VPWR sky130_fd_sc_hd__decap_4
XFILLER_0_51_67 VGND VGND VPWR VPWR sky130_fd_sc_hd__decap_8
XFILLER_0_42_125 VGND VGND VPWR VPWR sky130_fd_sc_hd__fill_2
X_1992_ _1073_ _1074_ _1075_ VGND VGND VPWR VPWR _1076_ sky130_fd_sc_hd__a21oi_4
XTAP_TAPCELL_ROW_15_253 VGND VPWR sky130_fd_sc_hd__tapvpwrvgnd_1
X_2613_ _1459_ _0212_ _0213_ VGND VGND VPWR VPWR _0214_ sky130_fd_sc_hd__a21oi_1
X_2544_ net75 _0132_ _0137_ VGND VGND VPWR VPWR _0138_ sky130_fd_sc_hd__mux2_2
X_2475_ _0059_ _0060_ VGND VGND VPWR VPWR _0062_ sky130_fd_sc_hd__nor2_1
XFILLER_0_23_372 VGND VGND VPWR VPWR sky130_fd_sc_hd__decap_3
XTAP_TAPCELL_ROW_66_610 VGND VPWR sky130_fd_sc_hd__tapvpwrvgnd_1
X_3027_ _0642_ _0643_ VGND VGND VPWR VPWR _0644_ sky130_fd_sc_hd__nor2_1
XFILLER_0_18_122 VGND VGND VPWR VPWR sky130_fd_sc_hd__decap_4
XFILLER_0_33_136 VGND VGND VPWR VPWR sky130_fd_sc_hd__decap_8
XTAP_TAPCELL_ROW_29_356 VGND VPWR sky130_fd_sc_hd__tapvpwrvgnd_1
XFILLER_0_24_103 VGND VGND VPWR VPWR sky130_fd_sc_hd__fill_1
XTAP_TAPCELL_ROW_12_234 VGND VPWR sky130_fd_sc_hd__tapvpwrvgnd_1
X_2260_ _1196_ net73 _1310_ VGND VGND VPWR VPWR _1344_ sky130_fd_sc_hd__and3_1
X_2191_ _1127_ _1227_ VGND VGND VPWR VPWR _1275_ sky130_fd_sc_hd__and2_1
XFILLER_0_20_397 VPWR VGND VPWR VGND sky130_ef_sc_hd__decap_12
XFILLER_0_62_77 VGND VGND VPWR VPWR sky130_fd_sc_hd__decap_6
X_1975_ net40 _1058_ VGND VGND VPWR VPWR _1059_ sky130_fd_sc_hd__or2_1
XFILLER_0_15_169 VGND VGND VPWR VPWR sky130_fd_sc_hd__decap_4
X_2458_ _0041_ _0042_ VGND VGND VPWR VPWR _0043_ sky130_fd_sc_hd__nand2b_2
X_2527_ _1539_ _0069_ VGND VGND VPWR VPWR _0119_ sky130_fd_sc_hd__nand2_1
XFILLER_0_53_3 VPWR VGND VPWR VGND sky130_ef_sc_hd__decap_12
XFILLER_0_30_139 VGND VGND VPWR VPWR sky130_fd_sc_hd__fill_1
X_2389_ net48 _1322_ VGND VGND VPWR VPWR _1475_ sky130_fd_sc_hd__nand2_1
XFILLER_0_34_401 VGND VGND VPWR VPWR sky130_fd_sc_hd__decap_8
Xclkbuf_2_2__f_clock clknet_0_clock VGND VGND VPWR VPWR clknet_2_2__leaf_clock sky130_fd_sc_hd__clkbuf_16
XFILLER_0_16_26 VGND VGND VPWR VPWR sky130_fd_sc_hd__fill_2
XFILLER_0_52_286 VGND VGND VPWR VPWR sky130_fd_sc_hd__fill_2
XFILLER_0_52_253 VGND VGND VPWR VPWR sky130_fd_sc_hd__decap_3
XFILLER_0_44_209 VPWR VGND VPWR VGND sky130_ef_sc_hd__decap_12
XFILLER_0_37_294 VGND VGND VPWR VPWR sky130_fd_sc_hd__decap_6
X_1760_ _0842_ _0843_ VGND VGND VPWR VPWR _0844_ sky130_fd_sc_hd__or2b_1
X_1691_ _0210_ _0760_ _0166_ VGND VGND VPWR VPWR _0775_ sky130_fd_sc_hd__o21ai_4
XFILLER_0_57_55 VGND VGND VPWR VPWR sky130_fd_sc_hd__fill_1
X_2312_ net33 _1108_ _1367_ _1395_ VGND VGND VPWR VPWR _1396_ sky130_fd_sc_hd__a31o_1
XFILLER_0_57_88 VGND VGND VPWR VPWR sky130_fd_sc_hd__decap_3
XTAP_TAPCELL_ROW_48_484 VGND VPWR sky130_fd_sc_hd__tapvpwrvgnd_1
X_2174_ _1109_ _1252_ _1257_ VGND VGND VPWR VPWR _1258_ sky130_fd_sc_hd__a21oi_1
X_2243_ _1146_ _1244_ _1323_ VGND VGND VPWR VPWR _1327_ sky130_fd_sc_hd__a21o_1
XFILLER_0_7_144 VPWR VGND VPWR VGND sky130_ef_sc_hd__decap_12
XFILLER_0_7_166 VGND VGND VPWR VPWR sky130_fd_sc_hd__fill_2
Xoutput28 net28 VGND VGND VPWR VPWR io_accOut[15] sky130_fd_sc_hd__buf_2
X_1958_ _1030_ _1039_ _1015_ _1041_ VGND VGND VPWR VPWR _1042_ sky130_fd_sc_hd__a31oi_4
Xoutput39 net39 VGND VGND VPWR VPWR io_accOut[25] sky130_fd_sc_hd__buf_2
XFILLER_0_22_80 VGND VGND VPWR VPWR sky130_fd_sc_hd__decap_4
XFILLER_0_3_361 VPWR VGND VPWR VGND sky130_ef_sc_hd__decap_12
X_1889_ _0898_ _0903_ VGND VGND VPWR VPWR _0973_ sky130_fd_sc_hd__xnor2_1
XFILLER_0_66_389 VPWR VGND VPWR VGND sky130_ef_sc_hd__decap_12
XFILLER_0_34_231 VGND VGND VPWR VPWR sky130_fd_sc_hd__decap_4
XFILLER_0_26_209 VPWR VGND VPWR VGND sky130_ef_sc_hd__decap_12
XFILLER_0_27_69 VGND VGND VPWR VPWR sky130_fd_sc_hd__decap_3
XFILLER_0_57_367 VGND VGND VPWR VPWR sky130_fd_sc_hd__decap_6
XFILLER_0_57_345 VGND VGND VPWR VPWR sky130_fd_sc_hd__fill_2
XFILLER_0_57_334 VGND VGND VPWR VPWR sky130_fd_sc_hd__fill_2
XTAP_TAPCELL_ROW_45_465 VGND VPWR sky130_fd_sc_hd__tapvpwrvgnd_1
XFILLER_0_43_68 VGND VGND VPWR VPWR sky130_fd_sc_hd__fill_1
XFILLER_0_43_57 VGND VGND VPWR VPWR sky130_fd_sc_hd__decap_4
X_2930_ _0477_ _0549_ VGND VGND VPWR VPWR _0551_ sky130_fd_sc_hd__nor2_1
X_2861_ _0481_ VGND VGND VPWR VPWR _0482_ sky130_fd_sc_hd__buf_2
X_2792_ _0410_ _0337_ _0340_ VGND VGND VPWR VPWR _0411_ sky130_fd_sc_hd__a21o_1
XFILLER_0_4_147 VGND VGND VPWR VPWR sky130_fd_sc_hd__fill_1
XFILLER_0_4_125 VGND VGND VPWR VPWR sky130_fd_sc_hd__decap_3
X_1674_ _0740_ _0757_ VGND VGND VPWR VPWR _0758_ sky130_fd_sc_hd__or2_1
X_1743_ _0809_ _0826_ VGND VGND VPWR VPWR _0827_ sky130_fd_sc_hd__nand2_1
XFILLER_0_7_57 VPWR VGND VPWR VGND sky130_ef_sc_hd__decap_12
X_1812_ _0790_ _0875_ VGND VGND VPWR VPWR _0896_ sky130_fd_sc_hd__nand2_1
XFILLER_0_68_65 VPWR VGND VPWR VGND sky130_ef_sc_hd__decap_12
X_2226_ net51 _1309_ net57 VGND VGND VPWR VPWR _1310_ sky130_fd_sc_hd__mux2_1
X_2088_ _1091_ _1170_ _1171_ VGND VGND VPWR VPWR _1172_ sky130_fd_sc_hd__or3_4
X_2157_ _1128_ _1124_ _1240_ _1021_ VGND VGND VPWR VPWR _1241_ sky130_fd_sc_hd__o211a_1
XFILLER_0_63_337 VGND VGND VPWR VPWR sky130_fd_sc_hd__decap_8
XFILLER_0_16_253 VGND VGND VPWR VPWR sky130_fd_sc_hd__decap_3
XFILLER_0_54_315 VGND VGND VPWR VPWR sky130_fd_sc_hd__fill_1
XTAP_TAPCELL_ROW_42_446 VGND VPWR sky130_fd_sc_hd__tapvpwrvgnd_1
XFILLER_0_39_389 VGND VGND VPWR VPWR sky130_fd_sc_hd__decap_3
XFILLER_0_13_27 VGND VGND VPWR VPWR sky130_fd_sc_hd__fill_1
XFILLER_0_62_392 VPWR VGND VPWR VGND sky130_ef_sc_hd__decap_12
X_3060_ _0543_ _0676_ VGND VGND VPWR VPWR _0678_ sky130_fd_sc_hd__nand2_1
X_2011_ _1093_ _1094_ VGND VGND VPWR VPWR _1095_ sky130_fd_sc_hd__or2_1
XFILLER_0_57_186 VGND VGND VPWR VPWR sky130_fd_sc_hd__fill_1
XFILLER_0_57_164 VGND VGND VPWR VPWR sky130_fd_sc_hd__decap_4
XFILLER_0_57_131 VGND VGND VPWR VPWR sky130_fd_sc_hd__fill_1
X_2844_ _0462_ _0464_ _0374_ VGND VGND VPWR VPWR _0465_ sky130_fd_sc_hd__mux2_2
X_2913_ _0496_ _0533_ _0372_ VGND VGND VPWR VPWR _0534_ sky130_fd_sc_hd__mux2_2
X_2775_ _0385_ net91 _0335_ VGND VGND VPWR VPWR _0392_ sky130_fd_sc_hd__a21o_1
X_1657_ _0736_ _0728_ _0739_ VGND VGND VPWR VPWR _0741_ sky130_fd_sc_hd__or3_1
X_1726_ _0778_ _0785_ _0762_ _0144_ _0773_ VGND VGND VPWR VPWR _0810_ sky130_fd_sc_hd__o221ai_1
XFILLER_0_13_223 VGND VGND VPWR VPWR sky130_fd_sc_hd__fill_1
X_1588_ net10 net14 VGND VGND VPWR VPWR _0451_ sky130_fd_sc_hd__nand2_2
X_2209_ _1289_ _1291_ VGND VGND VPWR VPWR _1293_ sky130_fd_sc_hd__or2_1
XFILLER_0_5_3 VPWR VGND VPWR VGND sky130_ef_sc_hd__decap_12
XFILLER_0_24_26 VGND VGND VPWR VPWR sky130_fd_sc_hd__fill_2
XFILLER_0_39_142 VGND VGND VPWR VPWR sky130_fd_sc_hd__decap_8
XFILLER_0_27_337 VGND VGND VPWR VPWR sky130_fd_sc_hd__decap_8
XFILLER_0_50_340 VGND VGND VPWR VPWR sky130_fd_sc_hd__decap_6
X_2491_ _0073_ _0079_ _0072_ VGND VGND VPWR VPWR _0080_ sky130_fd_sc_hd__a21o_1
X_2560_ _1189_ _1186_ VGND VGND VPWR VPWR _0156_ sky130_fd_sc_hd__and2b_1
XFILLER_0_35_370 VGND VGND VPWR VPWR sky130_fd_sc_hd__decap_3
XFILLER_0_10_204 VGND VGND VPWR VPWR sky130_fd_sc_hd__decap_4
XFILLER_0_65_55 VGND VGND VPWR VPWR sky130_fd_sc_hd__fill_1
XFILLER_0_4_36 VPWR VGND VPWR VGND sky130_ef_sc_hd__decap_12
X_3112_ clknet_2_2__leaf_clock _0029_ VGND VGND VPWR VPWR net42 sky130_fd_sc_hd__dfxtp_1
X_3043_ _0501_ _0659_ _0660_ _0523_ VGND VGND VPWR VPWR _0027_ sky130_fd_sc_hd__o211a_1
XTAP_TAPCELL_ROW_53_519 VGND VPWR sky130_fd_sc_hd__tapvpwrvgnd_1
XTAP_TAPCELL_ROW_18_273 VGND VPWR sky130_fd_sc_hd__tapvpwrvgnd_1
XFILLER_0_18_326 VPWR VGND VPWR VGND sky130_ef_sc_hd__decap_12
XTAP_TAPCELL_ROW_61_574 VGND VPWR sky130_fd_sc_hd__tapvpwrvgnd_1
X_2827_ _1412_ net69 net66 VGND VGND VPWR VPWR _0448_ sky130_fd_sc_hd__mux2_1
X_2758_ _0372_ VGND VGND VPWR VPWR _0373_ sky130_fd_sc_hd__inv_2
XFILLER_0_45_167 VGND VGND VPWR VPWR sky130_fd_sc_hd__fill_1
X_2689_ _0296_ _0294_ VGND VGND VPWR VPWR _0297_ sky130_fd_sc_hd__xor2_1
XFILLER_0_41_373 VGND VGND VPWR VPWR sky130_fd_sc_hd__decap_6
X_1709_ _0792_ _0762_ VGND VGND VPWR VPWR _0793_ sky130_fd_sc_hd__or2_1
XTAP_TAPCELL_ROW_69_641 VGND VPWR sky130_fd_sc_hd__tapvpwrvgnd_1
XTAP_TAPCELL_ROW_69_630 VGND VPWR sky130_fd_sc_hd__tapvpwrvgnd_1
XFILLER_0_68_204 VGND VGND VPWR VPWR sky130_fd_sc_hd__decap_8
XFILLER_0_59_259 VGND VGND VPWR VPWR sky130_fd_sc_hd__decap_8
XFILLER_0_59_237 VPWR VGND VPWR VGND sky130_ef_sc_hd__decap_12
X_2612_ _0135_ _1456_ _0097_ VGND VGND VPWR VPWR _0213_ sky130_fd_sc_hd__and3_1
XFILLER_0_51_57 VGND VGND VPWR VPWR sky130_fd_sc_hd__decap_4
XFILLER_0_42_137 VGND VGND VPWR VPWR sky130_fd_sc_hd__decap_3
XTAP_TAPCELL_ROW_15_254 VGND VPWR sky130_fd_sc_hd__tapvpwrvgnd_1
X_1991_ net43 _1056_ VGND VGND VPWR VPWR _1075_ sky130_fd_sc_hd__and2_1
X_2543_ _0136_ VGND VGND VPWR VPWR _0137_ sky130_fd_sc_hd__buf_2
X_2474_ _0059_ _0060_ VGND VGND VPWR VPWR _0061_ sky130_fd_sc_hd__and2_1
XTAP_TAPCELL_ROW_66_611 VGND VPWR sky130_fd_sc_hd__tapvpwrvgnd_1
X_3026_ _0630_ _0641_ VGND VGND VPWR VPWR _0643_ sky130_fd_sc_hd__and2_1
XFILLER_0_61_413 VGND VGND VPWR VPWR sky130_fd_sc_hd__fill_2
XFILLER_0_33_104 VGND VGND VPWR VPWR sky130_fd_sc_hd__decap_8
XFILLER_0_49_281 VPWR VGND VPWR VGND sky130_ef_sc_hd__decap_12
XTAP_TAPCELL_ROW_12_235 VGND VPWR sky130_fd_sc_hd__tapvpwrvgnd_1
XFILLER_0_21_49 VGND VGND VPWR VPWR sky130_fd_sc_hd__decap_6
XFILLER_0_32_192 VGND VGND VPWR VPWR sky130_fd_sc_hd__decap_4
XTAP_TAPCELL_ROW_20_290 VGND VPWR sky130_fd_sc_hd__tapvpwrvgnd_1
XFILLER_0_20_321 VGND VGND VPWR VPWR sky130_fd_sc_hd__decap_8
XFILLER_0_46_68 VGND VGND VPWR VPWR sky130_fd_sc_hd__decap_6
X_2190_ _1193_ _1273_ _1196_ VGND VGND VPWR VPWR _1274_ sky130_fd_sc_hd__a21o_1
XFILLER_0_1_15 VPWR VGND VPWR VGND sky130_ef_sc_hd__decap_12
XFILLER_0_7_337 VPWR VGND VPWR VGND sky130_ef_sc_hd__decap_12
X_1974_ _1056_ _1057_ VGND VGND VPWR VPWR _1058_ sky130_fd_sc_hd__or2_1
XFILLER_0_55_273 VGND VGND VPWR VPWR sky130_fd_sc_hd__decap_6
XFILLER_0_23_192 VGND VGND VPWR VPWR sky130_fd_sc_hd__decap_3
X_2526_ _1495_ _0112_ _0115_ _0114_ _0117_ VGND VGND VPWR VPWR _0118_ sky130_fd_sc_hd__o32a_1
X_2388_ _1321_ _1354_ VGND VGND VPWR VPWR _1474_ sky130_fd_sc_hd__nand2_2
X_2457_ _0039_ _0040_ VGND VGND VPWR VPWR _0042_ sky130_fd_sc_hd__or2_1
XFILLER_0_46_3 VPWR VGND VPWR VGND sky130_ef_sc_hd__decap_12
X_3009_ net37 _0441_ VGND VGND VPWR VPWR _0626_ sky130_fd_sc_hd__or2_1
XFILLER_0_61_221 VGND VGND VPWR VPWR sky130_fd_sc_hd__decap_3
XFILLER_0_14_192 VGND VGND VPWR VPWR sky130_fd_sc_hd__decap_4
XFILLER_0_69_321 VPWR VGND VPWR VGND sky130_ef_sc_hd__decap_12
XFILLER_0_69_365 VPWR VGND VPWR VGND sky130_ef_sc_hd__decap_12
XFILLER_0_37_240 VPWR VGND VPWR VGND sky130_ef_sc_hd__decap_12
XFILLER_0_32_15 VPWR VGND VPWR VGND sky130_ef_sc_hd__decap_12
X_1690_ _0144_ _0773_ _0762_ VGND VGND VPWR VPWR _0774_ sky130_fd_sc_hd__or3_4
X_2242_ _1324_ _1325_ _1271_ VGND VGND VPWR VPWR _1326_ sky130_fd_sc_hd__a21o_1
X_2311_ net22 net56 _1170_ _1112_ VGND VGND VPWR VPWR _1395_ sky130_fd_sc_hd__and4_1
XFILLER_0_20_162 VGND VGND VPWR VPWR sky130_fd_sc_hd__decap_4
XFILLER_0_20_195 VGND VGND VPWR VPWR sky130_fd_sc_hd__fill_1
XTAP_TAPCELL_ROW_48_485 VGND VPWR sky130_fd_sc_hd__tapvpwrvgnd_1
X_2173_ _1196_ _1193_ _1256_ VGND VGND VPWR VPWR _1257_ sky130_fd_sc_hd__and3_1
XFILLER_0_28_251 VGND VGND VPWR VPWR sky130_fd_sc_hd__fill_1
X_1957_ _1040_ _1023_ _1036_ VGND VGND VPWR VPWR _1041_ sky130_fd_sc_hd__a21o_1
XTAP_TAPCELL_ROW_23_308 VGND VPWR sky130_fd_sc_hd__tapvpwrvgnd_1
XFILLER_0_7_156 VGND VGND VPWR VPWR sky130_fd_sc_hd__decap_4
XFILLER_0_16_402 VGND VGND VPWR VPWR sky130_fd_sc_hd__decap_8
X_2509_ _1456_ _0090_ _0097_ _0098_ _1472_ VGND VGND VPWR VPWR _0099_ sky130_fd_sc_hd__a311o_1
Xoutput29 net29 VGND VGND VPWR VPWR io_accOut[16] sky130_fd_sc_hd__buf_2
XFILLER_0_31_405 VGND VGND VPWR VPWR sky130_fd_sc_hd__fill_2
XFILLER_0_3_373 VPWR VGND VPWR VGND sky130_ef_sc_hd__decap_12
X_1888_ _0947_ _0971_ VGND VGND VPWR VPWR _0972_ sky130_fd_sc_hd__or2_1
XFILLER_0_66_324 VGND VGND VPWR VPWR sky130_fd_sc_hd__fill_1
XFILLER_0_57_302 VPWR VGND VPWR VGND sky130_ef_sc_hd__decap_12
X_2791_ _0409_ _0334_ _0329_ VGND VGND VPWR VPWR _0410_ sky130_fd_sc_hd__a21bo_1
XTAP_TAPCELL_ROW_45_466 VGND VPWR sky130_fd_sc_hd__tapvpwrvgnd_1
X_2860_ net19 net21 VGND VGND VPWR VPWR _0481_ sky130_fd_sc_hd__nor2_1
X_1811_ _0884_ _0885_ _0894_ VGND VGND VPWR VPWR _0895_ sky130_fd_sc_hd__a21oi_2
XFILLER_0_68_77 VGND VGND VPWR VPWR sky130_fd_sc_hd__decap_6
X_1742_ _0778_ _0772_ _0784_ _0144_ _0808_ VGND VGND VPWR VPWR _0826_ sky130_fd_sc_hd__o221ai_1
X_1673_ _0755_ _0756_ VGND VGND VPWR VPWR _0757_ sky130_fd_sc_hd__nand2_1
XFILLER_0_0_321 VPWR VGND VPWR VGND sky130_ef_sc_hd__decap_12
XFILLER_0_7_69 VGND VGND VPWR VPWR sky130_fd_sc_hd__decap_6
XFILLER_0_13_405 VGND VGND VPWR VPWR sky130_fd_sc_hd__decap_8
X_2225_ net81 _1212_ VGND VGND VPWR VPWR _1309_ sky130_fd_sc_hd__nor2_1
XFILLER_0_0_365 VPWR VGND VPWR VGND sky130_ef_sc_hd__decap_12
XTAP_TAPCELL_ROW_36_400 VGND VPWR sky130_fd_sc_hd__tapvpwrvgnd_1
X_2087_ _1168_ VGND VGND VPWR VPWR _1171_ sky130_fd_sc_hd__inv_2
X_2156_ _1011_ _1140_ VGND VGND VPWR VPWR _1240_ sky130_fd_sc_hd__nand2_1
XPHY_EDGE_ROW_5_Right_5 VGND VGND VPWR VPWR sky130_fd_sc_hd__decap_3
XFILLER_0_63_349 VPWR VGND VPWR VGND sky130_ef_sc_hd__decap_12
X_2989_ _0376_ _0580_ _0606_ _0315_ VGND VGND VPWR VPWR _0607_ sky130_fd_sc_hd__a211o_1
XPHY_EDGE_ROW_39_Left_109 VGND VGND VPWR VPWR sky130_fd_sc_hd__decap_3
XFILLER_0_16_221 VPWR VGND VPWR VGND sky130_ef_sc_hd__decap_12
XFILLER_0_31_279 VGND VGND VPWR VPWR sky130_fd_sc_hd__fill_1
XFILLER_0_3_181 VPWR VGND VPWR VGND sky130_ef_sc_hd__decap_12
XPHY_EDGE_ROW_48_Left_118 VGND VGND VPWR VPWR sky130_fd_sc_hd__decap_3
XPHY_EDGE_ROW_57_Left_127 VGND VGND VPWR VPWR sky130_fd_sc_hd__decap_3
XTAP_TAPCELL_ROW_42_447 VGND VPWR sky130_fd_sc_hd__tapvpwrvgnd_1
XFILLER_0_39_335 VGND VGND VPWR VPWR sky130_fd_sc_hd__fill_1
XFILLER_0_22_224 VGND VGND VPWR VPWR sky130_fd_sc_hd__fill_1
XPHY_EDGE_ROW_66_Left_136 VGND VGND VPWR VPWR sky130_fd_sc_hd__decap_3
X_2010_ _1086_ _1068_ VGND VGND VPWR VPWR _1094_ sky130_fd_sc_hd__and2b_1
X_2912_ _0447_ _0516_ _0532_ VGND VGND VPWR VPWR _0533_ sky130_fd_sc_hd__o21ai_2
XFILLER_0_60_319 VGND VGND VPWR VPWR sky130_fd_sc_hd__fill_1
XFILLER_0_57_198 VGND VGND VPWR VPWR sky130_fd_sc_hd__fill_1
XFILLER_0_57_176 VGND VGND VPWR VPWR sky130_fd_sc_hd__fill_1
XFILLER_0_53_393 VGND VGND VPWR VPWR sky130_fd_sc_hd__decap_8
X_2774_ _0390_ _0389_ _0167_ VGND VGND VPWR VPWR _0391_ sky130_fd_sc_hd__mux2_4
X_2843_ _0443_ _0463_ _0401_ VGND VGND VPWR VPWR _0464_ sky130_fd_sc_hd__mux2_2
XFILLER_0_45_305 VPWR VGND VPWR VGND sky130_ef_sc_hd__decap_12
X_1725_ _0144_ _0784_ _0808_ VGND VGND VPWR VPWR _0809_ sky130_fd_sc_hd__or3_4
XFILLER_0_5_413 VGND VGND VPWR VPWR sky130_fd_sc_hd__fill_2
X_1656_ _0736_ _0728_ _0739_ VGND VGND VPWR VPWR _0740_ sky130_fd_sc_hd__o21ai_1
XFILLER_0_0_151 VGND VGND VPWR VPWR sky130_fd_sc_hd__decap_6
X_1587_ _0243_ _0199_ VGND VGND VPWR VPWR _0440_ sky130_fd_sc_hd__nand2_1
X_2208_ _1289_ _1291_ VGND VGND VPWR VPWR _1292_ sky130_fd_sc_hd__nand2_2
XTAP_TAPCELL_ROW_56_539 VGND VPWR sky130_fd_sc_hd__tapvpwrvgnd_1
X_2139_ _1161_ _1151_ _1128_ VGND VGND VPWR VPWR _1223_ sky130_fd_sc_hd__mux2_1
XFILLER_0_63_113 VPWR VGND VPWR VGND sky130_ef_sc_hd__decap_12
XFILLER_0_48_176 VGND VGND VPWR VPWR sky130_fd_sc_hd__decap_6
XFILLER_0_36_305 VGND VGND VPWR VPWR sky130_fd_sc_hd__decap_3
XFILLER_0_8_273 VGND VGND VPWR VPWR sky130_fd_sc_hd__fill_1
XFILLER_0_39_110 VGND VGND VPWR VPWR sky130_fd_sc_hd__fill_2
XFILLER_0_39_165 VGND VGND VPWR VPWR sky130_fd_sc_hd__decap_3
XFILLER_0_40_15 VPWR VGND VPWR VGND sky130_ef_sc_hd__decap_12
XFILLER_0_35_393 VGND VGND VPWR VPWR sky130_fd_sc_hd__decap_3
X_2490_ _1099_ _1103_ _1502_ _0065_ VGND VGND VPWR VPWR _0079_ sky130_fd_sc_hd__o31a_1
XFILLER_0_50_363 VGND VGND VPWR VPWR sky130_fd_sc_hd__fill_1
XFILLER_0_4_15 VGND VGND VPWR VPWR sky130_fd_sc_hd__fill_1
X_3042_ net40 _0441_ VGND VGND VPWR VPWR _0660_ sky130_fd_sc_hd__or2_1
XFILLER_0_4_48 VPWR VGND VPWR VGND sky130_ef_sc_hd__decap_12
XFILLER_0_4_26 VGND VGND VPWR VPWR sky130_fd_sc_hd__fill_2
X_3111_ clknet_2_2__leaf_clock _0028_ VGND VGND VPWR VPWR net41 sky130_fd_sc_hd__dfxtp_1
XTAP_TAPCELL_ROW_61_575 VGND VPWR sky130_fd_sc_hd__tapvpwrvgnd_1
XTAP_TAPCELL_ROW_18_274 VGND VPWR sky130_fd_sc_hd__tapvpwrvgnd_1
XFILLER_0_18_338 VGND VGND VPWR VPWR sky130_fd_sc_hd__fill_1
X_2826_ _0446_ VGND VGND VPWR VPWR _0447_ sky130_fd_sc_hd__buf_2
X_2688_ _0289_ _0169_ VGND VGND VPWR VPWR _0296_ sky130_fd_sc_hd__nor2_2
X_2757_ _0371_ VGND VGND VPWR VPWR _0372_ sky130_fd_sc_hd__buf_6
XFILLER_0_45_179 VGND VGND VPWR VPWR sky130_fd_sc_hd__fill_1
XFILLER_0_45_157 VGND VGND VPWR VPWR sky130_fd_sc_hd__fill_1
XFILLER_0_41_341 VGND VGND VPWR VPWR sky130_fd_sc_hd__fill_1
XFILLER_0_41_330 VGND VGND VPWR VPWR sky130_fd_sc_hd__decap_6
X_1708_ _0791_ VGND VGND VPWR VPWR _0792_ sky130_fd_sc_hd__buf_2
XTAP_TAPCELL_ROW_69_642 VGND VPWR sky130_fd_sc_hd__tapvpwrvgnd_1
XTAP_TAPCELL_ROW_69_631 VGND VPWR sky130_fd_sc_hd__tapvpwrvgnd_1
X_1639_ _0716_ _0265_ net13 VGND VGND VPWR VPWR _0723_ sky130_fd_sc_hd__o21ai_2
XFILLER_0_68_227 VGND VGND VPWR VPWR sky130_fd_sc_hd__decap_8
XFILLER_0_36_113 VGND VGND VPWR VPWR sky130_fd_sc_hd__fill_1
XFILLER_0_32_374 VGND VGND VPWR VPWR sky130_fd_sc_hd__fill_1
XFILLER_0_32_363 VGND VGND VPWR VPWR sky130_fd_sc_hd__fill_1
XFILLER_0_10_29 VGND VGND VPWR VPWR sky130_fd_sc_hd__decap_6
XFILLER_0_17_393 VPWR VGND VPWR VGND sky130_ef_sc_hd__decap_12
XFILLER_0_35_15 VPWR VGND VPWR VGND sky130_ef_sc_hd__decap_12
XFILLER_0_59_249 VGND VGND VPWR VPWR sky130_fd_sc_hd__decap_6
XFILLER_0_27_113 VGND VGND VPWR VPWR sky130_fd_sc_hd__decap_4
XTAP_TAPCELL_ROW_15_255 VGND VPWR sky130_fd_sc_hd__tapvpwrvgnd_1
X_1990_ net43 _1056_ VGND VGND VPWR VPWR _1074_ sky130_fd_sc_hd__or2_1
X_2542_ _0135_ VGND VGND VPWR VPWR _0136_ sky130_fd_sc_hd__buf_2
X_2611_ _0135_ _1468_ VGND VGND VPWR VPWR _0212_ sky130_fd_sc_hd__nor2_1
XFILLER_0_23_352 VGND VGND VPWR VPWR sky130_fd_sc_hd__decap_6
XFILLER_0_50_193 VGND VGND VPWR VPWR sky130_fd_sc_hd__decap_3
X_2473_ net34 _1255_ _1188_ VGND VGND VPWR VPWR _0060_ sky130_fd_sc_hd__mux2_1
XTAP_TAPCELL_ROW_66_612 VGND VPWR sky130_fd_sc_hd__tapvpwrvgnd_1
X_3025_ _0630_ _0641_ VGND VGND VPWR VPWR _0642_ sky130_fd_sc_hd__nor2_1
XFILLER_0_25_92 VGND VGND VPWR VPWR sky130_fd_sc_hd__decap_8
XFILLER_0_18_157 VGND VGND VPWR VPWR sky130_fd_sc_hd__decap_8
X_2809_ _0425_ VGND VGND VPWR VPWR _0429_ sky130_fd_sc_hd__buf_6
XFILLER_0_49_293 VPWR VGND VPWR VGND sky130_ef_sc_hd__decap_12
XFILLER_0_52_403 VGND VGND VPWR VPWR sky130_fd_sc_hd__decap_8
XFILLER_0_24_138 VGND VGND VPWR VPWR sky130_fd_sc_hd__fill_2
XTAP_TAPCELL_ROW_12_236 VGND VPWR sky130_fd_sc_hd__tapvpwrvgnd_1
XTAP_TAPCELL_ROW_20_291 VGND VPWR sky130_fd_sc_hd__tapvpwrvgnd_1
XFILLER_0_1_27 VGND VGND VPWR VPWR sky130_fd_sc_hd__decap_8
XFILLER_0_43_414 VGND VGND VPWR VPWR sky130_fd_sc_hd__fill_1
X_1973_ _1050_ _1030_ VGND VGND VPWR VPWR _1057_ sky130_fd_sc_hd__xnor2_1
XFILLER_0_7_349 VPWR VGND VPWR VGND sky130_ef_sc_hd__decap_12
XFILLER_0_15_105 VGND VGND VPWR VPWR sky130_fd_sc_hd__fill_2
X_2525_ _0037_ _0116_ _1264_ _0036_ VGND VGND VPWR VPWR _0117_ sky130_fd_sc_hd__a31oi_1
XFILLER_0_11_83 VGND VGND VPWR VPWR sky130_fd_sc_hd__fill_1
X_2456_ _0039_ _0040_ VGND VGND VPWR VPWR _0041_ sky130_fd_sc_hd__and2_1
X_2387_ _1471_ _1472_ VGND VGND VPWR VPWR _1473_ sky130_fd_sc_hd__nor2_1
XFILLER_0_39_3 VPWR VGND VPWR VGND sky130_ef_sc_hd__decap_12
X_3008_ _0623_ _0624_ VGND VGND VPWR VPWR _0625_ sky130_fd_sc_hd__and2_1
XFILLER_0_61_277 VGND VGND VPWR VPWR sky130_fd_sc_hd__decap_3
XFILLER_0_21_108 VGND VGND VPWR VPWR sky130_fd_sc_hd__decap_4
XFILLER_0_69_333 VGND VGND VPWR VPWR sky130_fd_sc_hd__decap_3
XFILLER_0_69_377 VPWR VGND VPWR VGND sky130_ef_sc_hd__decap_12
XFILLER_0_52_211 VGND VGND VPWR VPWR sky130_fd_sc_hd__decap_8
XFILLER_0_37_252 VPWR VGND VPWR VGND sky130_ef_sc_hd__decap_12
XFILLER_0_32_49 VGND VGND VPWR VPWR sky130_fd_sc_hd__fill_2
XFILLER_0_32_27 VGND VGND VPWR VPWR sky130_fd_sc_hd__fill_1
XFILLER_0_29_219 VGND VGND VPWR VPWR sky130_fd_sc_hd__decap_4
XFILLER_0_52_266 VPWR VGND VPWR VGND sky130_ef_sc_hd__decap_12
XFILLER_0_20_141 VPWR VGND VPWR VGND sky130_ef_sc_hd__decap_12
XFILLER_0_57_57 VPWR VGND VPWR VGND sky130_ef_sc_hd__decap_12
X_2172_ net34 _1255_ net57 VGND VGND VPWR VPWR _1256_ sky130_fd_sc_hd__mux2_1
X_2241_ _1146_ _1238_ _1219_ VGND VGND VPWR VPWR _1325_ sky130_fd_sc_hd__a21o_1
X_2310_ _1314_ _1311_ _1173_ _1393_ _1247_ VGND VGND VPWR VPWR _1394_ sky130_fd_sc_hd__a311o_1
XPHY_EDGE_ROW_27_Left_97 VGND VGND VPWR VPWR sky130_fd_sc_hd__decap_3
XTAP_TAPCELL_ROW_48_486 VGND VPWR sky130_fd_sc_hd__tapvpwrvgnd_1
XTAP_TAPCELL_ROW_23_309 VGND VPWR sky130_fd_sc_hd__tapvpwrvgnd_1
XFILLER_0_43_277 VGND VGND VPWR VPWR sky130_fd_sc_hd__decap_3
XFILLER_0_43_233 VGND VGND VPWR VPWR sky130_fd_sc_hd__decap_6
XTAP_TAPCELL_ROW_31_364 VGND VPWR sky130_fd_sc_hd__tapvpwrvgnd_1
X_1956_ _1033_ _1019_ VGND VGND VPWR VPWR _1040_ sky130_fd_sc_hd__nand2_1
X_1887_ _0647_ _0763_ _0778_ _0887_ VGND VGND VPWR VPWR _0971_ sky130_fd_sc_hd__a2bb2oi_1
X_2508_ _1467_ _1475_ VGND VGND VPWR VPWR _0098_ sky130_fd_sc_hd__nor2_1
XFILLER_0_43_299 VGND VGND VPWR VPWR sky130_fd_sc_hd__decap_6
XFILLER_0_3_385 VGND VGND VPWR VPWR sky130_fd_sc_hd__decap_6
X_2439_ net28 _1214_ _1187_ VGND VGND VPWR VPWR _1529_ sky130_fd_sc_hd__mux2_1
XTAP_TAPCELL_ROW_39_420 VGND VPWR sky130_fd_sc_hd__tapvpwrvgnd_1
XFILLER_0_19_241 VGND VGND VPWR VPWR sky130_fd_sc_hd__decap_6
XFILLER_0_34_288 VPWR VGND VPWR VGND sky130_ef_sc_hd__decap_12
XFILLER_0_22_406 VGND VGND VPWR VPWR sky130_fd_sc_hd__decap_4
XFILLER_0_69_141 VPWR VGND VPWR VGND sky130_ef_sc_hd__decap_12
XFILLER_0_57_314 VGND VGND VPWR VPWR sky130_fd_sc_hd__decap_4
XTAP_TAPCELL_ROW_45_467 VGND VPWR sky130_fd_sc_hd__tapvpwrvgnd_1
XFILLER_0_43_15 VPWR VGND VPWR VGND sky130_ef_sc_hd__decap_12
XFILLER_0_65_391 VGND VGND VPWR VPWR sky130_fd_sc_hd__fill_1
X_2790_ _0333_ _0382_ _0407_ _0391_ _0384_ VGND VGND VPWR VPWR _0409_ sky130_fd_sc_hd__a221o_1
XFILLER_0_25_244 VGND VGND VPWR VPWR sky130_fd_sc_hd__fill_1
XFILLER_0_4_138 VGND VGND VPWR VPWR sky130_fd_sc_hd__fill_2
X_1741_ _0144_ _0824_ _0785_ VGND VGND VPWR VPWR _0825_ sky130_fd_sc_hd__or3_4
X_1810_ _0886_ _0892_ _0893_ VGND VGND VPWR VPWR _0894_ sky130_fd_sc_hd__a21o_1
XFILLER_0_40_269 VGND VGND VPWR VPWR sky130_fd_sc_hd__decap_8
X_1672_ _0753_ _0754_ VGND VGND VPWR VPWR _0756_ sky130_fd_sc_hd__or2_1
XFILLER_0_0_377 VPWR VGND VPWR VGND sky130_ef_sc_hd__decap_12
XFILLER_0_0_333 VGND VGND VPWR VPWR sky130_fd_sc_hd__decap_3
XFILLER_0_7_15 VPWR VGND VPWR VGND sky130_ef_sc_hd__decap_12
XFILLER_0_7_48 VGND VGND VPWR VPWR sky130_fd_sc_hd__decap_3
X_2224_ _1274_ _1277_ _1271_ VGND VGND VPWR VPWR _1308_ sky130_fd_sc_hd__a21o_1
XTAP_TAPCELL_ROW_36_401 VGND VPWR sky130_fd_sc_hd__tapvpwrvgnd_1
X_2155_ _1207_ _1238_ _1196_ VGND VGND VPWR VPWR _1239_ sky130_fd_sc_hd__a21o_1
XFILLER_0_63_317 VGND VGND VPWR VPWR sky130_fd_sc_hd__decap_4
XFILLER_0_48_336 VGND VGND VPWR VPWR sky130_fd_sc_hd__fill_2
XFILLER_0_33_70 VGND VGND VPWR VPWR sky130_fd_sc_hd__decap_8
X_2086_ _1043_ _1083_ VGND VGND VPWR VPWR _1170_ sky130_fd_sc_hd__and2_2
X_2988_ _0589_ _0605_ _0458_ VGND VGND VPWR VPWR _0606_ sky130_fd_sc_hd__mux2_1
XFILLER_0_31_225 VGND VGND VPWR VPWR sky130_fd_sc_hd__fill_1
X_1939_ _0998_ _1022_ VGND VGND VPWR VPWR _1023_ sky130_fd_sc_hd__nor2_1
XFILLER_0_16_233 VGND VGND VPWR VPWR sky130_fd_sc_hd__decap_4
XFILLER_0_16_244 VGND VGND VPWR VPWR sky130_fd_sc_hd__decap_8
XFILLER_0_16_277 VGND VGND VPWR VPWR sky130_fd_sc_hd__fill_2
XFILLER_0_3_193 VGND VGND VPWR VPWR sky130_fd_sc_hd__decap_6
XFILLER_0_66_100 VGND VGND VPWR VPWR sky130_fd_sc_hd__decap_8
XFILLER_0_62_361 VGND VGND VPWR VPWR sky130_fd_sc_hd__decap_3
XFILLER_0_62_350 VGND VGND VPWR VPWR sky130_fd_sc_hd__decap_4
XPHY_EDGE_ROW_11_Right_11 VGND VGND VPWR VPWR sky130_fd_sc_hd__decap_3
XFILLER_0_38_15 VPWR VGND VPWR VGND sky130_ef_sc_hd__decap_12
XPHY_EDGE_ROW_20_Right_20 VGND VGND VPWR VPWR sky130_fd_sc_hd__decap_3
XFILLER_0_57_155 VGND VGND VPWR VPWR sky130_fd_sc_hd__decap_3
X_2911_ _0447_ _0531_ VGND VGND VPWR VPWR _0532_ sky130_fd_sc_hd__nand2_1
XFILLER_0_53_350 VGND VGND VPWR VPWR sky130_fd_sc_hd__decap_8
X_2773_ _0387_ _0389_ _0330_ VGND VGND VPWR VPWR _0390_ sky130_fd_sc_hd__o21bai_1
X_2842_ _0448_ VGND VGND VPWR VPWR _0463_ sky130_fd_sc_hd__inv_2
X_1724_ _0768_ _0807_ VGND VGND VPWR VPWR _0808_ sky130_fd_sc_hd__or2_1
XFILLER_0_13_225 VPWR VGND VPWR VGND sky130_ef_sc_hd__decap_12
X_1655_ _0723_ _0738_ VGND VGND VPWR VPWR _0739_ sky130_fd_sc_hd__xor2_1
XFILLER_0_0_141 VGND VGND VPWR VPWR sky130_fd_sc_hd__decap_3
XFILLER_0_0_163 VGND VGND VPWR VPWR sky130_fd_sc_hd__decap_4
X_1586_ _0276_ _0309_ VGND VGND VPWR VPWR _0430_ sky130_fd_sc_hd__or2_1
X_2207_ _1290_ VGND VGND VPWR VPWR _1291_ sky130_fd_sc_hd__inv_2
X_2138_ _1176_ VGND VGND VPWR VPWR _1222_ sky130_fd_sc_hd__clkbuf_4
XFILLER_0_28_92 VPWR VGND VPWR VGND sky130_ef_sc_hd__decap_12
X_2069_ _0971_ _1115_ _1152_ VGND VGND VPWR VPWR _1153_ sky130_fd_sc_hd__o21ai_1
XTAP_TAPCELL_ROW_64_595 VGND VPWR sky130_fd_sc_hd__tapvpwrvgnd_1
XFILLER_0_63_169 VGND VGND VPWR VPWR sky130_fd_sc_hd__decap_8
XFILLER_0_63_125 VPWR VGND VPWR VGND sky130_ef_sc_hd__decap_12
XFILLER_0_48_188 VGND VGND VPWR VPWR sky130_fd_sc_hd__decap_8
XFILLER_0_48_144 VGND VGND VPWR VPWR sky130_fd_sc_hd__fill_2
XFILLER_0_29_391 VGND VGND VPWR VPWR sky130_fd_sc_hd__fill_1
XFILLER_0_8_241 VGND VGND VPWR VPWR sky130_fd_sc_hd__decap_8
XFILLER_0_8_296 VPWR VGND VPWR VGND sky130_ef_sc_hd__decap_12
XPHY_EDGE_ROW_14_Left_84 VGND VGND VPWR VPWR sky130_fd_sc_hd__decap_3
XFILLER_0_27_317 VGND VGND VPWR VPWR sky130_fd_sc_hd__fill_1
XFILLER_0_42_309 VPWR VGND VPWR VGND sky130_ef_sc_hd__decap_12
XFILLER_0_40_49 VPWR VGND VPWR VGND sky130_ef_sc_hd__decap_12
XFILLER_0_40_27 VGND VGND VPWR VPWR sky130_fd_sc_hd__fill_1
XFILLER_0_50_353 VGND VGND VPWR VPWR sky130_fd_sc_hd__fill_2
X_3110_ clknet_2_2__leaf_clock _0027_ VGND VGND VPWR VPWR net40 sky130_fd_sc_hd__dfxtp_1
XFILLER_0_10_228 VGND VGND VPWR VPWR sky130_fd_sc_hd__fill_1
XFILLER_0_65_57 VPWR VGND VPWR VGND sky130_ef_sc_hd__decap_12
X_3041_ _0649_ _0658_ VGND VGND VPWR VPWR _0659_ sky130_fd_sc_hd__xnor2_1
XTAP_TAPCELL_ROW_61_576 VGND VPWR sky130_fd_sc_hd__tapvpwrvgnd_1
X_2825_ _0445_ VGND VGND VPWR VPWR _0446_ sky130_fd_sc_hd__buf_2
XFILLER_0_5_211 VPWR VGND VPWR VGND sky130_ef_sc_hd__decap_12
XFILLER_0_14_72 VGND VGND VPWR VPWR sky130_fd_sc_hd__fill_2
XTAP_TAPCELL_ROW_18_275 VGND VPWR sky130_fd_sc_hd__tapvpwrvgnd_1
XFILLER_0_69_3 VPWR VGND VPWR VGND sky130_ef_sc_hd__decap_12
X_2756_ _0288_ _0299_ _0370_ VGND VGND VPWR VPWR _0371_ sky130_fd_sc_hd__or3b_4
X_2687_ _0165_ _0289_ _0294_ VGND VGND VPWR VPWR _0295_ sky130_fd_sc_hd__and3b_1
XFILLER_0_30_93 VGND VGND VPWR VPWR sky130_fd_sc_hd__fill_1
X_1638_ _0716_ _0265_ VGND VGND VPWR VPWR _0722_ sky130_fd_sc_hd__nor2_1
XFILLER_0_5_244 VGND VGND VPWR VPWR sky130_fd_sc_hd__decap_8
X_1707_ _0790_ _0768_ VGND VGND VPWR VPWR _0791_ sky130_fd_sc_hd__nand2_1
XTAP_TAPCELL_ROW_69_643 VGND VPWR sky130_fd_sc_hd__tapvpwrvgnd_1
XTAP_TAPCELL_ROW_69_632 VGND VPWR sky130_fd_sc_hd__tapvpwrvgnd_1
X_1569_ net11 VGND VGND VPWR VPWR _0243_ sky130_fd_sc_hd__buf_2
XTAP_TAPCELL_ROW_1_154 VGND VPWR sky130_fd_sc_hd__tapvpwrvgnd_1
XFILLER_0_51_128 VGND VGND VPWR VPWR sky130_fd_sc_hd__fill_1
XFILLER_0_10_19 VGND VGND VPWR VPWR sky130_fd_sc_hd__fill_1
XTAP_TAPCELL_ROW_9_210 VGND VPWR sky130_fd_sc_hd__tapvpwrvgnd_1
XFILLER_0_35_27 VPWR VGND VPWR VGND sky130_ef_sc_hd__decap_12
XFILLER_0_67_294 VGND VGND VPWR VPWR sky130_fd_sc_hd__fill_2
XFILLER_0_67_261 VGND VGND VPWR VPWR sky130_fd_sc_hd__decap_6
XFILLER_0_67_250 VGND VGND VPWR VPWR sky130_fd_sc_hd__decap_3
XFILLER_0_51_15 VPWR VGND VPWR VGND sky130_ef_sc_hd__decap_12
XTAP_TAPCELL_ROW_15_256 VGND VPWR sky130_fd_sc_hd__tapvpwrvgnd_1
X_2610_ _0202_ _0209_ VGND VGND VPWR VPWR _0211_ sky130_fd_sc_hd__or2b_1
XFILLER_0_50_161 VPWR VGND VPWR VGND sky130_ef_sc_hd__decap_12
X_2472_ _1098_ _1460_ VGND VGND VPWR VPWR _0059_ sky130_fd_sc_hd__or2_1
XFILLER_0_42_117 VGND VGND VPWR VPWR sky130_fd_sc_hd__decap_8
XFILLER_0_35_191 VGND VGND VPWR VPWR sky130_fd_sc_hd__decap_4
X_2541_ net46 _0134_ VGND VGND VPWR VPWR _0135_ sky130_fd_sc_hd__xnor2_4
XFILLER_0_23_364 VGND VGND VPWR VPWR sky130_fd_sc_hd__fill_1
XFILLER_0_2_269 VGND VGND VPWR VPWR sky130_fd_sc_hd__decap_4
XFILLER_0_2_236 VGND VGND VPWR VPWR sky130_fd_sc_hd__decap_4
XTAP_TAPCELL_ROW_66_613 VGND VPWR sky130_fd_sc_hd__tapvpwrvgnd_1
XFILLER_0_25_82 VGND VGND VPWR VPWR sky130_fd_sc_hd__fill_1
X_3024_ _0639_ _0640_ VGND VGND VPWR VPWR _0641_ sky130_fd_sc_hd__nand2_1
X_2808_ _0401_ _0427_ VGND VGND VPWR VPWR _0428_ sky130_fd_sc_hd__nor2_1
XFILLER_0_41_81 VGND VGND VPWR VPWR sky130_fd_sc_hd__decap_4
X_2739_ _0233_ _0351_ VGND VGND VPWR VPWR _0352_ sky130_fd_sc_hd__xnor2_2
XFILLER_0_5_81 VGND VGND VPWR VPWR sky130_fd_sc_hd__fill_2
XFILLER_0_64_253 VPWR VGND VPWR VGND sky130_ef_sc_hd__decap_12
XFILLER_0_64_286 VPWR VGND VPWR VGND sky130_ef_sc_hd__decap_12
XFILLER_0_9_391 VGND VGND VPWR VPWR sky130_fd_sc_hd__fill_1
XTAP_TAPCELL_ROW_12_237 VGND VPWR sky130_fd_sc_hd__tapvpwrvgnd_1
XTAP_TAPCELL_ROW_20_292 VGND VPWR sky130_fd_sc_hd__tapvpwrvgnd_1
XFILLER_0_46_59 VGND VGND VPWR VPWR sky130_fd_sc_hd__decap_3
XFILLER_0_46_15 VPWR VGND VPWR VGND sky130_ef_sc_hd__decap_12
XFILLER_0_47_209 VGND VGND VPWR VPWR sky130_fd_sc_hd__decap_8
XFILLER_0_1_39 VPWR VGND VPWR VGND sky130_ef_sc_hd__decap_12
X_1972_ _1042_ VGND VGND VPWR VPWR _1056_ sky130_fd_sc_hd__clkbuf_2
XFILLER_0_15_139 VGND VGND VPWR VPWR sky130_fd_sc_hd__decap_6
X_2524_ _1263_ VGND VGND VPWR VPWR _0116_ sky130_fd_sc_hd__inv_2
XPHY_EDGE_ROW_49_Right_49 VGND VGND VPWR VPWR sky130_fd_sc_hd__decap_3
X_2455_ net27 _1217_ _1187_ VGND VGND VPWR VPWR _0040_ sky130_fd_sc_hd__mux2_1
XPHY_EDGE_ROW_58_Right_58 VGND VGND VPWR VPWR sky130_fd_sc_hd__decap_3
X_2386_ _1352_ _1470_ VGND VGND VPWR VPWR _1472_ sky130_fd_sc_hd__nor2_1
XFILLER_0_52_80 VGND VGND VPWR VPWR sky130_fd_sc_hd__decap_4
XFILLER_0_38_209 VGND VGND VPWR VPWR sky130_fd_sc_hd__fill_1
X_3007_ net82 _0622_ VGND VGND VPWR VPWR _0624_ sky130_fd_sc_hd__or2_1
XTAP_TAPCELL_ROW_26_329 VGND VPWR sky130_fd_sc_hd__tapvpwrvgnd_1
XPHY_EDGE_ROW_67_Right_67 VGND VGND VPWR VPWR sky130_fd_sc_hd__decap_3
XFILLER_0_46_264 VGND VGND VPWR VPWR sky130_fd_sc_hd__fill_1
XFILLER_0_16_29 VGND VGND VPWR VPWR sky130_fd_sc_hd__decap_6
XFILLER_0_69_389 VGND VGND VPWR VPWR sky130_fd_sc_hd__decap_3
XFILLER_0_52_223 VPWR VGND VPWR VGND sky130_ef_sc_hd__decap_12
XFILLER_0_4_309 VPWR VGND VPWR VGND sky130_ef_sc_hd__decap_12
XFILLER_0_52_278 VGND VGND VPWR VPWR sky130_fd_sc_hd__fill_1
XPHY_EDGE_ROW_2_Left_72 VGND VGND VPWR VPWR sky130_fd_sc_hd__decap_3
XFILLER_0_57_69 VPWR VGND VPWR VGND sky130_ef_sc_hd__decap_12
X_2240_ _1146_ _1256_ _1323_ VGND VGND VPWR VPWR _1324_ sky130_fd_sc_hd__a21o_1
X_2171_ _1114_ _1202_ _1254_ VGND VGND VPWR VPWR _1255_ sky130_fd_sc_hd__o21bai_1
XFILLER_0_20_186 VGND VGND VPWR VPWR sky130_fd_sc_hd__fill_1
XFILLER_0_20_197 VPWR VGND VPWR VGND sky130_ef_sc_hd__decap_12
XTAP_TAPCELL_ROW_48_487 VGND VPWR sky130_fd_sc_hd__tapvpwrvgnd_1
XFILLER_0_43_289 VGND VGND VPWR VPWR sky130_fd_sc_hd__fill_2
XFILLER_0_43_223 VGND VGND VPWR VPWR sky130_fd_sc_hd__fill_1
XTAP_TAPCELL_ROW_31_365 VGND VPWR sky130_fd_sc_hd__tapvpwrvgnd_1
XFILLER_0_28_297 VGND VGND VPWR VPWR sky130_fd_sc_hd__decap_8
XFILLER_0_28_253 VGND VGND VPWR VPWR sky130_fd_sc_hd__decap_4
X_1955_ _1036_ _1038_ VGND VGND VPWR VPWR _1039_ sky130_fd_sc_hd__nor2b_4
XFILLER_0_7_169 VGND VGND VPWR VPWR sky130_fd_sc_hd__decap_6
X_1886_ _0954_ _0940_ VGND VGND VPWR VPWR _0970_ sky130_fd_sc_hd__nor2_1
X_2507_ _0093_ _0094_ _0095_ _1454_ _0096_ VGND VGND VPWR VPWR _0097_ sky130_fd_sc_hd__a311o_1
X_2438_ _1098_ _1428_ VGND VGND VPWR VPWR _1528_ sky130_fd_sc_hd__nor2_1
XFILLER_0_51_3 VPWR VGND VPWR VGND sky130_ef_sc_hd__decap_12
X_2369_ net47 _1093_ _1453_ VGND VGND VPWR VPWR _1454_ sky130_fd_sc_hd__and3_1
XTAP_TAPCELL_ROW_39_421 VGND VPWR sky130_fd_sc_hd__tapvpwrvgnd_1
XFILLER_0_34_212 VGND VGND VPWR VPWR sky130_fd_sc_hd__fill_1
XFILLER_0_19_220 VGND VGND VPWR VPWR sky130_fd_sc_hd__decap_4
XFILLER_0_19_275 VGND VGND VPWR VPWR sky130_fd_sc_hd__decap_4
XFILLER_0_34_256 VPWR VGND VPWR VGND sky130_ef_sc_hd__decap_12
XFILLER_0_69_197 VPWR VGND VPWR VGND sky130_ef_sc_hd__decap_12
XFILLER_0_69_153 VPWR VGND VPWR VGND sky130_ef_sc_hd__decap_12
XFILLER_0_57_337 VGND VGND VPWR VPWR sky130_fd_sc_hd__decap_8
XTAP_TAPCELL_ROW_45_468 VGND VPWR sky130_fd_sc_hd__tapvpwrvgnd_1
XFILLER_0_43_27 VPWR VGND VPWR VGND sky130_ef_sc_hd__decap_12
XFILLER_0_25_234 VGND VGND VPWR VPWR sky130_fd_sc_hd__fill_1
XFILLER_0_4_117 VGND VGND VPWR VPWR sky130_fd_sc_hd__decap_3
X_1671_ _0753_ _0754_ VGND VGND VPWR VPWR _0755_ sky130_fd_sc_hd__nand2_1
X_1740_ _0768_ _0823_ _0807_ _0778_ VGND VGND VPWR VPWR _0824_ sky130_fd_sc_hd__o22a_1
XFILLER_0_7_27 VGND VGND VPWR VPWR sky130_fd_sc_hd__fill_1
XFILLER_0_0_389 VGND VGND VPWR VPWR sky130_fd_sc_hd__decap_3
XFILLER_0_7_38 VGND VGND VPWR VPWR sky130_fd_sc_hd__fill_1
X_2223_ _1305_ _1306_ _1248_ VGND VGND VPWR VPWR _1307_ sky130_fd_sc_hd__a21o_1
XTAP_TAPCELL_ROW_36_402 VGND VPWR sky130_fd_sc_hd__tapvpwrvgnd_1
X_2154_ net32 _1237_ net58 VGND VGND VPWR VPWR _1238_ sky130_fd_sc_hd__mux2_2
X_2085_ _1077_ _1084_ _1168_ VGND VGND VPWR VPWR _1169_ sky130_fd_sc_hd__a21o_1
XFILLER_0_16_6 VGND VGND VPWR VPWR sky130_fd_sc_hd__decap_8
XFILLER_0_56_381 VGND VGND VPWR VPWR sky130_fd_sc_hd__fill_2
X_2987_ _0308_ _0279_ _0505_ VGND VGND VPWR VPWR _0605_ sky130_fd_sc_hd__mux2_4
XFILLER_0_8_401 VPWR VGND VPWR VGND sky130_ef_sc_hd__decap_12
X_1938_ _0981_ _0999_ _1001_ VGND VGND VPWR VPWR _1022_ sky130_fd_sc_hd__o21ai_1
X_1869_ _0941_ _0950_ _0952_ VGND VGND VPWR VPWR _0953_ sky130_fd_sc_hd__o21ba_1
XFILLER_0_16_289 VPWR VGND VPWR VGND sky130_ef_sc_hd__decap_12
XFILLER_0_39_337 VPWR VGND VPWR VGND sky130_ef_sc_hd__decap_12
XFILLER_0_13_19 VGND VGND VPWR VPWR sky130_fd_sc_hd__decap_8
XFILLER_0_47_381 VGND VGND VPWR VPWR sky130_fd_sc_hd__decap_8
XFILLER_0_38_27 VGND VGND VPWR VPWR sky130_fd_sc_hd__fill_1
XFILLER_0_54_15 VPWR VGND VPWR VGND sky130_ef_sc_hd__decap_12
X_2910_ _0360_ _0403_ net68 VGND VGND VPWR VPWR _0531_ sky130_fd_sc_hd__mux2_1
X_2841_ _0458_ _0442_ _0461_ VGND VGND VPWR VPWR _0462_ sky130_fd_sc_hd__o21a_1
XFILLER_0_38_381 VPWR VGND VPWR VGND sky130_ef_sc_hd__decap_12
X_2772_ _1440_ _0388_ VGND VGND VPWR VPWR _0389_ sky130_fd_sc_hd__xnor2_1
X_1723_ _0735_ _0806_ VGND VGND VPWR VPWR _0807_ sky130_fd_sc_hd__nand2_2
X_1654_ _0210_ _0667_ _0166_ _0737_ VGND VGND VPWR VPWR _0738_ sky130_fd_sc_hd__a31o_1
XFILLER_0_13_237 VPWR VGND VPWR VGND sky130_ef_sc_hd__decap_12
X_2206_ net52 _1275_ _1078_ VGND VGND VPWR VPWR _1290_ sky130_fd_sc_hd__mux2_2
X_1585_ net16 net15 net9 VGND VGND VPWR VPWR _0419_ sky130_fd_sc_hd__o21ai_4
XFILLER_0_0_197 VPWR VGND VPWR VGND sky130_ef_sc_hd__decap_12
XFILLER_0_44_81 VGND VGND VPWR VPWR sky130_fd_sc_hd__decap_3
X_2137_ _1173_ _1216_ _1220_ VGND VGND VPWR VPWR _1221_ sky130_fd_sc_hd__and3_1
X_2068_ _0947_ _1115_ VGND VGND VPWR VPWR _1152_ sky130_fd_sc_hd__or2b_1
XTAP_TAPCELL_ROW_64_596 VGND VPWR sky130_fd_sc_hd__tapvpwrvgnd_1
XFILLER_0_63_137 VGND VGND VPWR VPWR sky130_fd_sc_hd__fill_1
XFILLER_0_60_91 VPWR VGND VPWR VGND sky130_ef_sc_hd__decap_12
XFILLER_0_44_384 VGND VGND VPWR VPWR sky130_fd_sc_hd__fill_1
XFILLER_0_8_253 VGND VGND VPWR VPWR sky130_fd_sc_hd__fill_2
XFILLER_0_24_29 VPWR VGND VPWR VGND sky130_ef_sc_hd__decap_12
XFILLER_0_24_18 VGND VGND VPWR VPWR sky130_fd_sc_hd__decap_8
XFILLER_0_49_15 VPWR VGND VPWR VGND sky130_ef_sc_hd__decap_12
XFILLER_0_35_362 VGND VGND VPWR VPWR sky130_fd_sc_hd__decap_8
XFILLER_0_65_69 VPWR VGND VPWR VGND sky130_ef_sc_hd__decap_12
X_3040_ _0655_ _0656_ VGND VGND VPWR VPWR _0658_ sky130_fd_sc_hd__nand2_1
XTAP_TAPCELL_ROW_18_276 VGND VPWR sky130_fd_sc_hd__tapvpwrvgnd_1
XTAP_TAPCELL_ROW_61_577 VGND VPWR sky130_fd_sc_hd__tapvpwrvgnd_1
X_2824_ _0299_ _0399_ VGND VGND VPWR VPWR _0445_ sky130_fd_sc_hd__or2_1
XFILLER_0_26_362 VGND VGND VPWR VPWR sky130_fd_sc_hd__fill_2
XFILLER_0_5_223 VGND VGND VPWR VPWR sky130_fd_sc_hd__fill_1
XFILLER_0_18_307 VGND VGND VPWR VPWR sky130_fd_sc_hd__fill_1
X_2755_ _0317_ _0327_ _0369_ _0312_ VGND VGND VPWR VPWR _0370_ sky130_fd_sc_hd__a31o_1
X_2686_ _0181_ _0151_ _0291_ _0293_ VGND VGND VPWR VPWR _0294_ sky130_fd_sc_hd__o31a_1
XFILLER_0_30_83 VGND VGND VPWR VPWR sky130_fd_sc_hd__fill_1
X_1637_ _0704_ _0710_ VGND VGND VPWR VPWR _0721_ sky130_fd_sc_hd__nand2_1
X_1706_ net1 _0764_ _0765_ net5 VGND VGND VPWR VPWR _0790_ sky130_fd_sc_hd__a22o_1
XTAP_TAPCELL_ROW_69_633 VGND VPWR sky130_fd_sc_hd__tapvpwrvgnd_1
X_1568_ _0188_ _0221_ VGND VGND VPWR VPWR _0232_ sky130_fd_sc_hd__nand2_1
XTAP_TAPCELL_ROW_52_511 VGND VPWR sky130_fd_sc_hd__tapvpwrvgnd_1
XTAP_TAPCELL_ROW_1_155 VGND VPWR sky130_fd_sc_hd__tapvpwrvgnd_1
XFILLER_0_32_365 VGND VGND VPWR VPWR sky130_fd_sc_hd__decap_6
XFILLER_0_17_362 VGND VGND VPWR VPWR sky130_fd_sc_hd__fill_2
XFILLER_0_32_387 VGND VGND VPWR VPWR sky130_fd_sc_hd__fill_1
XFILLER_0_3_3 VPWR VGND VPWR VGND sky130_ef_sc_hd__decap_12
XTAP_TAPCELL_ROW_9_211 VGND VPWR sky130_fd_sc_hd__tapvpwrvgnd_1
XFILLER_0_35_39 VPWR VGND VPWR VGND sky130_ef_sc_hd__decap_12
XFILLER_0_55_413 VGND VGND VPWR VPWR sky130_fd_sc_hd__fill_2
XFILLER_0_51_27 VPWR VGND VPWR VGND sky130_ef_sc_hd__decap_12
XFILLER_0_27_104 VGND VGND VPWR VPWR sky130_fd_sc_hd__decap_8
XTAP_TAPCELL_ROW_15_257 VGND VPWR sky130_fd_sc_hd__tapvpwrvgnd_1
XFILLER_0_50_173 VGND VGND VPWR VPWR sky130_fd_sc_hd__decap_6
X_2471_ _0055_ _0057_ VGND VGND VPWR VPWR _0058_ sky130_fd_sc_hd__and2b_1
X_2540_ net8 net4 VGND VGND VPWR VPWR _0134_ sky130_fd_sc_hd__xor2_4
XFILLER_0_23_343 VGND VGND VPWR VPWR sky130_fd_sc_hd__fill_1
XFILLER_0_2_215 VGND VGND VPWR VPWR sky130_fd_sc_hd__decap_3
XTAP_TAPCELL_ROW_66_614 VGND VPWR sky130_fd_sc_hd__tapvpwrvgnd_1
X_3023_ _0372_ _0638_ VGND VGND VPWR VPWR _0640_ sky130_fd_sc_hd__or2_1
XFILLER_0_18_126 VGND VGND VPWR VPWR sky130_fd_sc_hd__fill_1
X_2738_ _0168_ _0227_ VGND VGND VPWR VPWR _0351_ sky130_fd_sc_hd__nor2_1
XFILLER_0_61_405 VGND VGND VPWR VPWR sky130_fd_sc_hd__decap_8
X_2807_ _1412_ net66 VGND VGND VPWR VPWR _0427_ sky130_fd_sc_hd__nand2_1
XFILLER_0_14_365 VPWR VGND VPWR VGND sky130_ef_sc_hd__decap_12
X_2669_ _0063_ _0274_ VGND VGND VPWR VPWR _0275_ sky130_fd_sc_hd__xnor2_2
XFILLER_0_41_162 VGND VGND VPWR VPWR sky130_fd_sc_hd__decap_6
XFILLER_0_1_281 VPWR VGND VPWR VGND sky130_ef_sc_hd__decap_12
XFILLER_0_64_265 VGND VGND VPWR VPWR sky130_fd_sc_hd__decap_4
XFILLER_0_64_221 VPWR VGND VPWR VGND sky130_ef_sc_hd__decap_12
XFILLER_0_37_413 VGND VGND VPWR VPWR sky130_fd_sc_hd__fill_2
XFILLER_0_24_118 VPWR VGND VPWR VGND sky130_ef_sc_hd__decap_12
XFILLER_0_64_298 VGND VGND VPWR VPWR sky130_fd_sc_hd__decap_8
XFILLER_0_17_181 VGND VGND VPWR VPWR sky130_fd_sc_hd__decap_4
XTAP_TAPCELL_ROW_20_293 VGND VPWR sky130_fd_sc_hd__tapvpwrvgnd_1
XFILLER_0_46_27 VGND VGND VPWR VPWR sky130_fd_sc_hd__fill_1
XFILLER_0_62_15 VPWR VGND VPWR VGND sky130_ef_sc_hd__decap_12
XFILLER_0_55_232 VGND VGND VPWR VPWR sky130_fd_sc_hd__fill_2
X_1971_ _1049_ _1053_ _1054_ VGND VGND VPWR VPWR _1055_ sky130_fd_sc_hd__a21o_4
XFILLER_0_7_307 VPWR VGND VPWR VGND sky130_ef_sc_hd__decap_12
X_2523_ _0113_ _1497_ _0114_ VGND VGND VPWR VPWR _0115_ sky130_fd_sc_hd__or3_1
X_2454_ _1098_ _1417_ VGND VGND VPWR VPWR _0039_ sky130_fd_sc_hd__or2_1
X_2385_ _1352_ _1470_ VGND VGND VPWR VPWR _1471_ sky130_fd_sc_hd__and2_1
X_3006_ net82 _0622_ VGND VGND VPWR VPWR _0623_ sky130_fd_sc_hd__nand2_1
Xinput1 io_inA[0] VGND VGND VPWR VPWR net1 sky130_fd_sc_hd__buf_1
XFILLER_0_52_92 VPWR VGND VPWR VGND sky130_ef_sc_hd__decap_12
XTAP_TAPCELL_ROW_34_385 VGND VPWR sky130_fd_sc_hd__tapvpwrvgnd_1
XFILLER_0_61_213 VGND VGND VPWR VPWR sky130_fd_sc_hd__decap_3
XFILLER_0_32_29 VPWR VGND VPWR VGND sky130_ef_sc_hd__decap_12
XFILLER_0_52_235 VPWR VGND VPWR VGND sky130_ef_sc_hd__decap_12
XFILLER_0_40_408 VGND VGND VPWR VPWR sky130_fd_sc_hd__decap_3
XFILLER_0_25_405 VGND VGND VPWR VPWR sky130_fd_sc_hd__decap_3
XFILLER_0_57_15 VPWR VGND VPWR VGND sky130_ef_sc_hd__decap_12
XFILLER_0_20_110 VPWR VGND VPWR VGND sky130_ef_sc_hd__decap_12
X_2170_ _1253_ _1228_ _1128_ VGND VGND VPWR VPWR _1254_ sky130_fd_sc_hd__mux2_1
XTAP_TAPCELL_ROW_48_488 VGND VPWR sky130_fd_sc_hd__tapvpwrvgnd_1
X_1954_ _1027_ _1028_ _1037_ _1032_ _1035_ VGND VGND VPWR VPWR _1038_ sky130_fd_sc_hd__a311o_1
XFILLER_0_7_104 VGND VGND VPWR VPWR sky130_fd_sc_hd__decap_8
XFILLER_0_43_257 VPWR VGND VPWR VGND sky130_ef_sc_hd__decap_12
XFILLER_0_43_202 VGND VGND VPWR VPWR sky130_fd_sc_hd__decap_6
XTAP_TAPCELL_ROW_31_366 VGND VPWR sky130_fd_sc_hd__tapvpwrvgnd_1
X_1885_ _0804_ _0934_ VGND VGND VPWR VPWR _0969_ sky130_fd_sc_hd__xnor2_2
X_2437_ _1292_ _1488_ _1516_ _1523_ _1526_ VGND VGND VPWR VPWR _1527_ sky130_fd_sc_hd__a311oi_2
X_2506_ net44 _1093_ _1374_ VGND VGND VPWR VPWR _0096_ sky130_fd_sc_hd__and3_1
X_2368_ _1270_ _1447_ _1359_ _1449_ _1452_ VGND VGND VPWR VPWR _1453_ sky130_fd_sc_hd__a32o_1
XFILLER_0_44_3 VPWR VGND VPWR VGND sky130_ef_sc_hd__decap_12
XFILLER_0_11_165 VGND VGND VPWR VPWR sky130_fd_sc_hd__decap_3
XTAP_TAPCELL_ROW_39_422 VGND VPWR sky130_fd_sc_hd__tapvpwrvgnd_1
X_2299_ _1323_ _1364_ _1382_ VGND VGND VPWR VPWR _1383_ sky130_fd_sc_hd__o21ai_1
XFILLER_0_2_72 VPWR VGND VPWR VGND sky130_ef_sc_hd__decap_12
XFILLER_0_34_268 VGND VGND VPWR VPWR sky130_fd_sc_hd__decap_3
XFILLER_0_27_18 VPWR VGND VPWR VGND sky130_ef_sc_hd__decap_12
XFILLER_0_69_165 VGND VGND VPWR VPWR sky130_fd_sc_hd__decap_3
XFILLER_0_43_39 VPWR VGND VPWR VGND sky130_ef_sc_hd__decap_12
XFILLER_0_65_393 VPWR VGND VPWR VGND sky130_ef_sc_hd__decap_12
XFILLER_0_40_249 VGND VGND VPWR VPWR sky130_fd_sc_hd__decap_3
XFILLER_0_25_279 VGND VGND VPWR VPWR sky130_fd_sc_hd__fill_1
X_1670_ _0749_ _0750_ VGND VGND VPWR VPWR _0754_ sky130_fd_sc_hd__xor2_1
X_2222_ _1281_ _1284_ _1297_ VGND VGND VPWR VPWR _1306_ sky130_fd_sc_hd__a21o_1
XTAP_TAPCELL_ROW_36_403 VGND VPWR sky130_fd_sc_hd__tapvpwrvgnd_1
X_2084_ _1043_ _1081_ VGND VGND VPWR VPWR _1168_ sky130_fd_sc_hd__xor2_2
X_2153_ _1114_ _1234_ _1235_ _1236_ VGND VGND VPWR VPWR _1237_ sky130_fd_sc_hd__o22ai_1
X_2986_ _0603_ _0478_ VGND VGND VPWR VPWR _0604_ sky130_fd_sc_hd__nand2b_1
X_1937_ _1020_ VGND VGND VPWR VPWR _1021_ sky130_fd_sc_hd__buf_8
XFILLER_0_8_413 VGND VGND VPWR VPWR sky130_fd_sc_hd__fill_2
XFILLER_0_31_205 VGND VGND VPWR VPWR sky130_fd_sc_hd__decap_3
X_1799_ _0880_ _0881_ _0878_ VGND VGND VPWR VPWR _0883_ sky130_fd_sc_hd__a21oi_1
X_1868_ _0951_ _0906_ VGND VGND VPWR VPWR _0952_ sky130_fd_sc_hd__xor2_2
XFILLER_0_66_124 VGND VGND VPWR VPWR sky130_fd_sc_hd__fill_1
XFILLER_0_47_393 VGND VGND VPWR VPWR sky130_fd_sc_hd__fill_2
XFILLER_0_54_27 VGND VGND VPWR VPWR sky130_fd_sc_hd__fill_1
XPHY_EDGE_ROW_35_Left_105 VGND VGND VPWR VPWR sky130_fd_sc_hd__decap_3
XFILLER_0_57_113 VPWR VGND VPWR VGND sky130_ef_sc_hd__decap_12
X_2840_ _0458_ _0459_ VGND VGND VPWR VPWR _0461_ sky130_fd_sc_hd__nand2_1
X_2771_ _0136_ _0387_ VGND VGND VPWR VPWR _0388_ sky130_fd_sc_hd__nor2_1
XFILLER_0_38_393 VGND VGND VPWR VPWR sky130_fd_sc_hd__fill_2
XFILLER_0_5_405 VGND VGND VPWR VPWR sky130_fd_sc_hd__decap_8
XPHY_EDGE_ROW_44_Left_114 VGND VGND VPWR VPWR sky130_fd_sc_hd__decap_3
X_1653_ _0243_ _0166_ _0221_ VGND VGND VPWR VPWR _0737_ sky130_fd_sc_hd__a21oi_1
X_1722_ _0715_ _0734_ _0718_ VGND VGND VPWR VPWR _0806_ sky130_fd_sc_hd__or3_4
XPHY_EDGE_ROW_9_Right_9 VGND VGND VPWR VPWR sky130_fd_sc_hd__decap_3
XFILLER_0_13_249 VGND VGND VPWR VPWR sky130_fd_sc_hd__decap_4
X_1584_ _0342_ _0364_ _0397_ VGND VGND VPWR VPWR _0408_ sky130_fd_sc_hd__a21o_1
XFILLER_0_21_271 VGND VGND VPWR VPWR sky130_fd_sc_hd__decap_3
X_2205_ _1103_ _1267_ _1288_ VGND VGND VPWR VPWR _1289_ sky130_fd_sc_hd__a21oi_2
XPHY_EDGE_ROW_53_Left_123 VGND VGND VPWR VPWR sky130_fd_sc_hd__decap_3
XFILLER_0_28_83 VGND VGND VPWR VPWR sky130_fd_sc_hd__fill_1
XTAP_TAPCELL_ROW_64_597 VGND VPWR sky130_fd_sc_hd__tapvpwrvgnd_1
XFILLER_0_48_168 VGND VGND VPWR VPWR sky130_fd_sc_hd__fill_1
X_2136_ _1207_ _1218_ _1219_ VGND VGND VPWR VPWR _1220_ sky130_fd_sc_hd__a21o_1
XFILLER_0_8_221 VGND VGND VPWR VPWR sky130_fd_sc_hd__decap_8
X_2067_ _1147_ _1148_ _1150_ VGND VGND VPWR VPWR _1151_ sky130_fd_sc_hd__o21ai_1
XPHY_EDGE_ROW_62_Left_132 VGND VGND VPWR VPWR sky130_fd_sc_hd__decap_3
X_2969_ _0583_ _0587_ _0523_ VGND VGND VPWR VPWR _0018_ sky130_fd_sc_hd__o21a_1
XFILLER_0_29_393 VGND VGND VPWR VPWR sky130_fd_sc_hd__decap_4
XFILLER_0_8_60 VPWR VGND VPWR VGND sky130_ef_sc_hd__decap_12
XTAP_TAPCELL_ROW_4_175 VGND VPWR sky130_fd_sc_hd__tapvpwrvgnd_1
XFILLER_0_54_149 VGND VGND VPWR VPWR sky130_fd_sc_hd__fill_2
XFILLER_0_39_157 VGND VGND VPWR VPWR sky130_fd_sc_hd__decap_8
XFILLER_0_40_29 VGND VGND VPWR VPWR sky130_fd_sc_hd__decap_8
XFILLER_0_49_27 VPWR VGND VPWR VGND sky130_ef_sc_hd__decap_12
XFILLER_0_65_15 VPWR VGND VPWR VGND sky130_ef_sc_hd__decap_12
XFILLER_0_4_29 VGND VGND VPWR VPWR sky130_fd_sc_hd__fill_1
XFILLER_0_14_41 VPWR VGND VPWR VGND sky130_ef_sc_hd__decap_12
XTAP_TAPCELL_ROW_18_277 VGND VPWR sky130_fd_sc_hd__tapvpwrvgnd_1
XTAP_TAPCELL_ROW_61_578 VGND VPWR sky130_fd_sc_hd__tapvpwrvgnd_1
X_2754_ _0341_ _0355_ _0368_ VGND VGND VPWR VPWR _0369_ sky130_fd_sc_hd__a21bo_1
X_2823_ _0442_ _0443_ _0401_ VGND VGND VPWR VPWR _0444_ sky130_fd_sc_hd__mux2_2
X_1705_ _0774_ _0788_ VGND VGND VPWR VPWR _0789_ sky130_fd_sc_hd__nor2_1
XFILLER_0_5_279 VGND VGND VPWR VPWR sky130_fd_sc_hd__fill_1
X_2685_ _0137_ _0151_ _0291_ _0292_ VGND VGND VPWR VPWR _0293_ sky130_fd_sc_hd__a31oi_1
XFILLER_0_41_388 VGND VGND VPWR VPWR sky130_fd_sc_hd__decap_4
XFILLER_0_39_82 VGND VGND VPWR VPWR sky130_fd_sc_hd__fill_1
X_1567_ _0199_ _0210_ VGND VGND VPWR VPWR _0221_ sky130_fd_sc_hd__and2_1
X_1636_ _0706_ _0709_ VGND VGND VPWR VPWR _0720_ sky130_fd_sc_hd__nand2_1
XTAP_TAPCELL_ROW_69_634 VGND VPWR sky130_fd_sc_hd__tapvpwrvgnd_1
XFILLER_0_55_81 VPWR VGND VPWR VGND sky130_ef_sc_hd__decap_12
X_2119_ net81 _1202_ VGND VGND VPWR VPWR _1203_ sky130_fd_sc_hd__nor2_1
XTAP_TAPCELL_ROW_1_156 VGND VPWR sky130_fd_sc_hd__tapvpwrvgnd_1
XTAP_TAPCELL_ROW_52_512 VGND VPWR sky130_fd_sc_hd__tapvpwrvgnd_1
X_3099_ clknet_2_1__leaf_clock _0016_ VGND VGND VPWR VPWR net28 sky130_fd_sc_hd__dfxtp_1
XFILLER_0_36_149 VGND VGND VPWR VPWR sky130_fd_sc_hd__fill_1
XFILLER_0_44_171 VGND VGND VPWR VPWR sky130_fd_sc_hd__fill_2
XTAP_TAPCELL_ROW_9_212 VGND VPWR sky130_fd_sc_hd__tapvpwrvgnd_1
XFILLER_0_67_230 VPWR VGND VPWR VGND sky130_ef_sc_hd__decap_12
XFILLER_0_51_39 VPWR VGND VPWR VGND sky130_ef_sc_hd__decap_12
XTAP_TAPCELL_ROW_15_258 VGND VPWR sky130_fd_sc_hd__tapvpwrvgnd_1
X_2470_ _0053_ _0054_ VGND VGND VPWR VPWR _0057_ sky130_fd_sc_hd__nand2_1
XTAP_TAPCELL_ROW_66_615 VGND VPWR sky130_fd_sc_hd__tapvpwrvgnd_1
X_3022_ _0372_ _0638_ VGND VGND VPWR VPWR _0639_ sky130_fd_sc_hd__nand2_1
XFILLER_0_25_62 VPWR VGND VPWR VGND sky130_ef_sc_hd__decap_12
XFILLER_0_18_116 VGND VGND VPWR VPWR sky130_fd_sc_hd__decap_3
X_2737_ _0349_ VGND VGND VPWR VPWR _0350_ sky130_fd_sc_hd__inv_2
X_2806_ _0425_ VGND VGND VPWR VPWR _0426_ sky130_fd_sc_hd__buf_6
X_2668_ _0137_ _0130_ _0273_ VGND VGND VPWR VPWR _0274_ sky130_fd_sc_hd__a21o_1
XFILLER_0_14_355 VGND VGND VPWR VPWR sky130_fd_sc_hd__fill_2
XFILLER_0_14_377 VPWR VGND VPWR VGND sky130_ef_sc_hd__decap_12
X_2599_ _1376_ _1391_ _1443_ _1458_ VGND VGND VPWR VPWR _0198_ sky130_fd_sc_hd__a31o_1
XFILLER_0_41_196 VGND VGND VPWR VPWR sky130_fd_sc_hd__decap_8
XFILLER_0_5_61 VGND VGND VPWR VPWR sky130_fd_sc_hd__decap_4
XFILLER_0_1_293 VPWR VGND VPWR VGND sky130_ef_sc_hd__decap_12
XFILLER_0_1_260 VGND VGND VPWR VPWR sky130_fd_sc_hd__decap_4
X_1619_ _0667_ _0569_ _0702_ VGND VGND VPWR VPWR _0703_ sky130_fd_sc_hd__a21o_1
XFILLER_0_64_244 VGND VGND VPWR VPWR sky130_fd_sc_hd__decap_8
XFILLER_0_64_233 VGND VGND VPWR VPWR sky130_fd_sc_hd__decap_4
XFILLER_0_9_393 VPWR VGND VPWR VGND sky130_ef_sc_hd__decap_12
XFILLER_0_32_141 VPWR VGND VPWR VGND sky130_ef_sc_hd__decap_12
XFILLER_0_20_336 VPWR VGND VPWR VGND sky130_ef_sc_hd__decap_12
XFILLER_0_62_27 VGND VGND VPWR VPWR sky130_fd_sc_hd__fill_1
X_1970_ net39 _1052_ VGND VGND VPWR VPWR _1054_ sky130_fd_sc_hd__and2_1
XFILLER_0_7_319 VPWR VGND VPWR VGND sky130_ef_sc_hd__decap_12
X_2522_ _1533_ _0043_ VGND VGND VPWR VPWR _0114_ sky130_fd_sc_hd__nand2_1
XFILLER_0_23_152 VGND VGND VPWR VPWR sky130_fd_sc_hd__fill_1
X_2453_ _0036_ _0037_ VGND VGND VPWR VPWR _0038_ sky130_fd_sc_hd__and2b_1
X_2384_ net49 _1322_ VGND VGND VPWR VPWR _1470_ sky130_fd_sc_hd__nand2_1
XFILLER_0_11_325 VGND VGND VPWR VPWR sky130_fd_sc_hd__fill_1
Xinput2 io_inA[1] VGND VGND VPWR VPWR net2 sky130_fd_sc_hd__buf_1
X_3005_ net37 _0621_ _1188_ VGND VGND VPWR VPWR _0622_ sky130_fd_sc_hd__mux2_1
XFILLER_0_61_236 VGND VGND VPWR VPWR sky130_fd_sc_hd__decap_3
XFILLER_0_46_299 VGND VGND VPWR VPWR sky130_fd_sc_hd__decap_8
XFILLER_0_46_244 VGND VGND VPWR VPWR sky130_fd_sc_hd__fill_1
XTAP_TAPCELL_ROW_34_386 VGND VPWR sky130_fd_sc_hd__tapvpwrvgnd_1
XFILLER_0_6_363 VGND VGND VPWR VPWR sky130_fd_sc_hd__fill_1
XFILLER_0_14_141 VPWR VGND VPWR VGND sky130_ef_sc_hd__decap_12
XFILLER_0_52_247 VGND VGND VPWR VPWR sky130_fd_sc_hd__fill_1
XFILLER_0_52_203 VGND VGND VPWR VPWR sky130_fd_sc_hd__fill_1
XFILLER_0_57_27 VPWR VGND VPWR VGND sky130_ef_sc_hd__decap_12
XTAP_TAPCELL_ROW_48_489 VGND VPWR sky130_fd_sc_hd__tapvpwrvgnd_1
XFILLER_0_43_225 VGND VGND VPWR VPWR sky130_fd_sc_hd__fill_2
XTAP_TAPCELL_ROW_31_367 VGND VPWR sky130_fd_sc_hd__tapvpwrvgnd_1
XFILLER_0_28_222 VGND VGND VPWR VPWR sky130_fd_sc_hd__decap_6
X_1953_ _1021_ _1025_ VGND VGND VPWR VPWR _1037_ sky130_fd_sc_hd__or2_1
XFILLER_0_22_85 VPWR VGND VPWR VGND sky130_ef_sc_hd__decap_12
X_1884_ _0122_ _0967_ VGND VGND VPWR VPWR _0968_ sky130_fd_sc_hd__xnor2_2
X_2505_ _1389_ _0092_ _1403_ VGND VGND VPWR VPWR _0095_ sky130_fd_sc_hd__a21bo_1
XFILLER_0_43_269 VGND VGND VPWR VPWR sky130_fd_sc_hd__decap_8
X_2436_ _1525_ VGND VGND VPWR VPWR _1526_ sky130_fd_sc_hd__inv_2
XFILLER_0_47_71 VPWR VGND VPWR VGND sky130_ef_sc_hd__decap_12
X_2367_ _1450_ _1451_ _1191_ VGND VGND VPWR VPWR _1452_ sky130_fd_sc_hd__o21a_1
XTAP_TAPCELL_ROW_39_423 VGND VPWR sky130_fd_sc_hd__tapvpwrvgnd_1
XFILLER_0_37_3 VPWR VGND VPWR VGND sky130_ef_sc_hd__decap_12
X_2298_ net47 _1078_ _1112_ _1108_ VGND VGND VPWR VPWR _1382_ sky130_fd_sc_hd__a31o_1
XFILLER_0_66_317 VGND VGND VPWR VPWR sky130_fd_sc_hd__fill_1
XFILLER_0_63_81 VPWR VGND VPWR VGND sky130_ef_sc_hd__decap_12
XFILLER_0_59_380 VGND VGND VPWR VPWR sky130_fd_sc_hd__fill_1
XTAP_TAPCELL_ROW_22_301 VGND VPWR sky130_fd_sc_hd__tapvpwrvgnd_1
XFILLER_0_25_225 VGND VGND VPWR VPWR sky130_fd_sc_hd__decap_4
XFILLER_0_68_15 VPWR VGND VPWR VGND sky130_ef_sc_hd__decap_12
XFILLER_0_40_217 VPWR VGND VPWR VGND sky130_ef_sc_hd__decap_12
XFILLER_0_40_206 VGND VGND VPWR VPWR sky130_fd_sc_hd__fill_2
X_2221_ _1197_ _1205_ _1222_ VGND VGND VPWR VPWR _1305_ sky130_fd_sc_hd__a21o_1
X_2152_ _1159_ _1162_ _1147_ VGND VGND VPWR VPWR _1236_ sky130_fd_sc_hd__mux2_1
XFILLER_0_48_317 VGND VGND VPWR VPWR sky130_fd_sc_hd__fill_1
X_2083_ _1146_ _1166_ _1109_ VGND VGND VPWR VPWR _1167_ sky130_fd_sc_hd__a21oi_1
XTAP_TAPCELL_ROW_36_404 VGND VPWR sky130_fd_sc_hd__tapvpwrvgnd_1
X_2985_ _0441_ _0468_ VGND VGND VPWR VPWR _0603_ sky130_fd_sc_hd__nand2_1
XFILLER_0_33_84 VGND VGND VPWR VPWR sky130_fd_sc_hd__decap_3
X_1936_ _1019_ _1016_ VGND VGND VPWR VPWR _1020_ sky130_fd_sc_hd__and2_4
X_1867_ _0907_ _0895_ VGND VGND VPWR VPWR _0951_ sky130_fd_sc_hd__or2_1
XFILLER_0_16_269 VGND VGND VPWR VPWR sky130_fd_sc_hd__decap_8
XFILLER_0_31_239 VPWR VGND VPWR VGND sky130_ef_sc_hd__decap_12
XFILLER_0_3_141 VPWR VGND VPWR VGND sky130_ef_sc_hd__decap_12
X_1798_ _0878_ _0880_ _0881_ VGND VGND VPWR VPWR _0882_ sky130_fd_sc_hd__and3_1
X_2419_ _1360_ _1362_ _1102_ VGND VGND VPWR VPWR _1508_ sky130_fd_sc_hd__a21o_1
XFILLER_0_54_309 VGND VGND VPWR VPWR sky130_fd_sc_hd__decap_6
XFILLER_0_22_228 VPWR VGND VPWR VGND sky130_ef_sc_hd__decap_12
XFILLER_0_22_217 VGND VGND VPWR VPWR sky130_fd_sc_hd__fill_2
XFILLER_0_38_29 VPWR VGND VPWR VGND sky130_ef_sc_hd__decap_12
XFILLER_0_30_283 VGND VGND VPWR VPWR sky130_fd_sc_hd__fill_2
XFILLER_0_57_125 VGND VGND VPWR VPWR sky130_fd_sc_hd__decap_6
XFILLER_0_65_191 VGND VGND VPWR VPWR sky130_fd_sc_hd__decap_6
XFILLER_0_53_364 VGND VGND VPWR VPWR sky130_fd_sc_hd__decap_6
XFILLER_0_53_320 VGND VGND VPWR VPWR sky130_fd_sc_hd__fill_1
X_2770_ _1412_ _1418_ VGND VGND VPWR VPWR _0387_ sky130_fd_sc_hd__nor2_1
XTAP_TAPCELL_ROW_41_440 VGND VPWR sky130_fd_sc_hd__tapvpwrvgnd_1
X_1721_ _0804_ VGND VGND VPWR VPWR _0805_ sky130_fd_sc_hd__inv_2
X_1652_ _0724_ _0726_ VGND VGND VPWR VPWR _0736_ sky130_fd_sc_hd__and2_1
XFILLER_0_13_217 VGND VGND VPWR VPWR sky130_fd_sc_hd__decap_6
X_1583_ _0375_ _0386_ VGND VGND VPWR VPWR _0397_ sky130_fd_sc_hd__nor2_1
X_2204_ _1270_ _1286_ _1287_ _1098_ VGND VGND VPWR VPWR _1288_ sky130_fd_sc_hd__a31o_1
X_2135_ _1084_ VGND VGND VPWR VPWR _1219_ sky130_fd_sc_hd__buf_2
XTAP_TAPCELL_ROW_64_598 VGND VPWR sky130_fd_sc_hd__tapvpwrvgnd_1
XFILLER_0_44_50 VGND VGND VPWR VPWR sky130_fd_sc_hd__decap_4
XFILLER_0_36_309 VPWR VGND VPWR VGND sky130_ef_sc_hd__decap_12
X_2066_ _1147_ _1149_ VGND VGND VPWR VPWR _1150_ sky130_fd_sc_hd__nand2_1
XFILLER_0_44_397 VPWR VGND VPWR VGND sky130_ef_sc_hd__decap_12
X_2899_ _0376_ _0472_ _0519_ VGND VGND VPWR VPWR _0520_ sky130_fd_sc_hd__a21oi_1
X_2968_ net30 _1487_ _0514_ _0586_ VGND VGND VPWR VPWR _0587_ sky130_fd_sc_hd__a22o_1
X_1919_ _1001_ _1002_ VGND VGND VPWR VPWR _1003_ sky130_fd_sc_hd__and2_1
XFILLER_0_8_72 VPWR VGND VPWR VGND sky130_ef_sc_hd__decap_12
XTAP_TAPCELL_ROW_55_532 VGND VPWR sky130_fd_sc_hd__tapvpwrvgnd_1
XFILLER_0_39_103 VGND VGND VPWR VPWR sky130_fd_sc_hd__fill_1
XTAP_TAPCELL_ROW_4_176 VGND VPWR sky130_fd_sc_hd__tapvpwrvgnd_1
XFILLER_0_54_128 VPWR VGND VPWR VGND sky130_ef_sc_hd__decap_12
XFILLER_0_35_320 VGND VGND VPWR VPWR sky130_fd_sc_hd__fill_1
XFILLER_0_50_323 VGND VGND VPWR VPWR sky130_fd_sc_hd__decap_4
XFILLER_0_49_39 VPWR VGND VPWR VGND sky130_ef_sc_hd__decap_12
XFILLER_0_65_27 VPWR VGND VPWR VGND sky130_ef_sc_hd__decap_12
XFILLER_0_58_401 VPWR VGND VPWR VGND sky130_ef_sc_hd__decap_12
XFILLER_0_14_53 VGND VGND VPWR VPWR sky130_fd_sc_hd__decap_6
XTAP_TAPCELL_ROW_18_278 VGND VPWR sky130_fd_sc_hd__tapvpwrvgnd_1
X_2753_ _0361_ _0367_ VGND VGND VPWR VPWR _0368_ sky130_fd_sc_hd__nor2_1
XTAP_TAPCELL_ROW_61_579 VGND VPWR sky130_fd_sc_hd__tapvpwrvgnd_1
X_2822_ net91 _0385_ net68 VGND VGND VPWR VPWR _0443_ sky130_fd_sc_hd__mux2_1
X_2684_ _0137_ _0152_ _0154_ VGND VGND VPWR VPWR _0292_ sky130_fd_sc_hd__nor3_1
XFILLER_0_30_41 VPWR VGND VPWR VGND sky130_ef_sc_hd__decap_12
XFILLER_0_26_397 VGND VGND VPWR VPWR sky130_fd_sc_hd__decap_4
XFILLER_0_26_353 VGND VGND VPWR VPWR sky130_fd_sc_hd__decap_3
X_1704_ _0776_ _0787_ VGND VGND VPWR VPWR _0788_ sky130_fd_sc_hd__xnor2_1
XFILLER_0_5_225 VGND VGND VPWR VPWR sky130_fd_sc_hd__decap_4
XTAP_TAPCELL_ROW_69_635 VGND VPWR sky130_fd_sc_hd__tapvpwrvgnd_1
X_1635_ _0711_ _0703_ VGND VGND VPWR VPWR _0719_ sky130_fd_sc_hd__or2b_1
X_1566_ net14 VGND VGND VPWR VPWR _0210_ sky130_fd_sc_hd__buf_2
XPHY_EDGE_ROW_18_Left_88 VGND VGND VPWR VPWR sky130_fd_sc_hd__decap_3
XFILLER_0_55_93 VPWR VGND VPWR VGND sky130_ef_sc_hd__decap_12
X_3098_ clknet_2_0__leaf_clock _0015_ VGND VGND VPWR VPWR net27 sky130_fd_sc_hd__dfxtp_1
X_2118_ _1199_ _1201_ _1128_ VGND VGND VPWR VPWR _1202_ sky130_fd_sc_hd__mux2_1
XTAP_TAPCELL_ROW_1_157 VGND VPWR sky130_fd_sc_hd__tapvpwrvgnd_1
X_2049_ _1129_ _1131_ _1132_ VGND VGND VPWR VPWR _1133_ sky130_fd_sc_hd__mux2_1
XTAP_TAPCELL_ROW_52_513 VGND VPWR sky130_fd_sc_hd__tapvpwrvgnd_1
XFILLER_0_44_150 VGND VGND VPWR VPWR sky130_fd_sc_hd__decap_6
XFILLER_0_36_139 VGND VGND VPWR VPWR sky130_fd_sc_hd__fill_1
XFILLER_0_29_191 VGND VGND VPWR VPWR sky130_fd_sc_hd__decap_8
XFILLER_0_44_183 VGND VGND VPWR VPWR sky130_fd_sc_hd__fill_1
XFILLER_0_32_378 VGND VGND VPWR VPWR sky130_fd_sc_hd__fill_1
XTAP_TAPCELL_ROW_9_213 VGND VPWR sky130_fd_sc_hd__tapvpwrvgnd_1
XFILLER_0_67_242 VGND VGND VPWR VPWR sky130_fd_sc_hd__decap_8
XFILLER_0_35_161 VGND VGND VPWR VPWR sky130_fd_sc_hd__decap_6
XFILLER_0_2_228 VGND VGND VPWR VPWR sky130_fd_sc_hd__fill_1
XFILLER_0_50_197 VGND VGND VPWR VPWR sky130_fd_sc_hd__decap_6
X_3021_ net39 _1322_ _0637_ VGND VGND VPWR VPWR _0638_ sky130_fd_sc_hd__a21o_1
XFILLER_0_58_286 VGND VGND VPWR VPWR sky130_fd_sc_hd__fill_1
XFILLER_0_58_253 VGND VGND VPWR VPWR sky130_fd_sc_hd__fill_2
X_2805_ _0424_ net79 _0295_ VGND VGND VPWR VPWR _0425_ sky130_fd_sc_hd__a21o_1
XFILLER_0_25_74 VGND VGND VPWR VPWR sky130_fd_sc_hd__decap_8
XFILLER_0_18_139 VGND VGND VPWR VPWR sky130_fd_sc_hd__fill_1
X_2736_ _0236_ _0348_ VGND VGND VPWR VPWR _0349_ sky130_fd_sc_hd__xor2_2
XFILLER_0_67_3 VPWR VGND VPWR VGND sky130_ef_sc_hd__decap_12
X_2667_ _0058_ _0269_ _0082_ _0181_ VGND VGND VPWR VPWR _0273_ sky130_fd_sc_hd__o211a_1
XFILLER_0_41_186 VGND VGND VPWR VPWR sky130_fd_sc_hd__fill_1
XFILLER_0_41_95 VGND VGND VPWR VPWR sky130_fd_sc_hd__decap_8
XFILLER_0_26_194 VGND VGND VPWR VPWR sky130_fd_sc_hd__fill_2
XFILLER_0_26_161 VGND VGND VPWR VPWR sky130_fd_sc_hd__decap_8
X_1618_ _0550_ _0560_ VGND VGND VPWR VPWR _0702_ sky130_fd_sc_hd__and2b_1
XFILLER_0_14_389 VPWR VGND VPWR VGND sky130_ef_sc_hd__decap_12
X_2598_ _1496_ _0196_ VGND VGND VPWR VPWR _0197_ sky130_fd_sc_hd__xor2_1
X_1549_ net17 net15 VGND VGND VPWR VPWR _1530_ sky130_fd_sc_hd__and2_1
XFILLER_0_9_361 VPWR VGND VPWR VGND sky130_ef_sc_hd__decap_12
XFILLER_0_17_161 VGND VGND VPWR VPWR sky130_fd_sc_hd__decap_6
XFILLER_0_32_197 VGND VGND VPWR VPWR sky130_fd_sc_hd__decap_8
XFILLER_0_32_153 VGND VGND VPWR VPWR sky130_fd_sc_hd__decap_6
XFILLER_0_20_348 VPWR VGND VPWR VGND sky130_ef_sc_hd__decap_12
XFILLER_0_46_29 VPWR VGND VPWR VGND sky130_ef_sc_hd__decap_12
XFILLER_0_55_267 VGND VGND VPWR VPWR sky130_fd_sc_hd__fill_1
X_2521_ _0036_ _0037_ VGND VGND VPWR VPWR _0113_ sky130_fd_sc_hd__or2b_1
XFILLER_0_23_164 VGND VGND VPWR VPWR sky130_fd_sc_hd__decap_4
XFILLER_0_23_120 VPWR VGND VPWR VGND sky130_ef_sc_hd__decap_12
XFILLER_0_11_337 VPWR VGND VPWR VGND sky130_ef_sc_hd__decap_12
X_2452_ _0035_ _1540_ VGND VGND VPWR VPWR _0037_ sky130_fd_sc_hd__or2b_1
X_2383_ net48 _1322_ _1467_ _1468_ VGND VGND VPWR VPWR _1469_ sky130_fd_sc_hd__a31oi_1
XPHY_EDGE_ROW_18_Right_18 VGND VGND VPWR VPWR sky130_fd_sc_hd__decap_3
Xinput3 io_inA[2] VGND VGND VPWR VPWR net3 sky130_fd_sc_hd__dlymetal6s2s_1
XPHY_EDGE_ROW_27_Right_27 VGND VGND VPWR VPWR sky130_fd_sc_hd__decap_3
X_3004_ _0968_ _1056_ VGND VGND VPWR VPWR _0621_ sky130_fd_sc_hd__nor2_1
XFILLER_0_46_289 VGND VGND VPWR VPWR sky130_fd_sc_hd__decap_4
XFILLER_0_46_278 VGND VGND VPWR VPWR sky130_fd_sc_hd__decap_4
XFILLER_0_46_201 VGND VGND VPWR VPWR sky130_fd_sc_hd__fill_1
XTAP_TAPCELL_ROW_34_387 VGND VPWR sky130_fd_sc_hd__tapvpwrvgnd_1
XFILLER_0_14_120 VPWR VGND VPWR VGND sky130_ef_sc_hd__decap_12
X_2719_ _1412_ _1418_ _1440_ VGND VGND VPWR VPWR _0330_ sky130_fd_sc_hd__nor3_1
XPHY_EDGE_ROW_36_Right_36 VGND VGND VPWR VPWR sky130_fd_sc_hd__decap_3
XFILLER_0_14_153 VPWR VGND VPWR VGND sky130_ef_sc_hd__decap_12
XFILLER_0_69_337 VPWR VGND VPWR VGND sky130_ef_sc_hd__decap_12
XPHY_EDGE_ROW_45_Right_45 VGND VGND VPWR VPWR sky130_fd_sc_hd__decap_3
XFILLER_0_37_223 VGND VGND VPWR VPWR sky130_fd_sc_hd__fill_1
XPHY_EDGE_ROW_54_Right_54 VGND VGND VPWR VPWR sky130_fd_sc_hd__decap_3
XFILLER_0_57_39 VPWR VGND VPWR VGND sky130_ef_sc_hd__decap_12
XPHY_EDGE_ROW_63_Right_63 VGND VGND VPWR VPWR sky130_fd_sc_hd__decap_3
XFILLER_0_43_215 VGND VGND VPWR VPWR sky130_fd_sc_hd__decap_8
XTAP_TAPCELL_ROW_31_368 VGND VPWR sky130_fd_sc_hd__tapvpwrvgnd_1
X_1952_ _1028_ _1026_ _1031_ _1032_ _1035_ VGND VGND VPWR VPWR _1036_ sky130_fd_sc_hd__o221a_4
XFILLER_0_22_97 VPWR VGND VPWR VGND sky130_ef_sc_hd__decap_12
X_1883_ _0933_ _0964_ _0966_ VGND VGND VPWR VPWR _0967_ sky130_fd_sc_hd__o21ai_4
X_2435_ _1263_ _1264_ _1524_ VGND VGND VPWR VPWR _1525_ sky130_fd_sc_hd__o21bai_1
X_2504_ _1374_ _1375_ VGND VGND VPWR VPWR _0094_ sky130_fd_sc_hd__xnor2_2
XFILLER_0_51_281 VGND VGND VPWR VPWR sky130_fd_sc_hd__decap_3
XFILLER_0_47_94 VGND VGND VPWR VPWR sky130_fd_sc_hd__decap_4
X_2366_ _1248_ _1435_ _1101_ VGND VGND VPWR VPWR _1451_ sky130_fd_sc_hd__a21o_1
XTAP_TAPCELL_ROW_39_424 VGND VPWR sky130_fd_sc_hd__tapvpwrvgnd_1
X_2297_ net44 _1109_ _1367_ _1380_ VGND VGND VPWR VPWR _1381_ sky130_fd_sc_hd__a31oi_1
XFILLER_0_63_93 VGND VGND VPWR VPWR sky130_fd_sc_hd__decap_3
XTAP_TAPCELL_ROW_22_302 VGND VPWR sky130_fd_sc_hd__tapvpwrvgnd_1
XFILLER_0_2_85 VGND VGND VPWR VPWR sky130_fd_sc_hd__decap_4
XFILLER_0_30_410 VGND VGND VPWR VPWR sky130_fd_sc_hd__fill_1
XFILLER_0_6_194 VGND VGND VPWR VPWR sky130_fd_sc_hd__fill_2
XFILLER_0_57_318 VGND VGND VPWR VPWR sky130_fd_sc_hd__fill_1
XPHY_EDGE_ROW_6_Left_76 VGND VGND VPWR VPWR sky130_fd_sc_hd__decap_3
XFILLER_0_25_204 VPWR VGND VPWR VGND sky130_ef_sc_hd__decap_12
XFILLER_0_4_109 VGND VGND VPWR VPWR sky130_fd_sc_hd__decap_8
XFILLER_0_68_27 VGND VGND VPWR VPWR sky130_fd_sc_hd__fill_1
XFILLER_0_40_229 VPWR VGND VPWR VGND sky130_ef_sc_hd__decap_12
XFILLER_0_33_281 VPWR VGND VPWR VGND sky130_ef_sc_hd__decap_12
XFILLER_0_0_337 VPWR VGND VPWR VGND sky130_ef_sc_hd__decap_12
X_2220_ _1300_ _1303_ VGND VGND VPWR VPWR _1304_ sky130_fd_sc_hd__nor2_1
X_2082_ net35 _1165_ net57 VGND VGND VPWR VPWR _1166_ sky130_fd_sc_hd__mux2_1
X_2151_ _1126_ _1208_ VGND VGND VPWR VPWR _1235_ sky130_fd_sc_hd__nor2_1
XFILLER_0_17_64 VGND VGND VPWR VPWR sky130_fd_sc_hd__decap_3
XTAP_TAPCELL_ROW_44_460 VGND VPWR sky130_fd_sc_hd__tapvpwrvgnd_1
XTAP_TAPCELL_ROW_36_405 VGND VPWR sky130_fd_sc_hd__tapvpwrvgnd_1
X_2984_ net32 _0543_ _0602_ _0601_ _0482_ VGND VGND VPWR VPWR _0020_ sky130_fd_sc_hd__o221a_1
XFILLER_0_56_373 VGND VGND VPWR VPWR sky130_fd_sc_hd__decap_8
XFILLER_0_3_153 VPWR VGND VPWR VGND sky130_ef_sc_hd__decap_12
X_1797_ _0777_ _0851_ _0823_ _0133_ _0879_ VGND VGND VPWR VPWR _0881_ sky130_fd_sc_hd__o221ai_2
X_1866_ _0943_ _0948_ _0949_ VGND VGND VPWR VPWR _0950_ sky130_fd_sc_hd__a21oi_1
X_1935_ _1018_ VGND VGND VPWR VPWR _1019_ sky130_fd_sc_hd__buf_6
X_2418_ _1505_ _1506_ VGND VGND VPWR VPWR _1507_ sky130_fd_sc_hd__or2b_2
X_2349_ _1361_ _1430_ _1432_ _1269_ VGND VGND VPWR VPWR _1433_ sky130_fd_sc_hd__a211o_1
XPHY_EDGE_ROW_0_Right_0 VGND VGND VPWR VPWR sky130_fd_sc_hd__decap_3
XFILLER_0_62_365 VPWR VGND VPWR VGND sky130_ef_sc_hd__decap_12
XFILLER_0_62_354 VGND VGND VPWR VPWR sky130_fd_sc_hd__fill_1
XFILLER_0_30_251 VGND VGND VPWR VPWR sky130_fd_sc_hd__fill_1
XFILLER_0_54_29 VPWR VGND VPWR VGND sky130_ef_sc_hd__decap_12
XTAP_TAPCELL_ROW_7_196 VGND VPWR sky130_fd_sc_hd__tapvpwrvgnd_1
XFILLER_0_57_148 VGND VGND VPWR VPWR sky130_fd_sc_hd__fill_2
XFILLER_0_57_137 VGND VGND VPWR VPWR sky130_fd_sc_hd__decap_4
XFILLER_0_53_343 VGND VGND VPWR VPWR sky130_fd_sc_hd__decap_3
XFILLER_0_38_373 VGND VGND VPWR VPWR sky130_fd_sc_hd__decap_3
X_1651_ _0718_ _0715_ _0734_ VGND VGND VPWR VPWR _0735_ sky130_fd_sc_hd__o21ai_4
X_1720_ _0802_ _0803_ VGND VGND VPWR VPWR _0804_ sky130_fd_sc_hd__and2_1
XFILLER_0_28_41 VPWR VGND VPWR VGND sky130_ef_sc_hd__decap_12
XFILLER_0_0_167 VGND VGND VPWR VPWR sky130_fd_sc_hd__fill_1
X_1582_ _0342_ _0364_ VGND VGND VPWR VPWR _0386_ sky130_fd_sc_hd__xnor2_1
X_2203_ _1221_ _1206_ _1106_ VGND VGND VPWR VPWR _1287_ sky130_fd_sc_hd__o21ai_2
X_2134_ net27 _1217_ _1092_ VGND VGND VPWR VPWR _1218_ sky130_fd_sc_hd__mux2_4
X_2065_ _0941_ _0952_ _1115_ VGND VGND VPWR VPWR _1149_ sky130_fd_sc_hd__mux2_1
XTAP_TAPCELL_ROW_64_599 VGND VPWR sky130_fd_sc_hd__tapvpwrvgnd_1
XFILLER_0_60_83 VGND VGND VPWR VPWR sky130_fd_sc_hd__fill_1
XFILLER_0_48_115 VPWR VGND VPWR VGND sky130_ef_sc_hd__decap_12
XFILLER_0_48_104 VGND VGND VPWR VPWR sky130_fd_sc_hd__decap_8
X_2967_ _0559_ _0585_ _0509_ VGND VGND VPWR VPWR _0586_ sky130_fd_sc_hd__mux2_4
XFILLER_0_69_81 VGND VGND VPWR VPWR sky130_fd_sc_hd__decap_3
X_2898_ _0376_ _0518_ VGND VGND VPWR VPWR _0519_ sky130_fd_sc_hd__nor2_1
X_1918_ _0988_ _0997_ _1000_ VGND VGND VPWR VPWR _1002_ sky130_fd_sc_hd__or3_1
X_1849_ _0925_ _0930_ _0931_ _0932_ VGND VGND VPWR VPWR _0933_ sky130_fd_sc_hd__o211ai_4
XFILLER_0_67_413 VGND VGND VPWR VPWR sky130_fd_sc_hd__fill_2
XTAP_TAPCELL_ROW_55_533 VGND VPWR sky130_fd_sc_hd__tapvpwrvgnd_1
XTAP_TAPCELL_ROW_4_177 VGND VPWR sky130_fd_sc_hd__tapvpwrvgnd_1
XFILLER_0_47_181 VGND VGND VPWR VPWR sky130_fd_sc_hd__fill_1
XFILLER_0_50_368 VGND VGND VPWR VPWR sky130_fd_sc_hd__fill_2
XFILLER_0_65_39 VPWR VGND VPWR VGND sky130_ef_sc_hd__decap_12
XFILLER_0_58_413 VGND VGND VPWR VPWR sky130_fd_sc_hd__fill_2
X_2821_ _0334_ _0329_ net68 VGND VGND VPWR VPWR _0442_ sky130_fd_sc_hd__mux2_1
XFILLER_0_14_98 VGND VGND VPWR VPWR sky130_fd_sc_hd__decap_6
XTAP_TAPCELL_ROW_18_279 VGND VPWR sky130_fd_sc_hd__tapvpwrvgnd_1
X_2752_ _0363_ _0366_ VGND VGND VPWR VPWR _0367_ sky130_fd_sc_hd__or2_1
XFILLER_0_53_184 VGND VGND VPWR VPWR sky130_fd_sc_hd__fill_2
XFILLER_0_53_162 VGND VGND VPWR VPWR sky130_fd_sc_hd__decap_6
X_2683_ _0145_ _0280_ _0290_ VGND VGND VPWR VPWR _0291_ sky130_fd_sc_hd__a21oi_1
XFILLER_0_41_379 VGND VGND VPWR VPWR sky130_fd_sc_hd__fill_1
XFILLER_0_30_53 VGND VGND VPWR VPWR sky130_fd_sc_hd__decap_8
XFILLER_0_26_365 VPWR VGND VPWR VGND sky130_ef_sc_hd__decap_12
X_1703_ _0778_ _0784_ _0786_ VGND VGND VPWR VPWR _0787_ sky130_fd_sc_hd__o21a_1
X_1634_ _0647_ _0320_ _0716_ _0717_ VGND VGND VPWR VPWR _0718_ sky130_fd_sc_hd__a31o_1
XTAP_TAPCELL_ROW_69_636 VGND VPWR sky130_fd_sc_hd__tapvpwrvgnd_1
X_1565_ net12 VGND VGND VPWR VPWR _0199_ sky130_fd_sc_hd__buf_2
XTAP_TAPCELL_ROW_52_514 VGND VPWR sky130_fd_sc_hd__tapvpwrvgnd_1
X_3097_ clknet_2_1__leaf_clock _0014_ VGND VGND VPWR VPWR net26 sky130_fd_sc_hd__dfxtp_1
X_2117_ _1147_ _1139_ _1200_ VGND VGND VPWR VPWR _1201_ sky130_fd_sc_hd__o21a_1
XTAP_TAPCELL_ROW_1_158 VGND VPWR sky130_fd_sc_hd__tapvpwrvgnd_1
XFILLER_0_12_3 VGND VGND VPWR VPWR sky130_fd_sc_hd__decap_4
X_2048_ _0969_ _0963_ _0978_ _0933_ VGND VGND VPWR VPWR _1132_ sky130_fd_sc_hd__a31o_1
XFILLER_0_32_302 VGND VGND VPWR VPWR sky130_fd_sc_hd__decap_6
XFILLER_0_17_332 VGND VGND VPWR VPWR sky130_fd_sc_hd__decap_4
XFILLER_0_17_354 VGND VGND VPWR VPWR sky130_fd_sc_hd__decap_8
XFILLER_0_32_335 VGND VGND VPWR VPWR sky130_fd_sc_hd__decap_3
XFILLER_0_4_292 VPWR VGND VPWR VGND sky130_ef_sc_hd__decap_12
XTAP_TAPCELL_ROW_9_214 VGND VPWR sky130_fd_sc_hd__tapvpwrvgnd_1
XFILLER_0_55_405 VGND VGND VPWR VPWR sky130_fd_sc_hd__decap_8
XFILLER_0_35_195 VGND VGND VPWR VPWR sky130_fd_sc_hd__fill_1
XFILLER_0_35_140 VGND VGND VPWR VPWR sky130_fd_sc_hd__decap_8
XFILLER_0_23_313 VGND VGND VPWR VPWR sky130_fd_sc_hd__fill_1
XFILLER_0_2_207 VGND VGND VPWR VPWR sky130_fd_sc_hd__decap_8
XFILLER_0_58_221 VGND VGND VPWR VPWR sky130_fd_sc_hd__decap_4
X_3020_ _1052_ _1322_ VGND VGND VPWR VPWR _0637_ sky130_fd_sc_hd__nor2_1
X_2804_ _0422_ _0279_ _0423_ VGND VGND VPWR VPWR _0424_ sky130_fd_sc_hd__o21ai_1
XFILLER_0_14_302 VGND VGND VPWR VPWR sky130_fd_sc_hd__decap_6
XFILLER_0_14_313 VPWR VGND VPWR VGND sky130_ef_sc_hd__decap_12
X_2735_ _0227_ _0233_ _0168_ VGND VGND VPWR VPWR _0348_ sky130_fd_sc_hd__a21o_1
X_2597_ _0194_ _0195_ _0136_ VGND VGND VPWR VPWR _0196_ sky130_fd_sc_hd__mux2_1
X_2666_ _0058_ _0271_ VGND VGND VPWR VPWR _0272_ sky130_fd_sc_hd__xnor2_2
X_1617_ _0419_ _0588_ _0700_ VGND VGND VPWR VPWR _0701_ sky130_fd_sc_hd__o21ai_4
X_1548_ _1509_ VGND VGND VPWR VPWR _0000_ sky130_fd_sc_hd__clkbuf_1
XFILLER_0_9_373 VPWR VGND VPWR VGND sky130_ef_sc_hd__decap_12
XFILLER_0_1_3 VPWR VGND VPWR VGND sky130_ef_sc_hd__decap_12
XFILLER_0_62_29 VPWR VGND VPWR VGND sky130_ef_sc_hd__decap_12
XFILLER_0_55_279 VGND VGND VPWR VPWR sky130_fd_sc_hd__fill_1
XFILLER_0_43_408 VGND VGND VPWR VPWR sky130_fd_sc_hd__decap_6
XFILLER_0_11_33 VGND VGND VPWR VPWR sky130_fd_sc_hd__fill_1
XTAP_TAPCELL_ROW_11_230 VGND VPWR sky130_fd_sc_hd__tapvpwrvgnd_1
X_2520_ _1493_ _0108_ _0109_ _0110_ VGND VGND VPWR VPWR _0112_ sky130_fd_sc_hd__o31ai_2
X_2451_ _1540_ _0035_ VGND VGND VPWR VPWR _0036_ sky130_fd_sc_hd__and2b_1
XFILLER_0_23_132 VPWR VGND VPWR VGND sky130_ef_sc_hd__decap_12
XFILLER_0_23_110 VGND VGND VPWR VPWR sky130_fd_sc_hd__fill_2
XFILLER_0_11_349 VPWR VGND VPWR VGND sky130_ef_sc_hd__decap_12
X_2382_ _1453_ _1455_ VGND VGND VPWR VPWR _1468_ sky130_fd_sc_hd__nor2_1
X_3003_ _0615_ _0620_ _0523_ VGND VGND VPWR VPWR _0023_ sky130_fd_sc_hd__o21a_1
XFILLER_0_36_41 VGND VGND VPWR VPWR sky130_fd_sc_hd__fill_1
Xinput4 io_inA[3] VGND VGND VPWR VPWR net4 sky130_fd_sc_hd__clkbuf_2
XFILLER_0_36_85 VPWR VGND VPWR VGND sky130_ef_sc_hd__decap_12
XFILLER_0_19_405 VGND VGND VPWR VPWR sky130_fd_sc_hd__decap_6
XFILLER_0_61_205 VGND VGND VPWR VPWR sky130_fd_sc_hd__decap_8
X_2718_ _0208_ _0328_ VGND VGND VPWR VPWR _0329_ sky130_fd_sc_hd__xnor2_2
XTAP_TAPCELL_ROW_34_388 VGND VPWR sky130_fd_sc_hd__tapvpwrvgnd_1
XFILLER_0_6_321 VPWR VGND VPWR VGND sky130_ef_sc_hd__decap_12
XFILLER_0_6_365 VPWR VGND VPWR VGND sky130_ef_sc_hd__decap_12
XFILLER_0_14_110 VGND VGND VPWR VPWR sky130_fd_sc_hd__decap_4
XFILLER_0_14_132 VGND VGND VPWR VPWR sky130_fd_sc_hd__decap_8
XFILLER_0_14_165 VPWR VGND VPWR VGND sky130_ef_sc_hd__decap_12
X_2649_ _1533_ _0171_ _0049_ VGND VGND VPWR VPWR _0253_ sky130_fd_sc_hd__o21ai_1
XFILLER_0_69_349 VPWR VGND VPWR VGND sky130_ef_sc_hd__decap_12
XFILLER_0_69_305 VGND VGND VPWR VPWR sky130_fd_sc_hd__decap_3
XTAP_TAPCELL_ROW_25_322 VGND VPWR sky130_fd_sc_hd__tapvpwrvgnd_1
XFILLER_0_9_181 VGND VGND VPWR VPWR sky130_fd_sc_hd__decap_6
XFILLER_0_60_293 VPWR VGND VPWR VGND sky130_ef_sc_hd__decap_12
XTAP_TAPCELL_ROW_31_369 VGND VPWR sky130_fd_sc_hd__tapvpwrvgnd_1
XFILLER_0_28_257 VGND VGND VPWR VPWR sky130_fd_sc_hd__fill_1
X_1951_ _1034_ _1023_ VGND VGND VPWR VPWR _1035_ sky130_fd_sc_hd__xnor2_1
XFILLER_0_22_32 VPWR VGND VPWR VGND sky130_ef_sc_hd__decap_12
XFILLER_0_3_335 VGND VGND VPWR VPWR sky130_fd_sc_hd__fill_1
X_1882_ _0932_ _0965_ _0931_ VGND VGND VPWR VPWR _0966_ sky130_fd_sc_hd__a21o_1
X_2434_ _1490_ _1491_ VGND VGND VPWR VPWR _1524_ sky130_fd_sc_hd__or2b_1
X_2503_ _1389_ _0092_ VGND VGND VPWR VPWR _0093_ sky130_fd_sc_hd__or2_1
XFILLER_0_51_260 VPWR VGND VPWR VGND sky130_ef_sc_hd__decap_12
X_2365_ _1297_ _1345_ _1431_ _1361_ VGND VGND VPWR VPWR _1450_ sky130_fd_sc_hd__o211a_1
XFILLER_0_11_113 VPWR VGND VPWR VGND sky130_ef_sc_hd__decap_12
XFILLER_0_11_157 VGND VGND VPWR VPWR sky130_fd_sc_hd__decap_3
XFILLER_0_47_51 VGND VGND VPWR VPWR sky130_fd_sc_hd__decap_4
XTAP_TAPCELL_ROW_39_425 VGND VPWR sky130_fd_sc_hd__tapvpwrvgnd_1
X_2296_ net33 _1078_ _1170_ _1112_ VGND VGND VPWR VPWR _1380_ sky130_fd_sc_hd__and4_1
XPHY_EDGE_ROW_22_Left_92 VGND VGND VPWR VPWR sky130_fd_sc_hd__decap_3
XFILLER_0_59_393 VPWR VGND VPWR VGND sky130_ef_sc_hd__decap_12
XTAP_TAPCELL_ROW_47_480 VGND VPWR sky130_fd_sc_hd__tapvpwrvgnd_1
XTAP_TAPCELL_ROW_22_303 VGND VPWR sky130_fd_sc_hd__tapvpwrvgnd_1
XFILLER_0_19_279 VGND VGND VPWR VPWR sky130_fd_sc_hd__fill_1
XFILLER_0_69_113 VPWR VGND VPWR VGND sky130_ef_sc_hd__decap_12
XFILLER_0_25_216 VGND VGND VPWR VPWR sky130_fd_sc_hd__decap_8
XFILLER_0_33_293 VGND VGND VPWR VPWR sky130_fd_sc_hd__decap_4
XFILLER_0_0_349 VPWR VGND VPWR VGND sky130_ef_sc_hd__decap_12
X_2150_ _1210_ _1211_ _1128_ VGND VGND VPWR VPWR _1234_ sky130_fd_sc_hd__mux2_1
X_2081_ _1021_ _1157_ _1161_ _1128_ _1164_ VGND VGND VPWR VPWR _1165_ sky130_fd_sc_hd__a221o_1
XTAP_TAPCELL_ROW_44_461 VGND VPWR sky130_fd_sc_hd__tapvpwrvgnd_1
X_2983_ _0465_ _0544_ _0543_ VGND VGND VPWR VPWR _0602_ sky130_fd_sc_hd__o21ai_1
XFILLER_0_33_53 VGND VGND VPWR VPWR sky130_fd_sc_hd__decap_3
X_1934_ _0963_ _0969_ _1009_ _1017_ VGND VGND VPWR VPWR _1018_ sky130_fd_sc_hd__and4_1
XFILLER_0_24_282 VPWR VGND VPWR VGND sky130_ef_sc_hd__decap_12
XFILLER_0_3_165 VGND VGND VPWR VPWR sky130_fd_sc_hd__decap_3
X_1796_ _0133_ _0823_ _0879_ VGND VGND VPWR VPWR _0880_ sky130_fd_sc_hd__or3_1
X_1865_ _0898_ _0903_ VGND VGND VPWR VPWR _0949_ sky130_fd_sc_hd__xor2_1
X_2417_ _1504_ _1500_ VGND VGND VPWR VPWR _1506_ sky130_fd_sc_hd__or2b_1
X_2348_ _1297_ _1345_ _1431_ _1248_ VGND VGND VPWR VPWR _1432_ sky130_fd_sc_hd__o211a_1
XFILLER_0_42_3 VPWR VGND VPWR VGND sky130_ef_sc_hd__decap_12
X_2279_ _1360_ _1362_ _1269_ VGND VGND VPWR VPWR _1363_ sky130_fd_sc_hd__a21o_1
XFILLER_0_66_149 VPWR VGND VPWR VGND sky130_ef_sc_hd__decap_12
XFILLER_0_62_333 VPWR VGND VPWR VGND sky130_ef_sc_hd__decap_12
XTAP_TAPCELL_ROW_50_497 VGND VPWR sky130_fd_sc_hd__tapvpwrvgnd_1
XFILLER_0_30_296 VPWR VGND VPWR VGND sky130_ef_sc_hd__decap_12
XTAP_TAPCELL_ROW_58_553 VGND VPWR sky130_fd_sc_hd__tapvpwrvgnd_1
XTAP_TAPCELL_ROW_7_197 VGND VPWR sky130_fd_sc_hd__tapvpwrvgnd_1
XFILLER_0_53_300 VPWR VGND VPWR VGND sky130_ef_sc_hd__decap_12
XFILLER_0_38_352 VPWR VGND VPWR VGND sky130_ef_sc_hd__decap_12
X_1650_ _0719_ _0733_ VGND VGND VPWR VPWR _0734_ sky130_fd_sc_hd__xnor2_1
X_1581_ net9 _0210_ VGND VGND VPWR VPWR _0375_ sky130_fd_sc_hd__nand2_1
X_2202_ _1278_ _1285_ _1248_ VGND VGND VPWR VPWR _1286_ sky130_fd_sc_hd__o21ai_2
XFILLER_0_28_53 VPWR VGND VPWR VGND sky130_ef_sc_hd__decap_12
XFILLER_0_0_113 VPWR VGND VPWR VGND sky130_ef_sc_hd__decap_12
XFILLER_0_44_85 VPWR VGND VPWR VGND sky130_ef_sc_hd__decap_12
X_2133_ _1114_ _1141_ _1125_ _1127_ VGND VGND VPWR VPWR _1217_ sky130_fd_sc_hd__a2bb2o_1
XFILLER_0_14_7 VPWR VGND VPWR VGND sky130_ef_sc_hd__decap_12
X_2064_ _0943_ _0973_ _1115_ VGND VGND VPWR VPWR _1148_ sky130_fd_sc_hd__mux2_1
XFILLER_0_56_193 VGND VGND VPWR VPWR sky130_fd_sc_hd__decap_3
X_2897_ _0458_ _0495_ _0517_ VGND VGND VPWR VPWR _0518_ sky130_fd_sc_hd__o21ai_1
X_2966_ _0570_ _0584_ _0458_ VGND VGND VPWR VPWR _0585_ sky130_fd_sc_hd__mux2_2
XFILLER_0_48_127 VPWR VGND VPWR VGND sky130_ef_sc_hd__decap_12
X_1917_ _0988_ _0997_ _1000_ VGND VGND VPWR VPWR _1001_ sky130_fd_sc_hd__o21ai_1
XFILLER_0_8_235 VGND VGND VPWR VPWR sky130_fd_sc_hd__fill_1
XFILLER_0_8_279 VGND VGND VPWR VPWR sky130_fd_sc_hd__decap_4
XPHY_EDGE_ROW_31_Left_101 VGND VGND VPWR VPWR sky130_fd_sc_hd__decap_3
XFILLER_0_8_85 VPWR VGND VPWR VGND sky130_ef_sc_hd__decap_12
X_1848_ _0929_ VGND VGND VPWR VPWR _0932_ sky130_fd_sc_hd__inv_2
X_1779_ _0647_ _0862_ _0687_ VGND VGND VPWR VPWR _0863_ sky130_fd_sc_hd__a21oi_1
XTAP_TAPCELL_ROW_4_178 VGND VPWR sky130_fd_sc_hd__tapvpwrvgnd_1
XTAP_TAPCELL_ROW_55_534 VGND VPWR sky130_fd_sc_hd__tapvpwrvgnd_1
XFILLER_0_54_108 VPWR VGND VPWR VGND sky130_ef_sc_hd__decap_12
XPHY_EDGE_ROW_40_Left_110 VGND VGND VPWR VPWR sky130_fd_sc_hd__decap_3
XFILLER_0_62_141 VGND VGND VPWR VPWR sky130_fd_sc_hd__decap_6
XFILLER_0_35_399 VGND VGND VPWR VPWR sky130_fd_sc_hd__decap_8
XFILLER_0_35_377 VPWR VGND VPWR VGND sky130_ef_sc_hd__decap_12
X_2751_ _0197_ _0365_ VGND VGND VPWR VPWR _0366_ sky130_fd_sc_hd__xnor2_1
X_2820_ accumulator.state\[1\] accumulator.state\[0\] VGND VGND VPWR VPWR _0441_ sky130_fd_sc_hd__nor2b_4
XFILLER_0_53_152 VGND VGND VPWR VPWR sky130_fd_sc_hd__fill_1
XFILLER_0_41_369 VGND VGND VPWR VPWR sky130_fd_sc_hd__fill_1
X_2682_ _0140_ _0141_ VGND VGND VPWR VPWR _0290_ sky130_fd_sc_hd__and2b_1
XFILLER_0_26_377 VGND VGND VPWR VPWR sky130_fd_sc_hd__decap_4
X_1702_ _0768_ _0785_ VGND VGND VPWR VPWR _0786_ sky130_fd_sc_hd__or2_1
XFILLER_0_5_238 VGND VGND VPWR VPWR sky130_fd_sc_hd__fill_1
X_1564_ _0177_ VGND VGND VPWR VPWR _0188_ sky130_fd_sc_hd__buf_2
X_1633_ _0712_ _0701_ VGND VGND VPWR VPWR _0717_ sky130_fd_sc_hd__and2b_1
XTAP_TAPCELL_ROW_69_637 VGND VPWR sky130_fd_sc_hd__tapvpwrvgnd_1
XFILLER_0_55_51 VGND VGND VPWR VPWR sky130_fd_sc_hd__decap_4
XTAP_TAPCELL_ROW_52_515 VGND VPWR sky130_fd_sc_hd__tapvpwrvgnd_1
XFILLER_0_49_414 VGND VGND VPWR VPWR sky130_fd_sc_hd__fill_1
X_3096_ clknet_2_0__leaf_clock _0013_ VGND VGND VPWR VPWR net25 sky130_fd_sc_hd__dfxtp_1
X_2116_ _1147_ _1123_ VGND VGND VPWR VPWR _1200_ sky130_fd_sc_hd__nand2_1
XTAP_TAPCELL_ROW_1_159 VGND VPWR sky130_fd_sc_hd__tapvpwrvgnd_1
X_2047_ _1130_ VGND VGND VPWR VPWR _1131_ sky130_fd_sc_hd__inv_2
XTAP_TAPCELL_ROW_60_570 VGND VPWR sky130_fd_sc_hd__tapvpwrvgnd_1
XFILLER_0_44_141 VGND VGND VPWR VPWR sky130_fd_sc_hd__decap_4
X_2949_ net89 _0543_ _0482_ _0568_ VGND VGND VPWR VPWR _0015_ sky130_fd_sc_hd__o211a_1
XFILLER_0_32_325 VGND VGND VPWR VPWR sky130_fd_sc_hd__fill_2
XFILLER_0_17_344 VGND VGND VPWR VPWR sky130_fd_sc_hd__fill_1
XTAP_TAPCELL_ROW_9_215 VGND VPWR sky130_fd_sc_hd__tapvpwrvgnd_1
XFILLER_0_67_211 VGND VGND VPWR VPWR sky130_fd_sc_hd__fill_1
XFILLER_0_23_347 VGND VGND VPWR VPWR sky130_fd_sc_hd__fill_2
XFILLER_0_18_108 VGND VGND VPWR VPWR sky130_fd_sc_hd__decap_8
X_2734_ _0346_ VGND VGND VPWR VPWR _0347_ sky130_fd_sc_hd__inv_2
X_2803_ _0286_ VGND VGND VPWR VPWR _0423_ sky130_fd_sc_hd__inv_2
XFILLER_0_41_133 VGND VGND VPWR VPWR sky130_fd_sc_hd__fill_1
XFILLER_0_26_174 VPWR VGND VPWR VGND sky130_ef_sc_hd__decap_12
XFILLER_0_26_141 VGND VGND VPWR VPWR sky130_fd_sc_hd__decap_6
XTAP_TAPCELL_ROW_14_250 VGND VPWR sky130_fd_sc_hd__tapvpwrvgnd_1
XFILLER_0_14_325 VPWR VGND VPWR VGND sky130_ef_sc_hd__decap_12
XFILLER_0_14_347 VGND VGND VPWR VPWR sky130_fd_sc_hd__decap_8
X_2596_ _1513_ _0108_ _1512_ VGND VGND VPWR VPWR _0195_ sky130_fd_sc_hd__a21oi_1
X_2665_ _0269_ _0270_ _0137_ VGND VGND VPWR VPWR _0271_ sky130_fd_sc_hd__mux2_1
X_1547_ net21 net54 _1487_ _1498_ VGND VGND VPWR VPWR _1509_ sky130_fd_sc_hd__and4bb_1
X_1616_ _0430_ _0579_ VGND VGND VPWR VPWR _0700_ sky130_fd_sc_hd__nand2_1
XFILLER_0_66_83 VGND VGND VPWR VPWR sky130_fd_sc_hd__fill_1
XFILLER_0_64_269 VGND VGND VPWR VPWR sky130_fd_sc_hd__fill_1
XFILLER_0_49_233 VPWR VGND VPWR VGND sky130_ef_sc_hd__decap_12
X_3079_ net21 net88 VGND VGND VPWR VPWR _0695_ sky130_fd_sc_hd__and2b_1
XFILLER_0_9_330 VGND VGND VPWR VPWR sky130_fd_sc_hd__decap_6
XFILLER_0_9_385 VGND VGND VPWR VPWR sky130_fd_sc_hd__decap_6
XFILLER_0_32_111 VGND VGND VPWR VPWR sky130_fd_sc_hd__fill_2
XFILLER_0_20_306 VGND VGND VPWR VPWR sky130_fd_sc_hd__fill_2
XFILLER_0_13_391 VGND VGND VPWR VPWR sky130_fd_sc_hd__fill_1
XFILLER_0_55_247 VGND VGND VPWR VPWR sky130_fd_sc_hd__decap_8
XFILLER_0_55_225 VGND VGND VPWR VPWR sky130_fd_sc_hd__decap_3
X_2381_ _1294_ _1460_ _1466_ _1097_ VGND VGND VPWR VPWR _1467_ sky130_fd_sc_hd__o22a_2
X_2450_ net26 _1194_ _1187_ VGND VGND VPWR VPWR _0035_ sky130_fd_sc_hd__mux2_1
XFILLER_0_23_144 VGND VGND VPWR VPWR sky130_fd_sc_hd__decap_8
X_3002_ net36 _1476_ _0618_ _0514_ _0619_ VGND VGND VPWR VPWR _0620_ sky130_fd_sc_hd__a221o_1
XFILLER_0_36_97 VPWR VGND VPWR VGND sky130_ef_sc_hd__decap_12
Xinput5 io_inB[0] VGND VGND VPWR VPWR net5 sky130_fd_sc_hd__buf_1
XFILLER_0_52_85 VGND VGND VPWR VPWR sky130_fd_sc_hd__fill_1
XFILLER_0_52_41 VGND VGND VPWR VPWR sky130_fd_sc_hd__decap_8
XFILLER_0_46_258 VGND VGND VPWR VPWR sky130_fd_sc_hd__decap_6
XFILLER_0_46_236 VGND VGND VPWR VPWR sky130_fd_sc_hd__decap_8
XTAP_TAPCELL_ROW_34_389 VGND VPWR sky130_fd_sc_hd__tapvpwrvgnd_1
XFILLER_0_61_228 VGND VGND VPWR VPWR sky130_fd_sc_hd__decap_8
X_2717_ _1441_ _0205_ net64 VGND VGND VPWR VPWR _0328_ sky130_fd_sc_hd__o21ba_1
XFILLER_0_34_409 VGND VGND VPWR VPWR sky130_fd_sc_hd__fill_2
XFILLER_0_6_333 VPWR VGND VPWR VGND sky130_ef_sc_hd__decap_12
XFILLER_0_6_377 VPWR VGND VPWR VGND sky130_ef_sc_hd__decap_12
XFILLER_0_14_177 VGND VGND VPWR VPWR sky130_fd_sc_hd__decap_3
X_2579_ _0043_ _0175_ VGND VGND VPWR VPWR _0176_ sky130_fd_sc_hd__and2_1
X_2648_ _0086_ _0118_ VGND VGND VPWR VPWR _0252_ sky130_fd_sc_hd__and2_1
XTAP_TAPCELL_ROW_25_323 VGND VPWR sky130_fd_sc_hd__tapvpwrvgnd_1
XFILLER_0_37_225 VGND VGND VPWR VPWR sky130_fd_sc_hd__decap_3
XFILLER_0_60_261 VGND VGND VPWR VPWR sky130_fd_sc_hd__fill_2
XFILLER_0_20_103 VGND VGND VPWR VPWR sky130_fd_sc_hd__fill_1
XPHY_EDGE_ROW_69_Left_139 VGND VGND VPWR VPWR sky130_fd_sc_hd__decap_3
X_1950_ _1033_ _1019_ VGND VGND VPWR VPWR _1034_ sky130_fd_sc_hd__and2_1
XFILLER_0_51_272 VGND VGND VPWR VPWR sky130_fd_sc_hd__decap_8
X_2502_ _0091_ _1078_ VGND VGND VPWR VPWR _0092_ sky130_fd_sc_hd__nor2_1
XFILLER_0_22_44 VPWR VGND VPWR VGND sky130_ef_sc_hd__decap_12
X_1881_ _0925_ _0930_ VGND VGND VPWR VPWR _0965_ sky130_fd_sc_hd__or2_1
X_2433_ _1496_ _1497_ _1522_ VGND VGND VPWR VPWR _1523_ sky130_fd_sc_hd__and3b_1
X_2364_ _1249_ _1430_ _1448_ _1269_ VGND VGND VPWR VPWR _1449_ sky130_fd_sc_hd__a211o_1
XFILLER_0_11_125 VPWR VGND VPWR VGND sky130_ef_sc_hd__decap_12
XFILLER_0_66_309 VGND VGND VPWR VPWR sky130_fd_sc_hd__decap_8
XFILLER_0_63_51 VGND VGND VPWR VPWR sky130_fd_sc_hd__decap_4
XTAP_TAPCELL_ROW_47_481 VGND VPWR sky130_fd_sc_hd__tapvpwrvgnd_1
X_2295_ _1222_ _1345_ _1348_ _1105_ VGND VGND VPWR VPWR _1379_ sky130_fd_sc_hd__o211a_1
XTAP_TAPCELL_ROW_39_426 VGND VPWR sky130_fd_sc_hd__tapvpwrvgnd_1
XFILLER_0_2_43 VGND VGND VPWR VPWR sky130_fd_sc_hd__fill_1
XFILLER_0_34_206 VGND VGND VPWR VPWR sky130_fd_sc_hd__decap_6
XTAP_TAPCELL_ROW_22_304 VGND VPWR sky130_fd_sc_hd__tapvpwrvgnd_1
XFILLER_0_6_141 VPWR VGND VPWR VGND sky130_ef_sc_hd__decap_12
XFILLER_0_19_269 VGND VGND VPWR VPWR sky130_fd_sc_hd__fill_1
XFILLER_0_69_169 VPWR VGND VPWR VGND sky130_ef_sc_hd__decap_12
XFILLER_0_69_125 VPWR VGND VPWR VGND sky130_ef_sc_hd__decap_12
XFILLER_0_68_29 VPWR VGND VPWR VGND sky130_ef_sc_hd__decap_12
XFILLER_0_0_306 VGND VGND VPWR VPWR sky130_fd_sc_hd__fill_2
XFILLER_0_48_309 VGND VGND VPWR VPWR sky130_fd_sc_hd__decap_8
XFILLER_0_17_11 VGND VGND VPWR VPWR sky130_fd_sc_hd__fill_1
XFILLER_0_17_22 VGND VGND VPWR VPWR sky130_fd_sc_hd__decap_6
XFILLER_0_17_55 VGND VGND VPWR VPWR sky130_fd_sc_hd__fill_1
XFILLER_0_17_77 VGND VGND VPWR VPWR sky130_fd_sc_hd__decap_4
XFILLER_0_17_99 VGND VGND VPWR VPWR sky130_fd_sc_hd__decap_3
X_2080_ _0993_ _1162_ _1163_ VGND VGND VPWR VPWR _1164_ sky130_fd_sc_hd__a21oi_1
X_2982_ _0313_ _0539_ _0477_ _0600_ VGND VGND VPWR VPWR _0601_ sky130_fd_sc_hd__o2bb2a_4
X_1933_ _0976_ _0961_ _0936_ VGND VGND VPWR VPWR _1017_ sky130_fd_sc_hd__and3b_1
XFILLER_0_24_294 VPWR VGND VPWR VGND sky130_ef_sc_hd__decap_12
XFILLER_0_24_272 VGND VGND VPWR VPWR sky130_fd_sc_hd__decap_6
XFILLER_0_3_111 VGND VGND VPWR VPWR sky130_fd_sc_hd__fill_1
X_1795_ _0865_ VGND VGND VPWR VPWR _0879_ sky130_fd_sc_hd__inv_2
XFILLER_0_12_401 VPWR VGND VPWR VGND sky130_ef_sc_hd__decap_12
X_1864_ _0647_ _0944_ _0778_ _0947_ VGND VGND VPWR VPWR _0948_ sky130_fd_sc_hd__a31o_1
X_2416_ _1500_ _1504_ VGND VGND VPWR VPWR _1505_ sky130_fd_sc_hd__and2b_1
X_2278_ _1305_ _1306_ _1361_ VGND VGND VPWR VPWR _1362_ sky130_fd_sc_hd__a21o_1
XFILLER_0_35_3 VPWR VGND VPWR VGND sky130_ef_sc_hd__decap_12
X_2347_ _1323_ _1146_ _1273_ _1341_ _1176_ VGND VGND VPWR VPWR _1431_ sky130_fd_sc_hd__a311o_1
XTAP_TAPCELL_ROW_50_498 VGND VPWR sky130_fd_sc_hd__tapvpwrvgnd_1
XFILLER_0_22_209 VGND VGND VPWR VPWR sky130_fd_sc_hd__decap_8
XFILLER_0_15_272 VGND VGND VPWR VPWR sky130_fd_sc_hd__fill_2
XFILLER_0_30_275 VGND VGND VPWR VPWR sky130_fd_sc_hd__decap_8
XFILLER_0_15_294 VGND VGND VPWR VPWR sky130_fd_sc_hd__decap_4
XTAP_TAPCELL_ROW_58_554 VGND VPWR sky130_fd_sc_hd__tapvpwrvgnd_1
XTAP_TAPCELL_ROW_7_198 VGND VPWR sky130_fd_sc_hd__tapvpwrvgnd_1
XFILLER_0_57_106 VGND VGND VPWR VPWR sky130_fd_sc_hd__decap_6
XFILLER_0_53_312 VGND VGND VPWR VPWR sky130_fd_sc_hd__decap_8
XFILLER_0_0_125 VPWR VGND VPWR VGND sky130_ef_sc_hd__decap_12
X_1580_ _0243_ _0320_ _0353_ VGND VGND VPWR VPWR _0364_ sky130_fd_sc_hd__and3_1
X_2132_ _1207_ _1215_ _1196_ VGND VGND VPWR VPWR _1216_ sky130_fd_sc_hd__a21o_1
X_2201_ _1174_ _1281_ _1284_ VGND VGND VPWR VPWR _1285_ sky130_fd_sc_hd__and3_1
XFILLER_0_28_65 VPWR VGND VPWR VGND sky130_ef_sc_hd__decap_12
XFILLER_0_0_169 VPWR VGND VPWR VGND sky130_ef_sc_hd__decap_12
XFILLER_0_48_139 VGND VGND VPWR VPWR sky130_fd_sc_hd__fill_1
XFILLER_0_44_97 VPWR VGND VPWR VGND sky130_ef_sc_hd__decap_12
X_2063_ _1132_ VGND VGND VPWR VPWR _1147_ sky130_fd_sc_hd__buf_2
XFILLER_0_63_109 VGND VGND VPWR VPWR sky130_fd_sc_hd__decap_3
XFILLER_0_60_85 VGND VGND VPWR VPWR sky130_fd_sc_hd__decap_3
XFILLER_0_60_41 VPWR VGND VPWR VGND sky130_ef_sc_hd__decap_12
X_2896_ _0447_ _0516_ VGND VGND VPWR VPWR _0517_ sky130_fd_sc_hd__nand2_1
X_2965_ _0302_ _0305_ _0505_ VGND VGND VPWR VPWR _0584_ sky130_fd_sc_hd__mux2_4
XFILLER_0_44_345 VGND VGND VPWR VPWR sky130_fd_sc_hd__decap_3
X_1916_ _0980_ _0999_ VGND VGND VPWR VPWR _1000_ sky130_fd_sc_hd__xnor2_1
X_1847_ _0768_ _0775_ VGND VGND VPWR VPWR _0931_ sky130_fd_sc_hd__or2_2
XFILLER_0_8_269 VGND VGND VPWR VPWR sky130_fd_sc_hd__decap_4
XFILLER_0_8_97 VPWR VGND VPWR VGND sky130_ef_sc_hd__decap_12
XFILLER_0_12_275 VGND VGND VPWR VPWR sky130_fd_sc_hd__decap_6
X_1778_ _0243_ _0320_ _0199_ VGND VGND VPWR VPWR _0862_ sky130_fd_sc_hd__a21o_1
XTAP_TAPCELL_ROW_4_179 VGND VPWR sky130_fd_sc_hd__tapvpwrvgnd_1
XTAP_TAPCELL_ROW_63_590 VGND VPWR sky130_fd_sc_hd__tapvpwrvgnd_1
XTAP_TAPCELL_ROW_55_535 VGND VPWR sky130_fd_sc_hd__tapvpwrvgnd_1
XFILLER_0_47_161 VGND VGND VPWR VPWR sky130_fd_sc_hd__decap_6
XFILLER_0_62_197 VGND VGND VPWR VPWR sky130_fd_sc_hd__decap_6
XFILLER_0_62_153 VGND VGND VPWR VPWR sky130_fd_sc_hd__decap_3
Xclone11 _0425_ VGND VGND VPWR VPWR net66 sky130_fd_sc_hd__buf_6
XFILLER_0_35_389 VGND VGND VPWR VPWR sky130_fd_sc_hd__decap_3
XFILLER_0_35_334 VGND VGND VPWR VPWR sky130_fd_sc_hd__fill_2
X_2750_ _0358_ _0193_ _0168_ VGND VGND VPWR VPWR _0365_ sky130_fd_sc_hd__o21ba_1
X_2681_ _0139_ _0277_ _0284_ VGND VGND VPWR VPWR _0289_ sky130_fd_sc_hd__and3_1
X_1701_ _0781_ _0780_ VGND VGND VPWR VPWR _0785_ sky130_fd_sc_hd__xnor2_2
XFILLER_0_53_197 VGND VGND VPWR VPWR sky130_fd_sc_hd__decap_4
XFILLER_0_41_337 VGND VGND VPWR VPWR sky130_fd_sc_hd__decap_4
XFILLER_0_39_53 VGND VGND VPWR VPWR sky130_fd_sc_hd__decap_3
X_1563_ net11 net13 VGND VGND VPWR VPWR _0177_ sky130_fd_sc_hd__and2_1
X_1632_ _0188_ _0221_ VGND VGND VPWR VPWR _0716_ sky130_fd_sc_hd__and2_1
XTAP_TAPCELL_ROW_69_638 VGND VPWR sky130_fd_sc_hd__tapvpwrvgnd_1
XFILLER_0_39_97 VGND VGND VPWR VPWR sky130_fd_sc_hd__decap_6
X_3095_ clknet_2_0__leaf_clock _0012_ VGND VGND VPWR VPWR net24 sky130_fd_sc_hd__dfxtp_1
X_2115_ _1147_ _1117_ _1198_ VGND VGND VPWR VPWR _1199_ sky130_fd_sc_hd__a21oi_1
XFILLER_0_64_407 VGND VGND VPWR VPWR sky130_fd_sc_hd__decap_8
XTAP_TAPCELL_ROW_52_516 VGND VPWR sky130_fd_sc_hd__tapvpwrvgnd_1
XFILLER_0_36_109 VGND VGND VPWR VPWR sky130_fd_sc_hd__decap_4
X_2046_ _0957_ _0936_ _1044_ VGND VGND VPWR VPWR _1130_ sky130_fd_sc_hd__mux2_1
XTAP_TAPCELL_ROW_17_270 VGND VPWR sky130_fd_sc_hd__tapvpwrvgnd_1
XTAP_TAPCELL_ROW_60_571 VGND VPWR sky130_fd_sc_hd__tapvpwrvgnd_1
XFILLER_0_44_197 VPWR VGND VPWR VGND sky130_ef_sc_hd__decap_12
XFILLER_0_44_120 VGND VGND VPWR VPWR sky130_fd_sc_hd__decap_4
X_2948_ _0494_ _0544_ _0567_ _0543_ VGND VGND VPWR VPWR _0568_ sky130_fd_sc_hd__o211ai_2
X_2879_ _0439_ _0499_ VGND VGND VPWR VPWR _0007_ sky130_fd_sc_hd__nor2_1
XTAP_TAPCELL_ROW_9_216 VGND VPWR sky130_fd_sc_hd__tapvpwrvgnd_1
XFILLER_0_67_223 VGND VGND VPWR VPWR sky130_fd_sc_hd__fill_1
XFILLER_0_50_134 VGND VGND VPWR VPWR sky130_fd_sc_hd__decap_6
XFILLER_0_23_337 VGND VGND VPWR VPWR sky130_fd_sc_hd__decap_6
X_2733_ _0226_ _0345_ VGND VGND VPWR VPWR _0346_ sky130_fd_sc_hd__xnor2_1
X_2802_ _0311_ _0421_ _0308_ VGND VGND VPWR VPWR _0422_ sky130_fd_sc_hd__o21ba_1
X_2664_ _0074_ _0262_ _0121_ VGND VGND VPWR VPWR _0270_ sky130_fd_sc_hd__a21bo_1
XFILLER_0_41_123 VGND VGND VPWR VPWR sky130_fd_sc_hd__fill_1
XFILLER_0_26_197 VPWR VGND VPWR VGND sky130_ef_sc_hd__decap_12
XFILLER_0_26_186 VGND VGND VPWR VPWR sky130_fd_sc_hd__fill_1
XFILLER_0_14_337 VGND VGND VPWR VPWR sky130_fd_sc_hd__decap_3
XTAP_TAPCELL_ROW_14_251 VGND VPWR sky130_fd_sc_hd__tapvpwrvgnd_1
X_2595_ _1292_ _1488_ _1515_ _1522_ VGND VGND VPWR VPWR _0194_ sky130_fd_sc_hd__a31o_1
X_1546_ accumulator.state\[1\] net20 VGND VGND VPWR VPWR _1498_ sky130_fd_sc_hd__or2_1
X_1615_ _0627_ _0636_ _0698_ VGND VGND VPWR VPWR _0699_ sky130_fd_sc_hd__o21a_1
XFILLER_0_49_223 VGND VGND VPWR VPWR sky130_fd_sc_hd__fill_1
X_3078_ _0501_ _0692_ _0693_ _0694_ VGND VGND VPWR VPWR _0031_ sky130_fd_sc_hd__o31a_1
XFILLER_0_49_267 VPWR VGND VPWR VGND sky130_ef_sc_hd__decap_12
XFILLER_0_49_245 VPWR VGND VPWR VGND sky130_ef_sc_hd__decap_12
X_2029_ _1111_ _1112_ _1077_ VGND VGND VPWR VPWR _1113_ sky130_fd_sc_hd__mux2_4
XFILLER_0_60_410 VGND VGND VPWR VPWR sky130_fd_sc_hd__decap_4
XTAP_TAPCELL_ROW_20_287 VGND VPWR sky130_fd_sc_hd__tapvpwrvgnd_1
XFILLER_0_20_329 VGND VGND VPWR VPWR sky130_fd_sc_hd__fill_1
XFILLER_0_55_204 VPWR VGND VPWR VGND sky130_ef_sc_hd__decap_12
XTAP_TAPCELL_ROW_28_343 VGND VPWR sky130_fd_sc_hd__tapvpwrvgnd_1
XFILLER_0_11_57 VGND VGND VPWR VPWR sky130_fd_sc_hd__decap_4
X_2380_ _1270_ _1251_ _1464_ VGND VGND VPWR VPWR _1466_ sky130_fd_sc_hd__o21ai_1
XFILLER_0_11_307 VPWR VGND VPWR VGND sky130_ef_sc_hd__decap_12
X_3001_ _0504_ _0566_ VGND VGND VPWR VPWR _0619_ sky130_fd_sc_hd__nor2_1
XFILLER_0_36_76 VGND VGND VPWR VPWR sky130_fd_sc_hd__decap_8
XFILLER_0_36_65 VGND VGND VPWR VPWR sky130_fd_sc_hd__fill_1
Xinput6 io_inB[1] VGND VGND VPWR VPWR net6 sky130_fd_sc_hd__buf_1
XFILLER_0_65_3 VPWR VGND VPWR VGND sky130_ef_sc_hd__decap_12
X_2716_ _0324_ _0326_ VGND VGND VPWR VPWR _0327_ sky130_fd_sc_hd__nor2_1
X_2647_ _1539_ VGND VGND VPWR VPWR _0251_ sky130_fd_sc_hd__inv_2
XFILLER_0_6_345 VPWR VGND VPWR VGND sky130_ef_sc_hd__decap_12
XFILLER_0_6_389 VPWR VGND VPWR VGND sky130_ef_sc_hd__decap_12
X_2578_ _0036_ _0173_ _0174_ _0037_ VGND VGND VPWR VPWR _0175_ sky130_fd_sc_hd__o31a_1
XFILLER_0_37_204 VGND VGND VPWR VPWR sky130_fd_sc_hd__decap_4
XTAP_TAPCELL_ROW_25_324 VGND VPWR sky130_fd_sc_hd__tapvpwrvgnd_1
XFILLER_0_45_281 VPWR VGND VPWR VGND sky130_ef_sc_hd__decap_12
XPHY_EDGE_ROW_14_Right_14 VGND VGND VPWR VPWR sky130_fd_sc_hd__decap_3
XFILLER_0_60_251 VGND VGND VPWR VPWR sky130_fd_sc_hd__fill_1
XPHY_EDGE_ROW_23_Right_23 VGND VGND VPWR VPWR sky130_fd_sc_hd__decap_3
XPHY_EDGE_ROW_32_Right_32 VGND VGND VPWR VPWR sky130_fd_sc_hd__decap_3
XFILLER_0_22_56 VPWR VGND VPWR VGND sky130_ef_sc_hd__decap_12
X_1880_ _0935_ _0962_ _0963_ VGND VGND VPWR VPWR _0964_ sky130_fd_sc_hd__o21a_1
X_2501_ net33 VGND VGND VPWR VPWR _0091_ sky130_fd_sc_hd__inv_2
XFILLER_0_24_410 VGND VGND VPWR VPWR sky130_fd_sc_hd__fill_2
XFILLER_0_3_337 VPWR VGND VPWR VGND sky130_ef_sc_hd__decap_12
XFILLER_0_11_137 VPWR VGND VPWR VGND sky130_ef_sc_hd__decap_12
X_2432_ _1521_ VGND VGND VPWR VPWR _1522_ sky130_fd_sc_hd__inv_2
X_2294_ _1249_ _1343_ _1377_ _1269_ VGND VGND VPWR VPWR _1378_ sky130_fd_sc_hd__a211o_1
X_2363_ _1106_ _1422_ _1423_ VGND VGND VPWR VPWR _1448_ sky130_fd_sc_hd__and3_1
XPHY_EDGE_ROW_41_Right_41 VGND VGND VPWR VPWR sky130_fd_sc_hd__decap_3
XFILLER_0_59_362 VPWR VGND VPWR VGND sky130_ef_sc_hd__decap_12
XPHY_EDGE_ROW_50_Right_50 VGND VGND VPWR VPWR sky130_fd_sc_hd__decap_3
XTAP_TAPCELL_ROW_47_482 VGND VPWR sky130_fd_sc_hd__tapvpwrvgnd_1
XFILLER_0_59_384 VGND VGND VPWR VPWR sky130_fd_sc_hd__decap_8
XTAP_TAPCELL_ROW_30_360 VGND VPWR sky130_fd_sc_hd__tapvpwrvgnd_1
XTAP_TAPCELL_ROW_22_305 VGND VPWR sky130_fd_sc_hd__tapvpwrvgnd_1
XFILLER_0_6_153 VGND VGND VPWR VPWR sky130_fd_sc_hd__fill_1
XFILLER_0_42_251 VGND VGND VPWR VPWR sky130_fd_sc_hd__fill_1
XFILLER_0_6_197 VGND VGND VPWR VPWR sky130_fd_sc_hd__decap_4
XFILLER_0_69_137 VGND VGND VPWR VPWR sky130_fd_sc_hd__decap_3
XFILLER_0_18_270 VPWR VGND VPWR VGND sky130_ef_sc_hd__decap_12
XFILLER_0_68_181 VPWR VGND VPWR VGND sky130_ef_sc_hd__decap_12
XFILLER_0_56_321 VGND VGND VPWR VPWR sky130_fd_sc_hd__fill_1
X_2981_ _0571_ _0599_ _0509_ VGND VGND VPWR VPWR _0600_ sky130_fd_sc_hd__mux2_4
Xinput20 io_start VGND VGND VPWR VPWR net20 sky130_fd_sc_hd__clkbuf_1
X_1932_ _1004_ _1006_ VGND VGND VPWR VPWR _1016_ sky130_fd_sc_hd__nand2_1
X_1863_ _0763_ _0877_ _0945_ _0946_ VGND VGND VPWR VPWR _0947_ sky130_fd_sc_hd__a31o_1
XFILLER_0_58_41 VPWR VGND VPWR VGND sky130_ef_sc_hd__decap_12
X_2415_ _1102_ _1501_ _1503_ _1192_ VGND VGND VPWR VPWR _1504_ sky130_fd_sc_hd__o211a_1
X_1794_ _0133_ _0877_ _0836_ VGND VGND VPWR VPWR _0878_ sky130_fd_sc_hd__nor3_1
XFILLER_0_12_413 VGND VGND VPWR VPWR sky130_fd_sc_hd__fill_2
X_2277_ _1105_ VGND VGND VPWR VPWR _1361_ sky130_fd_sc_hd__clkbuf_4
X_2346_ _1222_ _1340_ _1429_ VGND VGND VPWR VPWR _1430_ sky130_fd_sc_hd__a21o_1
XFILLER_0_28_3 VPWR VGND VPWR VGND sky130_ef_sc_hd__decap_12
XFILLER_0_59_181 VPWR VGND VPWR VGND sky130_ef_sc_hd__decap_12
XFILLER_0_62_324 VGND VGND VPWR VPWR sky130_fd_sc_hd__decap_6
XTAP_TAPCELL_ROW_50_499 VGND VPWR sky130_fd_sc_hd__tapvpwrvgnd_1
XFILLER_0_30_243 VGND VGND VPWR VPWR sky130_fd_sc_hd__decap_8
XTAP_TAPCELL_ROW_7_199 VGND VPWR sky130_fd_sc_hd__tapvpwrvgnd_1
XTAP_TAPCELL_ROW_58_555 VGND VPWR sky130_fd_sc_hd__tapvpwrvgnd_1
XFILLER_0_65_140 VPWR VGND VPWR VGND sky130_ef_sc_hd__decap_12
XFILLER_0_38_398 VPWR VGND VPWR VGND sky130_ef_sc_hd__decap_12
XFILLER_0_38_365 VGND VGND VPWR VPWR sky130_fd_sc_hd__decap_4
XFILLER_0_38_343 VGND VGND VPWR VPWR sky130_fd_sc_hd__decap_6
XFILLER_0_53_379 VGND VGND VPWR VPWR sky130_fd_sc_hd__decap_4
XFILLER_0_0_137 VGND VGND VPWR VPWR sky130_fd_sc_hd__decap_3
X_2131_ net28 _1214_ _1092_ VGND VGND VPWR VPWR _1215_ sky130_fd_sc_hd__mux2_2
X_2200_ _1207_ _1283_ _1219_ VGND VGND VPWR VPWR _1284_ sky130_fd_sc_hd__a21o_1
X_2062_ _1113_ VGND VGND VPWR VPWR _1146_ sky130_fd_sc_hd__buf_2
XFILLER_0_28_77 VGND VGND VPWR VPWR sky130_fd_sc_hd__decap_6
XFILLER_0_44_54 VGND VGND VPWR VPWR sky130_fd_sc_hd__fill_1
X_2964_ _0450_ _0554_ _0527_ _0557_ VGND VGND VPWR VPWR _0583_ sky130_fd_sc_hd__a2bb2o_4
X_2895_ _0349_ _0515_ _0426_ VGND VGND VPWR VPWR _0516_ sky130_fd_sc_hd__mux2_2
XFILLER_0_60_53 VPWR VGND VPWR VGND sky130_ef_sc_hd__decap_12
X_1915_ _1530_ _0985_ _0998_ VGND VGND VPWR VPWR _0999_ sky130_fd_sc_hd__a21boi_1
X_1777_ _0856_ _0859_ _0860_ VGND VGND VPWR VPWR _0861_ sky130_fd_sc_hd__or3_1
XFILLER_0_8_43 VPWR VGND VPWR VGND sky130_ef_sc_hd__decap_12
X_1846_ _0928_ _0929_ VGND VGND VPWR VPWR _0930_ sky130_fd_sc_hd__or2_2
XPHY_EDGE_ROW_4_Right_4 VGND VGND VPWR VPWR sky130_fd_sc_hd__decap_3
XFILLER_0_67_405 VGND VGND VPWR VPWR sky130_fd_sc_hd__decap_8
XTAP_TAPCELL_ROW_55_536 VGND VPWR sky130_fd_sc_hd__tapvpwrvgnd_1
X_2329_ _1307_ _1316_ _1269_ VGND VGND VPWR VPWR _1413_ sky130_fd_sc_hd__a21oi_1
XTAP_TAPCELL_ROW_63_591 VGND VPWR sky130_fd_sc_hd__tapvpwrvgnd_1
XFILLER_0_39_118 VGND VGND VPWR VPWR sky130_fd_sc_hd__decap_3
XFILLER_0_35_357 VGND VGND VPWR VPWR sky130_fd_sc_hd__fill_1
XFILLER_0_50_327 VGND VGND VPWR VPWR sky130_fd_sc_hd__fill_1
XFILLER_0_53_176 VGND VGND VPWR VPWR sky130_fd_sc_hd__decap_8
X_2680_ _0279_ _0286_ VGND VGND VPWR VPWR _0288_ sky130_fd_sc_hd__or2_1
XFILLER_0_41_349 VPWR VGND VPWR VGND sky130_ef_sc_hd__decap_12
XFILLER_0_38_195 VGND VGND VPWR VPWR sky130_fd_sc_hd__fill_1
XFILLER_0_38_151 VPWR VGND VPWR VGND sky130_ef_sc_hd__decap_12
XFILLER_0_30_67 VPWR VGND VPWR VGND sky130_ef_sc_hd__decap_12
X_1700_ _0783_ _0782_ VGND VGND VPWR VPWR _0784_ sky130_fd_sc_hd__xnor2_2
XFILLER_0_5_229 VGND VGND VPWR VPWR sky130_fd_sc_hd__fill_1
X_1631_ _0608_ _0699_ _0713_ _0714_ VGND VGND VPWR VPWR _0715_ sky130_fd_sc_hd__o211a_1
XFILLER_0_1_413 VGND VGND VPWR VPWR sky130_fd_sc_hd__fill_2
X_1562_ _0155_ VGND VGND VPWR VPWR _0166_ sky130_fd_sc_hd__buf_2
XTAP_TAPCELL_ROW_69_639 VGND VPWR sky130_fd_sc_hd__tapvpwrvgnd_1
X_3094_ clknet_2_1__leaf_clock _0011_ VGND VGND VPWR VPWR net23 sky130_fd_sc_hd__dfxtp_1
X_2045_ _0954_ _0938_ _1044_ VGND VGND VPWR VPWR _1129_ sky130_fd_sc_hd__mux2_1
X_2114_ _0993_ _1120_ VGND VGND VPWR VPWR _1198_ sky130_fd_sc_hd__and2_1
XTAP_TAPCELL_ROW_60_572 VGND VPWR sky130_fd_sc_hd__tapvpwrvgnd_1
XTAP_TAPCELL_ROW_52_517 VGND VPWR sky130_fd_sc_hd__tapvpwrvgnd_1
X_2947_ _0497_ _0566_ _0476_ VGND VGND VPWR VPWR _0567_ sky130_fd_sc_hd__mux2_2
XFILLER_0_29_173 VGND VGND VPWR VPWR sky130_fd_sc_hd__fill_1
XFILLER_0_29_162 VGND VGND VPWR VPWR sky130_fd_sc_hd__decap_6
XTAP_TAPCELL_ROW_17_271 VGND VPWR sky130_fd_sc_hd__tapvpwrvgnd_1
X_2878_ net50 _1476_ _0469_ _0498_ VGND VGND VPWR VPWR _0499_ sky130_fd_sc_hd__o2bb2a_2
XFILLER_0_4_251 VGND VGND VPWR VPWR sky130_fd_sc_hd__fill_1
X_1829_ _0909_ _0911_ VGND VGND VPWR VPWR _0913_ sky130_fd_sc_hd__and2_1
XTAP_TAPCELL_ROW_0_150 VGND VPWR sky130_fd_sc_hd__tapvpwrvgnd_1
XFILLER_0_50_179 VGND VGND VPWR VPWR sky130_fd_sc_hd__fill_1
XFILLER_0_31_393 VPWR VGND VPWR VGND sky130_ef_sc_hd__decap_12
XFILLER_0_16_390 VPWR VGND VPWR VGND sky130_ef_sc_hd__decap_12
XTAP_TAPCELL_ROW_66_609 VGND VPWR sky130_fd_sc_hd__tapvpwrvgnd_1
XFILLER_0_25_12 VPWR VGND VPWR VGND sky130_ef_sc_hd__decap_12
X_2801_ _0420_ _0402_ _0305_ VGND VGND VPWR VPWR _0421_ sky130_fd_sc_hd__a21oi_2
XFILLER_0_41_33 VGND VGND VPWR VPWR sky130_fd_sc_hd__fill_1
XFILLER_0_26_110 VPWR VGND VPWR VGND sky130_ef_sc_hd__decap_12
X_2594_ _1514_ _0192_ VGND VGND VPWR VPWR _0193_ sky130_fd_sc_hd__xnor2_2
X_2732_ _0216_ _0222_ _0168_ VGND VGND VPWR VPWR _0345_ sky130_fd_sc_hd__a21oi_1
X_2663_ _0258_ _0075_ _0080_ VGND VGND VPWR VPWR _0269_ sky130_fd_sc_hd__a21oi_1
XFILLER_0_41_113 VGND VGND VPWR VPWR sky130_fd_sc_hd__fill_2
XFILLER_0_22_360 VGND VGND VPWR VPWR sky130_fd_sc_hd__decap_4
X_1614_ _0627_ _0636_ _0696_ VGND VGND VPWR VPWR _0698_ sky130_fd_sc_hd__a21o_1
XFILLER_0_66_85 VGND VGND VPWR VPWR sky130_fd_sc_hd__fill_2
XFILLER_0_66_41 VPWR VGND VPWR VGND sky130_ef_sc_hd__decap_12
X_1545_ _1476_ VGND VGND VPWR VPWR _1487_ sky130_fd_sc_hd__buf_2
XFILLER_0_22_382 VPWR VGND VPWR VGND sky130_ef_sc_hd__decap_12
XFILLER_0_49_257 VGND VGND VPWR VPWR sky130_fd_sc_hd__decap_6
X_2028_ _1090_ _1094_ _1111_ VGND VGND VPWR VPWR _1112_ sky130_fd_sc_hd__a21oi_2
X_3077_ _1069_ _0501_ _0438_ VGND VGND VPWR VPWR _0694_ sky130_fd_sc_hd__a21oi_1
XFILLER_0_49_279 VGND VGND VPWR VPWR sky130_fd_sc_hd__fill_1
XFILLER_0_40_190 VGND VGND VPWR VPWR sky130_fd_sc_hd__decap_6
XFILLER_0_13_393 VPWR VGND VPWR VGND sky130_ef_sc_hd__decap_12
XTAP_TAPCELL_ROW_20_288 VGND VPWR sky130_fd_sc_hd__tapvpwrvgnd_1
XFILLER_0_55_216 VGND VGND VPWR VPWR sky130_fd_sc_hd__decap_8
XTAP_TAPCELL_ROW_28_344 VGND VPWR sky130_fd_sc_hd__tapvpwrvgnd_1
XFILLER_0_11_319 VGND VGND VPWR VPWR sky130_fd_sc_hd__decap_6
X_3000_ _0591_ _0616_ _0509_ VGND VGND VPWR VPWR _0618_ sky130_fd_sc_hd__mux2_4
Xinput7 io_inB[2] VGND VGND VPWR VPWR net7 sky130_fd_sc_hd__buf_1
XFILLER_0_6_357 VGND VGND VPWR VPWR sky130_fd_sc_hd__decap_6
X_2646_ _0179_ _0245_ _0249_ VGND VGND VPWR VPWR _0250_ sky130_fd_sc_hd__and3b_1
X_2577_ _1192_ _1262_ _1264_ VGND VGND VPWR VPWR _0174_ sky130_fd_sc_hd__and3_1
X_2715_ _0179_ _0325_ VGND VGND VPWR VPWR _0326_ sky130_fd_sc_hd__xnor2_2
XFILLER_0_58_3 VPWR VGND VPWR VGND sky130_ef_sc_hd__decap_12
XFILLER_0_10_363 VGND VGND VPWR VPWR sky130_fd_sc_hd__fill_1
XTAP_TAPCELL_ROW_25_325 VGND VPWR sky130_fd_sc_hd__tapvpwrvgnd_1
XFILLER_0_52_219 VGND VGND VPWR VPWR sky130_fd_sc_hd__fill_1
XFILLER_0_45_293 VPWR VGND VPWR VGND sky130_ef_sc_hd__decap_12
XTAP_TAPCELL_ROW_33_380 VGND VPWR sky130_fd_sc_hd__tapvpwrvgnd_1
XFILLER_0_20_127 VPWR VGND VPWR VGND sky130_ef_sc_hd__decap_12
XFILLER_0_68_363 VGND VGND VPWR VPWR sky130_fd_sc_hd__fill_1
XFILLER_0_43_208 VGND VGND VPWR VPWR sky130_fd_sc_hd__fill_1
XFILLER_0_22_68 VPWR VGND VPWR VGND sky130_ef_sc_hd__decap_12
X_2431_ _1518_ _1519_ _1520_ VGND VGND VPWR VPWR _1521_ sky130_fd_sc_hd__a21oi_1
X_2500_ _1467_ _1475_ VGND VGND VPWR VPWR _0090_ sky130_fd_sc_hd__xor2_2
XFILLER_0_3_349 VPWR VGND VPWR VGND sky130_ef_sc_hd__decap_12
XFILLER_0_3_305 VPWR VGND VPWR VGND sky130_ef_sc_hd__decap_12
XFILLER_0_11_149 VGND VGND VPWR VPWR sky130_fd_sc_hd__decap_8
X_2293_ _1105_ _1333_ _1336_ VGND VGND VPWR VPWR _1377_ sky130_fd_sc_hd__and3_1
X_2362_ _1107_ _1445_ _1446_ VGND VGND VPWR VPWR _1447_ sky130_fd_sc_hd__o21ai_2
XFILLER_0_59_374 VGND VGND VPWR VPWR sky130_fd_sc_hd__decap_6
XTAP_TAPCELL_ROW_22_306 VGND VPWR sky130_fd_sc_hd__tapvpwrvgnd_1
XFILLER_0_2_89 VGND VGND VPWR VPWR sky130_fd_sc_hd__fill_1
XFILLER_0_42_230 VGND VGND VPWR VPWR sky130_fd_sc_hd__fill_1
XFILLER_0_34_219 VPWR VGND VPWR VGND sky130_ef_sc_hd__decap_12
XTAP_TAPCELL_ROW_30_361 VGND VPWR sky130_fd_sc_hd__tapvpwrvgnd_1
X_2629_ _0229_ _0230_ _0135_ VGND VGND VPWR VPWR _0231_ sky130_fd_sc_hd__mux2_1
XFILLER_0_33_274 VGND VGND VPWR VPWR sky130_fd_sc_hd__decap_3
XFILLER_0_18_282 VGND VGND VPWR VPWR sky130_fd_sc_hd__fill_1
X_2980_ _0584_ _0597_ _0458_ VGND VGND VPWR VPWR _0599_ sky130_fd_sc_hd__mux2_4
XFILLER_0_17_57 VGND VGND VPWR VPWR sky130_fd_sc_hd__fill_2
XFILLER_0_68_193 VGND VGND VPWR VPWR sky130_fd_sc_hd__decap_3
XFILLER_0_33_78 VGND VGND VPWR VPWR sky130_fd_sc_hd__fill_1
XPHY_EDGE_ROW_26_Left_96 VGND VGND VPWR VPWR sky130_fd_sc_hd__decap_3
Xinput21 reset VGND VGND VPWR VPWR net21 sky130_fd_sc_hd__buf_1
XFILLER_0_3_113 VPWR VGND VPWR VGND sky130_ef_sc_hd__decap_12
Xinput10 io_inScaleA[1] VGND VGND VPWR VPWR net10 sky130_fd_sc_hd__clkbuf_2
X_1793_ _0767_ _0876_ VGND VGND VPWR VPWR _0877_ sky130_fd_sc_hd__or2_1
X_1862_ _0887_ _0792_ VGND VGND VPWR VPWR _0946_ sky130_fd_sc_hd__nor2_1
X_1931_ _0996_ _1014_ VGND VGND VPWR VPWR _1015_ sky130_fd_sc_hd__nor2_2
XFILLER_0_58_53 VPWR VGND VPWR VGND sky130_ef_sc_hd__decap_12
X_2414_ _1102_ _1502_ VGND VGND VPWR VPWR _1503_ sky130_fd_sc_hd__nand2_1
X_2276_ _1301_ _1302_ _1249_ VGND VGND VPWR VPWR _1360_ sky130_fd_sc_hd__a21o_1
X_2345_ _1174_ _1334_ _1335_ VGND VGND VPWR VPWR _1429_ sky130_fd_sc_hd__and3_1
XFILLER_0_66_108 VGND VGND VPWR VPWR sky130_fd_sc_hd__fill_2
XFILLER_0_15_252 VPWR VGND VPWR VGND sky130_ef_sc_hd__decap_12
XTAP_TAPCELL_ROW_58_556 VGND VPWR sky130_fd_sc_hd__tapvpwrvgnd_1
XFILLER_0_65_152 VPWR VGND VPWR VGND sky130_ef_sc_hd__decap_12
XTAP_TAPCELL_ROW_41_434 VGND VPWR sky130_fd_sc_hd__tapvpwrvgnd_1
XFILLER_0_61_391 VGND VGND VPWR VPWR sky130_fd_sc_hd__fill_1
XFILLER_0_21_200 VPWR VGND VPWR VGND sky130_ef_sc_hd__decap_12
XFILLER_0_21_233 VGND VGND VPWR VPWR sky130_fd_sc_hd__fill_1
X_2061_ net73 _1144_ VGND VGND VPWR VPWR _1145_ sky130_fd_sc_hd__nand2_1
X_2130_ _1126_ _1208_ _1213_ VGND VGND VPWR VPWR _1214_ sky130_fd_sc_hd__a21bo_1
X_2963_ _0576_ _0582_ _0523_ VGND VGND VPWR VPWR _0017_ sky130_fd_sc_hd__o21a_1
X_1914_ net18 net16 _1530_ VGND VGND VPWR VPWR _0998_ sky130_fd_sc_hd__or3_1
XFILLER_0_8_249 VGND VGND VPWR VPWR sky130_fd_sc_hd__decap_3
XFILLER_0_69_41 VPWR VGND VPWR VGND sky130_ef_sc_hd__decap_12
X_2894_ _0357_ VGND VGND VPWR VPWR _0515_ sky130_fd_sc_hd__inv_2
XFILLER_0_60_65 VPWR VGND VPWR VGND sky130_ef_sc_hd__decap_12
XFILLER_0_44_336 VGND VGND VPWR VPWR sky130_fd_sc_hd__decap_6
X_1776_ _0842_ _0843_ VGND VGND VPWR VPWR _0860_ sky130_fd_sc_hd__xnor2_1
X_1845_ _0798_ _0926_ _0927_ VGND VGND VPWR VPWR _0929_ sky130_fd_sc_hd__a21oi_1
XFILLER_0_8_55 VGND VGND VPWR VPWR sky130_fd_sc_hd__fill_2
XFILLER_0_12_222 VPWR VGND VPWR VGND sky130_ef_sc_hd__decap_12
XFILLER_0_69_85 VPWR VGND VPWR VGND sky130_ef_sc_hd__decap_12
X_2328_ _1406_ _1294_ _1407_ _1411_ VGND VGND VPWR VPWR _1412_ sky130_fd_sc_hd__a2bb2o_4
XFILLER_0_40_3 VPWR VGND VPWR VGND sky130_ef_sc_hd__decap_12
XTAP_TAPCELL_ROW_55_537 VGND VPWR sky130_fd_sc_hd__tapvpwrvgnd_1
X_2259_ _1340_ _1342_ _1222_ VGND VGND VPWR VPWR _1343_ sky130_fd_sc_hd__mux2_4
XTAP_TAPCELL_ROW_63_592 VGND VPWR sky130_fd_sc_hd__tapvpwrvgnd_1
Xclone13 _0425_ VGND VGND VPWR VPWR net68 sky130_fd_sc_hd__buf_6
XFILLER_0_47_185 VGND VGND VPWR VPWR sky130_fd_sc_hd__decap_6
XFILLER_0_35_314 VGND VGND VPWR VPWR sky130_fd_sc_hd__decap_6
XFILLER_0_62_188 VGND VGND VPWR VPWR sky130_fd_sc_hd__decap_8
XFILLER_0_43_380 VGND VGND VPWR VPWR sky130_fd_sc_hd__fill_1
XTAP_TAPCELL_ROW_3_170 VGND VPWR sky130_fd_sc_hd__tapvpwrvgnd_1
XFILLER_0_38_163 VPWR VGND VPWR VGND sky130_ef_sc_hd__decap_12
XFILLER_0_53_144 VGND VGND VPWR VPWR sky130_fd_sc_hd__decap_8
XFILLER_0_53_133 VGND VGND VPWR VPWR sky130_fd_sc_hd__decap_3
XFILLER_0_41_306 VPWR VGND VPWR VGND sky130_ef_sc_hd__decap_12
XFILLER_0_30_79 VGND VGND VPWR VPWR sky130_fd_sc_hd__decap_4
XFILLER_0_30_13 VPWR VGND VPWR VGND sky130_ef_sc_hd__decap_12
X_1630_ _0408_ _0598_ VGND VGND VPWR VPWR _0714_ sky130_fd_sc_hd__or2_1
X_1561_ net16 net15 VGND VGND VPWR VPWR _0155_ sky130_fd_sc_hd__or2_1
X_3093_ clknet_2_1__leaf_clock _0010_ VGND VGND VPWR VPWR net53 sky130_fd_sc_hd__dfxtp_1
X_2113_ _1193_ _1195_ _1196_ VGND VGND VPWR VPWR _1197_ sky130_fd_sc_hd__a21o_1
X_2044_ _1011_ VGND VGND VPWR VPWR _1128_ sky130_fd_sc_hd__buf_2
XFILLER_0_12_7 VGND VGND VPWR VPWR sky130_fd_sc_hd__fill_1
XTAP_TAPCELL_ROW_60_573 VGND VPWR sky130_fd_sc_hd__tapvpwrvgnd_1
X_2946_ _0533_ _0565_ _0509_ VGND VGND VPWR VPWR _0566_ sky130_fd_sc_hd__mux2_2
X_2877_ _0494_ _0497_ _0476_ VGND VGND VPWR VPWR _0498_ sky130_fd_sc_hd__mux2_4
XFILLER_0_17_314 VGND VGND VPWR VPWR sky130_fd_sc_hd__decap_4
XTAP_TAPCELL_ROW_17_272 VGND VPWR sky130_fd_sc_hd__tapvpwrvgnd_1
XFILLER_0_25_391 VGND VGND VPWR VPWR sky130_fd_sc_hd__fill_1
X_1759_ _0838_ _0840_ VGND VGND VPWR VPWR _0843_ sky130_fd_sc_hd__xnor2_2
X_1828_ _0909_ _0911_ VGND VGND VPWR VPWR _0912_ sky130_fd_sc_hd__or2_1
XPHY_EDGE_ROW_13_Left_83 VGND VGND VPWR VPWR sky130_fd_sc_hd__decap_3
XFILLER_0_67_203 VGND VGND VPWR VPWR sky130_fd_sc_hd__decap_8
XTAP_TAPCELL_ROW_0_151 VGND VPWR sky130_fd_sc_hd__tapvpwrvgnd_1
XTAP_TAPCELL_ROW_0_140 VGND VPWR sky130_fd_sc_hd__tapvpwrvgnd_1
XFILLER_0_35_177 VGND VGND VPWR VPWR sky130_fd_sc_hd__fill_2
XFILLER_0_58_225 VGND VGND VPWR VPWR sky130_fd_sc_hd__fill_1
XFILLER_0_25_24 VPWR VGND VPWR VGND sky130_ef_sc_hd__decap_12
X_2731_ _0220_ _0343_ VGND VGND VPWR VPWR _0344_ sky130_fd_sc_hd__xnor2_2
XFILLER_0_58_247 VGND VGND VPWR VPWR sky130_fd_sc_hd__fill_1
X_2800_ _0417_ _0378_ _0418_ VGND VGND VPWR VPWR _0420_ sky130_fd_sc_hd__a21o_1
XFILLER_0_46_409 VGND VGND VPWR VPWR sky130_fd_sc_hd__fill_2
Xclkbuf_2_1__f_clock clknet_0_clock VGND VGND VPWR VPWR clknet_2_1__leaf_clock sky130_fd_sc_hd__clkbuf_16
XFILLER_0_26_122 VGND VGND VPWR VPWR sky130_fd_sc_hd__fill_1
X_2593_ _1519_ _0191_ _0108_ _0136_ VGND VGND VPWR VPWR _0192_ sky130_fd_sc_hd__a2bb2o_1
X_2662_ _0257_ _0261_ _0267_ VGND VGND VPWR VPWR _0268_ sky130_fd_sc_hd__and3_1
XFILLER_0_41_169 VGND VGND VPWR VPWR sky130_fd_sc_hd__decap_8
XFILLER_0_41_103 VGND VGND VPWR VPWR sky130_fd_sc_hd__fill_1
X_1544_ _1465_ VGND VGND VPWR VPWR _1476_ sky130_fd_sc_hd__buf_2
XFILLER_0_22_394 VPWR VGND VPWR VGND sky130_ef_sc_hd__decap_12
XFILLER_0_1_277 VGND VGND VPWR VPWR sky130_fd_sc_hd__decap_3
X_1613_ _0199_ _0657_ _0687_ VGND VGND VPWR VPWR _0696_ sky130_fd_sc_hd__and3_1
XFILLER_0_66_53 VPWR VGND VPWR VGND sky130_ef_sc_hd__decap_12
XFILLER_0_5_89 VPWR VGND VPWR VGND sky130_ef_sc_hd__decap_12
XFILLER_0_49_225 VGND VGND VPWR VPWR sky130_fd_sc_hd__decap_4
X_3076_ _0683_ _0689_ _0691_ VGND VGND VPWR VPWR _0693_ sky130_fd_sc_hd__a21oi_1
X_2027_ _1073_ _1110_ VGND VGND VPWR VPWR _1111_ sky130_fd_sc_hd__xor2_2
X_2929_ _0518_ _0548_ _0509_ VGND VGND VPWR VPWR _0549_ sky130_fd_sc_hd__mux2_2
XFILLER_0_32_103 VGND VGND VPWR VPWR sky130_fd_sc_hd__decap_8
XFILLER_0_17_122 VGND VGND VPWR VPWR sky130_fd_sc_hd__decap_4
XTAP_TAPCELL_ROW_20_289 VGND VPWR sky130_fd_sc_hd__tapvpwrvgnd_1
XTAP_TAPCELL_ROW_28_345 VGND VPWR sky130_fd_sc_hd__tapvpwrvgnd_1
XFILLER_0_11_15 VPWR VGND VPWR VGND sky130_ef_sc_hd__decap_12
XFILLER_0_63_294 VGND VGND VPWR VPWR sky130_fd_sc_hd__fill_1
XFILLER_0_63_261 VPWR VGND VPWR VGND sky130_ef_sc_hd__decap_12
XFILLER_0_23_169 VGND VGND VPWR VPWR sky130_fd_sc_hd__fill_1
Xinput8 io_inB[3] VGND VGND VPWR VPWR net8 sky130_fd_sc_hd__buf_2
XFILLER_0_46_206 VGND VGND VPWR VPWR sky130_fd_sc_hd__decap_4
XFILLER_0_36_56 VGND VGND VPWR VPWR sky130_fd_sc_hd__decap_3
X_2714_ _0249_ _0245_ _0169_ VGND VGND VPWR VPWR _0325_ sky130_fd_sc_hd__a21o_1
XFILLER_0_54_272 VPWR VGND VPWR VGND sky130_ef_sc_hd__decap_12
XFILLER_0_54_261 VGND VGND VPWR VPWR sky130_fd_sc_hd__fill_1
XFILLER_0_14_114 VGND VGND VPWR VPWR sky130_fd_sc_hd__fill_1
X_2576_ _1495_ _1497_ _0112_ VGND VGND VPWR VPWR _0173_ sky130_fd_sc_hd__nor3_1
X_2645_ _0043_ _0248_ VGND VGND VPWR VPWR _0249_ sky130_fd_sc_hd__xnor2_2
XFILLER_0_69_309 VPWR VGND VPWR VGND sky130_ef_sc_hd__decap_12
XTAP_TAPCELL_ROW_33_381 VGND VPWR sky130_fd_sc_hd__tapvpwrvgnd_1
XTAP_TAPCELL_ROW_25_326 VGND VPWR sky130_fd_sc_hd__tapvpwrvgnd_1
XFILLER_0_9_152 VPWR VGND VPWR VGND sky130_ef_sc_hd__decap_12
X_3059_ _0673_ _0675_ VGND VGND VPWR VPWR _0676_ sky130_fd_sc_hd__xnor2_1
XFILLER_0_60_253 VGND VGND VPWR VPWR sky130_fd_sc_hd__decap_8
XFILLER_0_5_391 VGND VGND VPWR VPWR sky130_fd_sc_hd__fill_1
XFILLER_0_20_139 VGND VGND VPWR VPWR sky130_fd_sc_hd__fill_1
XPHY_EDGE_ROW_38_Left_108 VGND VGND VPWR VPWR sky130_fd_sc_hd__decap_3
XFILLER_0_51_231 VGND VGND VPWR VPWR sky130_fd_sc_hd__fill_1
XFILLER_0_3_317 VPWR VGND VPWR VGND sky130_ef_sc_hd__decap_12
X_2430_ _1510_ _1517_ VGND VGND VPWR VPWR _1520_ sky130_fd_sc_hd__nor2_1
XPHY_EDGE_ROW_47_Left_117 VGND VGND VPWR VPWR sky130_fd_sc_hd__decap_3
X_2361_ _1248_ _1425_ VGND VGND VPWR VPWR _1446_ sky130_fd_sc_hd__or2_1
XFILLER_0_11_106 VGND VGND VPWR VPWR sky130_fd_sc_hd__decap_6
X_2292_ _1374_ _1375_ VGND VGND VPWR VPWR _1376_ sky130_fd_sc_hd__or2_1
XPHY_EDGE_ROW_56_Left_126 VGND VGND VPWR VPWR sky130_fd_sc_hd__decap_3
XFILLER_0_47_55 VGND VGND VPWR VPWR sky130_fd_sc_hd__fill_1
XFILLER_0_59_331 VGND VGND VPWR VPWR sky130_fd_sc_hd__decap_4
XTAP_TAPCELL_ROW_22_307 VGND VPWR sky130_fd_sc_hd__tapvpwrvgnd_1
XPHY_EDGE_ROW_65_Left_135 VGND VGND VPWR VPWR sky130_fd_sc_hd__decap_3
XFILLER_0_42_253 VPWR VGND VPWR VGND sky130_ef_sc_hd__decap_12
XTAP_TAPCELL_ROW_30_362 VGND VPWR sky130_fd_sc_hd__tapvpwrvgnd_1
XFILLER_0_27_261 VGND VGND VPWR VPWR sky130_fd_sc_hd__decap_8
X_2628_ _0088_ _1474_ _0099_ _0101_ VGND VGND VPWR VPWR _0230_ sky130_fd_sc_hd__a31oi_1
X_2559_ _0153_ _0143_ _0146_ _0142_ _0151_ VGND VGND VPWR VPWR _0154_ sky130_fd_sc_hd__a311oi_2
XFILLER_0_10_194 VGND VGND VPWR VPWR sky130_fd_sc_hd__fill_2
XFILLER_0_65_367 VPWR VGND VPWR VGND sky130_ef_sc_hd__decap_12
XFILLER_0_18_250 VGND VGND VPWR VPWR sky130_fd_sc_hd__fill_2
XFILLER_0_18_261 VGND VGND VPWR VPWR sky130_fd_sc_hd__fill_2
XFILLER_0_0_309 VPWR VGND VPWR VGND sky130_ef_sc_hd__decap_12
XFILLER_0_17_47 VGND VGND VPWR VPWR sky130_fd_sc_hd__decap_8
XFILLER_0_56_334 VPWR VGND VPWR VGND sky130_ef_sc_hd__decap_12
XFILLER_0_33_57 VGND VGND VPWR VPWR sky130_fd_sc_hd__fill_1
XPHY_EDGE_ROW_1_Left_71 VGND VGND VPWR VPWR sky130_fd_sc_hd__decap_3
X_1930_ _1012_ _1013_ VGND VGND VPWR VPWR _1014_ sky130_fd_sc_hd__xor2_1
XFILLER_0_3_169 VPWR VGND VPWR VGND sky130_ef_sc_hd__decap_12
Xinput11 io_inScaleA[2] VGND VGND VPWR VPWR net11 sky130_fd_sc_hd__clkbuf_1
XFILLER_0_16_209 VPWR VGND VPWR VGND sky130_ef_sc_hd__decap_12
X_1792_ _0875_ VGND VGND VPWR VPWR _0876_ sky130_fd_sc_hd__inv_2
X_1861_ _0647_ _0766_ _0875_ VGND VGND VPWR VPWR _0945_ sky130_fd_sc_hd__a21o_1
XFILLER_0_58_65 VPWR VGND VPWR VGND sky130_ef_sc_hd__decap_12
X_2413_ _1107_ _1183_ _1387_ VGND VGND VPWR VPWR _1502_ sky130_fd_sc_hd__a21o_1
X_2344_ _1269_ _1421_ _1424_ _1427_ VGND VGND VPWR VPWR _1428_ sky130_fd_sc_hd__a31oi_2
X_2275_ _1294_ VGND VGND VPWR VPWR _1359_ sky130_fd_sc_hd__inv_2
XFILLER_0_47_389 VGND VGND VPWR VPWR sky130_fd_sc_hd__decap_3
XFILLER_0_15_264 VGND VGND VPWR VPWR sky130_fd_sc_hd__decap_8
XTAP_TAPCELL_ROW_58_557 VGND VPWR sky130_fd_sc_hd__tapvpwrvgnd_1
XFILLER_0_65_164 VGND VGND VPWR VPWR sky130_fd_sc_hd__decap_4
XFILLER_0_53_337 VGND VGND VPWR VPWR sky130_fd_sc_hd__fill_2
XTAP_TAPCELL_ROW_41_435 VGND VPWR sky130_fd_sc_hd__tapvpwrvgnd_1
XFILLER_0_21_212 VPWR VGND VPWR VGND sky130_ef_sc_hd__decap_12
XFILLER_0_21_289 VGND VGND VPWR VPWR sky130_fd_sc_hd__decap_6
X_2060_ net36 _1143_ _1091_ VGND VGND VPWR VPWR _1144_ sky130_fd_sc_hd__mux2_4
XTAP_TAPCELL_ROW_6_190 VGND VPWR sky130_fd_sc_hd__tapvpwrvgnd_1
XFILLER_0_60_77 VGND VGND VPWR VPWR sky130_fd_sc_hd__decap_6
XFILLER_0_56_197 VGND VGND VPWR VPWR sky130_fd_sc_hd__decap_6
X_2962_ _0436_ _0554_ _0581_ _0514_ VGND VGND VPWR VPWR _0582_ sky130_fd_sc_hd__a2bb2o_1
X_2893_ _1465_ _0313_ VGND VGND VPWR VPWR _0514_ sky130_fd_sc_hd__nor2_2
XFILLER_0_29_323 VPWR VGND VPWR VGND sky130_ef_sc_hd__decap_12
X_1913_ _0100_ _0990_ VGND VGND VPWR VPWR _0997_ sky130_fd_sc_hd__and2b_1
XFILLER_0_69_97 VPWR VGND VPWR VGND sky130_ef_sc_hd__decap_12
XFILLER_0_69_53 VGND VGND VPWR VPWR sky130_fd_sc_hd__decap_3
XFILLER_0_52_392 VGND VGND VPWR VPWR sky130_fd_sc_hd__fill_2
XFILLER_0_4_401 VPWR VGND VPWR VGND sky130_ef_sc_hd__decap_12
X_1775_ _0857_ _0858_ VGND VGND VPWR VPWR _0859_ sky130_fd_sc_hd__and2_1
X_1844_ _0798_ _0926_ _0927_ VGND VGND VPWR VPWR _0928_ sky130_fd_sc_hd__and3_1
XFILLER_0_12_234 VPWR VGND VPWR VGND sky130_ef_sc_hd__decap_12
X_2327_ _1097_ _1410_ VGND VGND VPWR VPWR _1411_ sky130_fd_sc_hd__nor2_1
X_2258_ _1323_ _1146_ _1273_ _1341_ VGND VGND VPWR VPWR _1342_ sky130_fd_sc_hd__a31o_1
XFILLER_0_33_3 VPWR VGND VPWR VGND sky130_ef_sc_hd__decap_12
XTAP_TAPCELL_ROW_55_538 VGND VPWR sky130_fd_sc_hd__tapvpwrvgnd_1
X_2189_ net53 _1272_ net57 VGND VGND VPWR VPWR _1273_ sky130_fd_sc_hd__mux2_1
XTAP_TAPCELL_ROW_63_593 VGND VPWR sky130_fd_sc_hd__tapvpwrvgnd_1
XFILLER_0_62_123 VPWR VGND VPWR VGND sky130_ef_sc_hd__decap_12
XFILLER_0_50_318 VGND VGND VPWR VPWR sky130_fd_sc_hd__fill_2
XFILLER_0_50_307 VGND VGND VPWR VPWR sky130_fd_sc_hd__fill_1
XFILLER_0_47_197 VPWR VGND VPWR VGND sky130_ef_sc_hd__decap_12
XFILLER_0_35_337 VPWR VGND VPWR VGND sky130_ef_sc_hd__decap_12
XTAP_TAPCELL_ROW_3_171 VGND VPWR sky130_fd_sc_hd__tapvpwrvgnd_1
XFILLER_0_38_197 VPWR VGND VPWR VGND sky130_ef_sc_hd__decap_12
XFILLER_0_38_175 VPWR VGND VPWR VGND sky130_ef_sc_hd__decap_12
XFILLER_0_53_156 VGND VGND VPWR VPWR sky130_fd_sc_hd__decap_3
XFILLER_0_41_318 VGND VGND VPWR VPWR sky130_fd_sc_hd__decap_4
XFILLER_0_30_25 VGND VGND VPWR VPWR sky130_fd_sc_hd__decap_3
X_1560_ _0133_ VGND VGND VPWR VPWR _0144_ sky130_fd_sc_hd__buf_2
XFILLER_0_39_78 VGND VGND VPWR VPWR sky130_fd_sc_hd__decap_4
X_2112_ _1170_ VGND VGND VPWR VPWR _1196_ sky130_fd_sc_hd__buf_2
XFILLER_0_55_55 VGND VGND VPWR VPWR sky130_fd_sc_hd__fill_1
X_3092_ clknet_2_1__leaf_clock _0009_ VGND VGND VPWR VPWR net52 sky130_fd_sc_hd__dfxtp_1
X_2043_ _1126_ _1017_ VGND VGND VPWR VPWR _1127_ sky130_fd_sc_hd__or2b_2
X_2945_ _0546_ _0564_ _0447_ VGND VGND VPWR VPWR _0565_ sky130_fd_sc_hd__mux2_4
XFILLER_0_44_145 VGND VGND VPWR VPWR sky130_fd_sc_hd__fill_1
XFILLER_0_44_134 VGND VGND VPWR VPWR sky130_fd_sc_hd__decap_3
X_2876_ _0454_ _0496_ _0372_ VGND VGND VPWR VPWR _0497_ sky130_fd_sc_hd__mux2_4
XFILLER_0_29_131 VPWR VGND VPWR VGND sky130_ef_sc_hd__decap_12
X_1827_ _0910_ _0869_ VGND VGND VPWR VPWR _0911_ sky130_fd_sc_hd__xnor2_1
XFILLER_0_17_337 VGND VGND VPWR VPWR sky130_fd_sc_hd__decap_4
XFILLER_0_4_264 VGND VGND VPWR VPWR sky130_fd_sc_hd__decap_4
XFILLER_0_4_253 VGND VGND VPWR VPWR sky130_fd_sc_hd__decap_4
X_1758_ _0792_ _0772_ VGND VGND VPWR VPWR _0842_ sky130_fd_sc_hd__or2_1
X_1689_ _0768_ _0772_ VGND VGND VPWR VPWR _0773_ sky130_fd_sc_hd__or2_4
XTAP_TAPCELL_ROW_0_152 VGND VPWR sky130_fd_sc_hd__tapvpwrvgnd_1
XTAP_TAPCELL_ROW_0_141 VGND VPWR sky130_fd_sc_hd__tapvpwrvgnd_1
XFILLER_0_35_167 VGND VGND VPWR VPWR sky130_fd_sc_hd__fill_1
XFILLER_0_25_36 VPWR VGND VPWR VGND sky130_ef_sc_hd__decap_12
XFILLER_0_66_281 VGND VGND VPWR VPWR sky130_fd_sc_hd__decap_8
X_2730_ _0168_ _0216_ VGND VGND VPWR VPWR _0343_ sky130_fd_sc_hd__nor2_1
X_2661_ _0074_ _0266_ VGND VGND VPWR VPWR _0267_ sky130_fd_sc_hd__xnor2_2
XFILLER_0_41_46 VGND VGND VPWR VPWR sky130_fd_sc_hd__decap_4
X_2592_ _1292_ _1488_ _1507_ _0135_ VGND VGND VPWR VPWR _0191_ sky130_fd_sc_hd__a31o_1
XFILLER_0_41_137 VPWR VGND VPWR VGND sky130_ef_sc_hd__decap_12
X_1543_ accumulator.state\[1\] accumulator.state\[0\] VGND VGND VPWR VPWR _1465_ sky130_fd_sc_hd__nand2b_1
XFILLER_0_5_24 VPWR VGND VPWR VGND sky130_ef_sc_hd__decap_12
XFILLER_0_1_223 VGND VGND VPWR VPWR sky130_fd_sc_hd__fill_1
X_1612_ _0677_ _0617_ VGND VGND VPWR VPWR _0687_ sky130_fd_sc_hd__xor2_1
XFILLER_0_66_65 VPWR VGND VPWR VGND sky130_ef_sc_hd__decap_12
XFILLER_0_5_57 VGND VGND VPWR VPWR sky130_fd_sc_hd__fill_1
X_3075_ _0683_ _0689_ _0691_ VGND VGND VPWR VPWR _0692_ sky130_fd_sc_hd__and3_1
XFILLER_0_49_204 VGND VGND VPWR VPWR sky130_fd_sc_hd__decap_4
X_2026_ _1075_ _1074_ VGND VGND VPWR VPWR _1110_ sky130_fd_sc_hd__or2b_1
X_2928_ _0401_ _0546_ _0547_ VGND VGND VPWR VPWR _0548_ sky130_fd_sc_hd__o21ai_1
X_2859_ _0439_ _0479_ VGND VGND VPWR VPWR _0005_ sky130_fd_sc_hd__nor2_1
XFILLER_0_17_167 VGND VGND VPWR VPWR sky130_fd_sc_hd__fill_1
XTAP_TAPCELL_ROW_28_346 VGND VPWR sky130_fd_sc_hd__tapvpwrvgnd_1
XFILLER_0_11_27 VGND VGND VPWR VPWR sky130_fd_sc_hd__decap_6
XTAP_TAPCELL_ROW_11_224 VGND VPWR sky130_fd_sc_hd__tapvpwrvgnd_1
Xinput9 io_inScaleA[0] VGND VGND VPWR VPWR net9 sky130_fd_sc_hd__clkbuf_2
X_2644_ _0136_ _0175_ _0247_ VGND VGND VPWR VPWR _0248_ sky130_fd_sc_hd__a21o_1
X_2713_ _0321_ _0323_ VGND VGND VPWR VPWR _0324_ sky130_fd_sc_hd__or2_1
XFILLER_0_54_284 VGND VGND VPWR VPWR sky130_fd_sc_hd__decap_6
XFILLER_0_54_251 VGND VGND VPWR VPWR sky130_fd_sc_hd__fill_1
XFILLER_0_14_104 VGND VGND VPWR VPWR sky130_fd_sc_hd__fill_1
X_2575_ _0136_ _0085_ VGND VGND VPWR VPWR _0172_ sky130_fd_sc_hd__nand2_1
XFILLER_0_10_321 VPWR VGND VPWR VGND sky130_ef_sc_hd__decap_12
XFILLER_0_10_365 VPWR VGND VPWR VGND sky130_ef_sc_hd__decap_12
X_3058_ _0664_ _0674_ VGND VGND VPWR VPWR _0675_ sky130_fd_sc_hd__xnor2_1
XFILLER_0_33_413 VGND VGND VPWR VPWR sky130_fd_sc_hd__fill_2
XTAP_TAPCELL_ROW_33_382 VGND VPWR sky130_fd_sc_hd__tapvpwrvgnd_1
X_2009_ net58 VGND VGND VPWR VPWR _1093_ sky130_fd_sc_hd__buf_6
XTAP_TAPCELL_ROW_25_327 VGND VPWR sky130_fd_sc_hd__tapvpwrvgnd_1
XFILLER_0_9_164 VGND VGND VPWR VPWR sky130_fd_sc_hd__decap_4
XFILLER_0_68_365 VPWR VGND VPWR VGND sky130_ef_sc_hd__decap_12
XFILLER_0_24_402 VGND VGND VPWR VPWR sky130_fd_sc_hd__decap_8
XFILLER_0_22_26 VGND VGND VPWR VPWR sky130_fd_sc_hd__fill_2
XFILLER_0_3_329 VGND VGND VPWR VPWR sky130_fd_sc_hd__decap_6
X_2291_ net44 _1093_ VGND VGND VPWR VPWR _1375_ sky130_fd_sc_hd__nand2_1
X_2360_ _1297_ _1419_ _1420_ VGND VGND VPWR VPWR _1445_ sky130_fd_sc_hd__o21a_1
XFILLER_0_63_55 VGND VGND VPWR VPWR sky130_fd_sc_hd__fill_1
XPHY_EDGE_ROW_10_Right_10 VGND VGND VPWR VPWR sky130_fd_sc_hd__decap_3
XFILLER_0_19_229 VGND VGND VPWR VPWR sky130_fd_sc_hd__decap_3
X_2627_ _1355_ _1478_ VGND VGND VPWR VPWR _0229_ sky130_fd_sc_hd__nand2_1
XFILLER_0_63_3 VPWR VGND VPWR VGND sky130_ef_sc_hd__decap_12
XFILLER_0_42_265 VGND VGND VPWR VPWR sky130_fd_sc_hd__fill_1
XTAP_TAPCELL_ROW_30_363 VGND VPWR sky130_fd_sc_hd__tapvpwrvgnd_1
XFILLER_0_27_273 VGND VGND VPWR VPWR sky130_fd_sc_hd__decap_6
XFILLER_0_6_167 VGND VGND VPWR VPWR sky130_fd_sc_hd__fill_1
X_2489_ _0047_ _0051_ _0076_ VGND VGND VPWR VPWR _0077_ sky130_fd_sc_hd__a21o_1
X_2558_ net67 _0081_ _0083_ _1190_ VGND VGND VPWR VPWR _0153_ sky130_fd_sc_hd__a31o_1
XFILLER_0_65_379 VPWR VGND VPWR VGND sky130_ef_sc_hd__decap_12
XFILLER_0_65_335 VGND VGND VPWR VPWR sky130_fd_sc_hd__fill_1
XFILLER_0_18_240 VGND VGND VPWR VPWR sky130_fd_sc_hd__decap_6
XFILLER_0_21_405 VGND VGND VPWR VPWR sky130_fd_sc_hd__decap_6
XFILLER_0_56_346 VPWR VGND VPWR VGND sky130_ef_sc_hd__decap_12
XTAP_TAPCELL_ROW_44_455 VGND VPWR sky130_fd_sc_hd__tapvpwrvgnd_1
X_1860_ _0790_ _0768_ VGND VGND VPWR VPWR _0944_ sky130_fd_sc_hd__and2_1
XFILLER_0_24_243 VGND VGND VPWR VPWR sky130_fd_sc_hd__fill_1
XFILLER_0_24_221 VGND VGND VPWR VPWR sky130_fd_sc_hd__decap_4
Xinput12 io_inScaleA[3] VGND VGND VPWR VPWR net12 sky130_fd_sc_hd__clkbuf_1
X_1791_ _0243_ _0320_ _0657_ VGND VGND VPWR VPWR _0875_ sky130_fd_sc_hd__o21a_1
XFILLER_0_58_77 VGND VGND VPWR VPWR sky130_fd_sc_hd__fill_2
X_2412_ _1249_ _1343_ _1377_ VGND VGND VPWR VPWR _1501_ sky130_fd_sc_hd__a21o_1
X_2343_ _1269_ _1426_ VGND VGND VPWR VPWR _1427_ sky130_fd_sc_hd__nor2_1
X_2274_ _1249_ _1356_ _1357_ VGND VGND VPWR VPWR _1358_ sky130_fd_sc_hd__o21a_1
X_1989_ _1070_ _1071_ _1072_ VGND VGND VPWR VPWR _1073_ sky130_fd_sc_hd__a21o_4
XFILLER_0_2_192 VGND VGND VPWR VPWR sky130_fd_sc_hd__fill_1
XTAP_TAPCELL_ROW_58_558 VGND VPWR sky130_fd_sc_hd__tapvpwrvgnd_1
XTAP_TAPCELL_ROW_41_436 VGND VPWR sky130_fd_sc_hd__tapvpwrvgnd_1
XFILLER_0_65_187 VGND VGND VPWR VPWR sky130_fd_sc_hd__fill_1
XFILLER_0_61_393 VPWR VGND VPWR VGND sky130_ef_sc_hd__decap_12
XFILLER_0_21_279 VGND VGND VPWR VPWR sky130_fd_sc_hd__fill_1
XFILLER_0_29_302 VGND VGND VPWR VPWR sky130_fd_sc_hd__fill_2
XTAP_TAPCELL_ROW_6_191 VGND VPWR sky130_fd_sc_hd__tapvpwrvgnd_1
XFILLER_0_56_176 VGND VGND VPWR VPWR sky130_fd_sc_hd__decap_3
X_2961_ _0548_ _0580_ _0509_ VGND VGND VPWR VPWR _0581_ sky130_fd_sc_hd__mux2_1
XFILLER_0_44_327 VGND VGND VPWR VPWR sky130_fd_sc_hd__fill_2
XFILLER_0_44_305 VGND VGND VPWR VPWR sky130_fd_sc_hd__decap_3
X_2892_ _0436_ _0504_ VGND VGND VPWR VPWR _0513_ sky130_fd_sc_hd__nor2_1
XFILLER_0_29_357 VPWR VGND VPWR VGND sky130_ef_sc_hd__decap_12
XFILLER_0_29_335 VGND VGND VPWR VPWR sky130_fd_sc_hd__fill_1
XFILLER_0_4_413 VGND VGND VPWR VPWR sky130_fd_sc_hd__fill_2
X_1843_ _0778_ _0775_ _0762_ _0768_ VGND VGND VPWR VPWR _0927_ sky130_fd_sc_hd__o22a_1
XFILLER_0_8_229 VGND VGND VPWR VPWR sky130_fd_sc_hd__fill_1
X_1912_ _0995_ _0968_ VGND VGND VPWR VPWR _0996_ sky130_fd_sc_hd__or2_1
X_1774_ _0855_ _0854_ VGND VGND VPWR VPWR _0858_ sky130_fd_sc_hd__xor2_1
XFILLER_0_12_246 VGND VGND VPWR VPWR sky130_fd_sc_hd__decap_6
X_2326_ _1249_ _1384_ _1409_ _1268_ VGND VGND VPWR VPWR _1410_ sky130_fd_sc_hd__o211a_1
X_2257_ _1108_ _1113_ _1283_ VGND VGND VPWR VPWR _1341_ sky130_fd_sc_hd__and3_1
XTAP_TAPCELL_ROW_63_594 VGND VPWR sky130_fd_sc_hd__tapvpwrvgnd_1
XFILLER_0_47_121 VGND VGND VPWR VPWR sky130_fd_sc_hd__fill_2
XFILLER_0_47_110 VGND VGND VPWR VPWR sky130_fd_sc_hd__fill_2
XFILLER_0_35_305 VGND VGND VPWR VPWR sky130_fd_sc_hd__fill_2
X_2188_ _1126_ _1008_ _1156_ _1127_ VGND VGND VPWR VPWR _1272_ sky130_fd_sc_hd__o211a_1
XFILLER_0_62_179 VGND VGND VPWR VPWR sky130_fd_sc_hd__fill_1
XFILLER_0_62_135 VGND VGND VPWR VPWR sky130_fd_sc_hd__decap_4
XFILLER_0_43_360 VPWR VGND VPWR VGND sky130_ef_sc_hd__decap_12
XFILLER_0_35_349 VGND VGND VPWR VPWR sky130_fd_sc_hd__decap_3
Xclone26 _1018_ VGND VGND VPWR VPWR net81 sky130_fd_sc_hd__buf_2
XFILLER_0_7_295 VPWR VGND VPWR VGND sky130_ef_sc_hd__decap_12
XTAP_TAPCELL_ROW_3_172 VGND VPWR sky130_fd_sc_hd__tapvpwrvgnd_1
XFILLER_0_14_27 VGND VGND VPWR VPWR sky130_fd_sc_hd__fill_1
XFILLER_0_53_113 VGND VGND VPWR VPWR sky130_fd_sc_hd__decap_4
XFILLER_0_53_102 VGND VGND VPWR VPWR sky130_fd_sc_hd__fill_2
XFILLER_0_38_187 VGND VGND VPWR VPWR sky130_fd_sc_hd__decap_8
XFILLER_0_61_190 VGND VGND VPWR VPWR sky130_fd_sc_hd__decap_8
XFILLER_0_1_405 VGND VGND VPWR VPWR sky130_fd_sc_hd__decap_8
X_2111_ net26 _1194_ _1092_ VGND VGND VPWR VPWR _1195_ sky130_fd_sc_hd__mux2_2
X_3091_ clknet_2_0__leaf_clock _0008_ VGND VGND VPWR VPWR net51 sky130_fd_sc_hd__dfxtp_1
X_2042_ _0933_ _0935_ _0963_ VGND VGND VPWR VPWR _1126_ sky130_fd_sc_hd__or3b_2
XFILLER_0_29_143 VGND VGND VPWR VPWR sky130_fd_sc_hd__decap_6
XPHY_EDGE_ROW_8_Right_8 VGND VGND VPWR VPWR sky130_fd_sc_hd__decap_3
X_2944_ _0563_ _0378_ _0426_ VGND VGND VPWR VPWR _0564_ sky130_fd_sc_hd__mux2_2
X_2875_ _0471_ _0495_ _0446_ VGND VGND VPWR VPWR _0496_ sky130_fd_sc_hd__mux2_4
XFILLER_0_44_179 VGND VGND VPWR VPWR sky130_fd_sc_hd__decap_4
XFILLER_0_44_124 VGND VGND VPWR VPWR sky130_fd_sc_hd__fill_1
XFILLER_0_44_113 VGND VGND VPWR VPWR sky130_fd_sc_hd__fill_1
XFILLER_0_25_393 VPWR VGND VPWR VGND sky130_ef_sc_hd__decap_12
XFILLER_0_4_221 VPWR VGND VPWR VGND sky130_ef_sc_hd__decap_12
X_1826_ _0792_ _0823_ VGND VGND VPWR VPWR _0910_ sky130_fd_sc_hd__nor2_1
XPHY_EDGE_ROW_39_Right_39 VGND VGND VPWR VPWR sky130_fd_sc_hd__decap_3
XFILLER_0_40_363 VGND VGND VPWR VPWR sky130_fd_sc_hd__fill_1
X_1688_ _0770_ _0771_ VGND VGND VPWR VPWR _0772_ sky130_fd_sc_hd__or2_4
X_1757_ _0838_ _0840_ VGND VGND VPWR VPWR _0841_ sky130_fd_sc_hd__or2b_1
X_2309_ _1108_ _1364_ _1365_ _1169_ _1172_ VGND VGND VPWR VPWR _1393_ sky130_fd_sc_hd__o2111a_1
XTAP_TAPCELL_ROW_0_153 VGND VPWR sky130_fd_sc_hd__tapvpwrvgnd_1
XTAP_TAPCELL_ROW_0_142 VGND VPWR sky130_fd_sc_hd__tapvpwrvgnd_1
XPHY_EDGE_ROW_48_Right_48 VGND VGND VPWR VPWR sky130_fd_sc_hd__decap_3
XFILLER_0_35_113 VGND VGND VPWR VPWR sky130_fd_sc_hd__decap_3
XPHY_EDGE_ROW_57_Right_57 VGND VGND VPWR VPWR sky130_fd_sc_hd__decap_3
XFILLER_0_43_190 VPWR VGND VPWR VGND sky130_ef_sc_hd__decap_12
XPHY_EDGE_ROW_66_Right_66 VGND VGND VPWR VPWR sky130_fd_sc_hd__decap_3
XFILLER_0_25_48 VGND VGND VPWR VPWR sky130_fd_sc_hd__decap_3
X_2660_ _0262_ _0264_ _0181_ VGND VGND VPWR VPWR _0266_ sky130_fd_sc_hd__mux2_1
XFILLER_0_41_149 VGND VGND VPWR VPWR sky130_fd_sc_hd__fill_2
XFILLER_0_41_69 VPWR VGND VPWR VGND sky130_ef_sc_hd__decap_12
X_1611_ net9 _0320_ _0667_ VGND VGND VPWR VPWR _0677_ sky130_fd_sc_hd__and3_1
X_2591_ _1507_ _0189_ VGND VGND VPWR VPWR _0190_ sky130_fd_sc_hd__xor2_2
XFILLER_0_34_190 VGND VGND VPWR VPWR sky130_fd_sc_hd__decap_6
X_1542_ _1444_ VGND VGND VPWR VPWR net54 sky130_fd_sc_hd__clkbuf_1
XFILLER_0_5_36 VPWR VGND VPWR VGND sky130_ef_sc_hd__decap_12
XFILLER_0_1_235 VPWR VGND VPWR VGND sky130_ef_sc_hd__decap_12
XFILLER_0_66_77 VGND VGND VPWR VPWR sky130_fd_sc_hd__decap_6
X_2025_ _1108_ VGND VGND VPWR VPWR _1109_ sky130_fd_sc_hd__buf_2
XFILLER_0_10_6 VGND VGND VPWR VPWR sky130_fd_sc_hd__decap_3
X_3074_ _0690_ _0688_ VGND VGND VPWR VPWR _0691_ sky130_fd_sc_hd__xor2_1
XFILLER_0_57_271 VGND VGND VPWR VPWR sky130_fd_sc_hd__decap_8
X_2927_ _0447_ _0531_ VGND VGND VPWR VPWR _0547_ sky130_fd_sc_hd__or2_1
XFILLER_0_49_216 VGND VGND VPWR VPWR sky130_fd_sc_hd__fill_1
XFILLER_0_60_414 VGND VGND VPWR VPWR sky130_fd_sc_hd__fill_1
X_2789_ _0406_ _0405_ _0167_ VGND VGND VPWR VPWR _0407_ sky130_fd_sc_hd__mux2_4
XFILLER_0_40_171 VGND VGND VPWR VPWR sky130_fd_sc_hd__decap_6
X_2858_ net48 _1476_ _0469_ _0478_ VGND VGND VPWR VPWR _0479_ sky130_fd_sc_hd__o2bb2a_4
XFILLER_0_32_138 VGND VGND VPWR VPWR sky130_fd_sc_hd__fill_2
X_1809_ _0889_ _0891_ VGND VGND VPWR VPWR _0893_ sky130_fd_sc_hd__and2b_1
XTAP_TAPCELL_ROW_28_347 VGND VPWR sky130_fd_sc_hd__tapvpwrvgnd_1
XTAP_TAPCELL_ROW_11_225 VGND VPWR sky130_fd_sc_hd__tapvpwrvgnd_1
XFILLER_0_6_305 VGND VGND VPWR VPWR sky130_fd_sc_hd__decap_3
X_2712_ _0249_ _0322_ VGND VGND VPWR VPWR _0323_ sky130_fd_sc_hd__xnor2_2
X_2643_ _0038_ _0170_ _0246_ _0181_ VGND VGND VPWR VPWR _0247_ sky130_fd_sc_hd__o211a_1
X_2574_ _0170_ _0046_ _0048_ VGND VGND VPWR VPWR _0171_ sky130_fd_sc_hd__o21a_1
XFILLER_0_42_403 VGND VGND VPWR VPWR sky130_fd_sc_hd__decap_8
XFILLER_0_10_333 VPWR VGND VPWR VGND sky130_ef_sc_hd__decap_12
XFILLER_0_10_377 VPWR VGND VPWR VGND sky130_ef_sc_hd__decap_12
X_2008_ _1091_ VGND VGND VPWR VPWR _1092_ sky130_fd_sc_hd__buf_6
XTAP_TAPCELL_ROW_25_328 VGND VPWR sky130_fd_sc_hd__tapvpwrvgnd_1
X_3057_ net42 _1322_ _0149_ VGND VGND VPWR VPWR _0674_ sky130_fd_sc_hd__a21oi_1
XFILLER_0_37_208 VGND VGND VPWR VPWR sky130_fd_sc_hd__fill_1
XTAP_TAPCELL_ROW_33_383 VGND VPWR sky130_fd_sc_hd__tapvpwrvgnd_1
XFILLER_0_9_110 VGND VGND VPWR VPWR sky130_fd_sc_hd__fill_2
XFILLER_0_5_393 VPWR VGND VPWR VGND sky130_ef_sc_hd__decap_12
XFILLER_0_68_377 VPWR VGND VPWR VGND sky130_ef_sc_hd__decap_12
X_2290_ _1269_ _1358_ _1359_ _1363_ _1373_ VGND VGND VPWR VPWR _1374_ sky130_fd_sc_hd__a32o_1
XFILLER_0_47_57 VGND VGND VPWR VPWR sky130_fd_sc_hd__decap_4
XFILLER_0_2_15 VPWR VGND VPWR VGND sky130_ef_sc_hd__decap_12
XFILLER_0_42_222 VGND VGND VPWR VPWR sky130_fd_sc_hd__decap_8
X_2626_ _0102_ _0087_ VGND VGND VPWR VPWR _0228_ sky130_fd_sc_hd__nand2_1
XFILLER_0_56_3 VPWR VGND VPWR VGND sky130_ef_sc_hd__decap_12
X_2557_ _0145_ _1190_ _0084_ _0147_ _0151_ VGND VGND VPWR VPWR _0152_ sky130_fd_sc_hd__o311a_4
XFILLER_0_30_406 VGND VGND VPWR VPWR sky130_fd_sc_hd__decap_4
XFILLER_0_2_363 VGND VGND VPWR VPWR sky130_fd_sc_hd__fill_1
XFILLER_0_10_130 VGND VGND VPWR VPWR sky130_fd_sc_hd__decap_8
XFILLER_0_10_141 VGND VGND VPWR VPWR sky130_fd_sc_hd__fill_2
XFILLER_0_12_82 VGND VGND VPWR VPWR sky130_fd_sc_hd__fill_2
X_2488_ _0064_ _0075_ VGND VGND VPWR VPWR _0076_ sky130_fd_sc_hd__nand2_1
XFILLER_0_10_174 VPWR VGND VPWR VGND sky130_ef_sc_hd__decap_12
XFILLER_0_65_303 VPWR VGND VPWR VGND sky130_ef_sc_hd__decap_12
X_3109_ clknet_2_2__leaf_clock _0026_ VGND VGND VPWR VPWR net39 sky130_fd_sc_hd__dfxtp_2
XFILLER_0_33_15 VPWR VGND VPWR VGND sky130_ef_sc_hd__decap_12
XFILLER_0_68_141 VGND VGND VPWR VPWR sky130_fd_sc_hd__fill_2
XFILLER_0_56_358 VGND VGND VPWR VPWR sky130_fd_sc_hd__decap_6
XTAP_TAPCELL_ROW_44_456 VGND VPWR sky130_fd_sc_hd__tapvpwrvgnd_1
X_1790_ _0791_ _0836_ VGND VGND VPWR VPWR _0874_ sky130_fd_sc_hd__or2_1
Xinput13 io_inScaleA[4] VGND VGND VPWR VPWR net13 sky130_fd_sc_hd__buf_2
X_2411_ _1187_ _1272_ _1499_ VGND VGND VPWR VPWR _1500_ sky130_fd_sc_hd__a21oi_2
X_2342_ _1105_ _1425_ VGND VGND VPWR VPWR _1426_ sky130_fd_sc_hd__or2_1
X_2273_ _1297_ _1298_ _1299_ _1106_ VGND VGND VPWR VPWR _1357_ sky130_fd_sc_hd__a211o_1
XFILLER_0_59_163 VGND VGND VPWR VPWR sky130_fd_sc_hd__decap_4
XFILLER_0_62_317 VGND VGND VPWR VPWR sky130_fd_sc_hd__fill_1
XFILLER_0_47_369 VPWR VGND VPWR VGND sky130_ef_sc_hd__decap_12
XFILLER_0_30_203 VGND VGND VPWR VPWR sky130_fd_sc_hd__fill_1
XFILLER_0_15_211 VGND VGND VPWR VPWR sky130_fd_sc_hd__fill_1
X_1988_ net42 _1056_ VGND VGND VPWR VPWR _1072_ sky130_fd_sc_hd__and2_1
X_2609_ _1441_ _0205_ _0208_ VGND VGND VPWR VPWR _0209_ sky130_fd_sc_hd__nor3_1
XTAP_TAPCELL_ROW_58_559 VGND VPWR sky130_fd_sc_hd__tapvpwrvgnd_1
XTAP_TAPCELL_ROW_41_437 VGND VPWR sky130_fd_sc_hd__tapvpwrvgnd_1
XFILLER_0_38_369 VGND VGND VPWR VPWR sky130_fd_sc_hd__fill_1
XFILLER_0_38_325 VGND VGND VPWR VPWR sky130_fd_sc_hd__decap_3
XFILLER_0_46_380 VPWR VGND VPWR VGND sky130_ef_sc_hd__decap_12
XFILLER_0_21_225 VGND VGND VPWR VPWR sky130_fd_sc_hd__decap_8
XFILLER_0_21_247 VPWR VGND VPWR VGND sky130_ef_sc_hd__decap_12
XFILLER_0_28_15 VPWR VGND VPWR VGND sky130_ef_sc_hd__decap_12
XTAP_TAPCELL_ROW_6_192 VGND VPWR sky130_fd_sc_hd__tapvpwrvgnd_1
XFILLER_0_56_100 VGND VGND VPWR VPWR sky130_fd_sc_hd__fill_2
X_2960_ _0578_ VGND VGND VPWR VPWR _0580_ sky130_fd_sc_hd__inv_2
XFILLER_0_44_69 VPWR VGND VPWR VGND sky130_ef_sc_hd__decap_12
X_2891_ _0502_ _0512_ _0439_ VGND VGND VPWR VPWR _0008_ sky130_fd_sc_hd__a21oi_1
XFILLER_0_29_369 VGND VGND VPWR VPWR sky130_fd_sc_hd__decap_3
X_1773_ _0792_ _0807_ VGND VGND VPWR VPWR _0857_ sky130_fd_sc_hd__nor2_1
X_1842_ _0792_ _0775_ _0800_ VGND VGND VPWR VPWR _0926_ sky130_fd_sc_hd__or3_1
X_1911_ _0992_ _0994_ VGND VGND VPWR VPWR _0995_ sky130_fd_sc_hd__nand2b_1
X_2325_ _1323_ _1105_ _1271_ _1408_ VGND VGND VPWR VPWR _1409_ sky130_fd_sc_hd__or4_1
X_2187_ _1176_ VGND VGND VPWR VPWR _1271_ sky130_fd_sc_hd__buf_2
X_2256_ _1109_ _1146_ _1204_ _1339_ VGND VGND VPWR VPWR _1340_ sky130_fd_sc_hd__a31o_1
XFILLER_0_43_372 VGND VGND VPWR VPWR sky130_fd_sc_hd__decap_8
Xclone27 _0426_ VGND VGND VPWR VPWR net82 sky130_fd_sc_hd__clkbuf_16
XTAP_TAPCELL_ROW_3_173 VGND VPWR sky130_fd_sc_hd__tapvpwrvgnd_1
XFILLER_0_53_169 VGND VGND VPWR VPWR sky130_fd_sc_hd__fill_2
XFILLER_0_53_125 VGND VGND VPWR VPWR sky130_fd_sc_hd__decap_8
XFILLER_0_34_361 VGND VGND VPWR VPWR sky130_fd_sc_hd__decap_3
XFILLER_0_19_391 VGND VGND VPWR VPWR sky130_fd_sc_hd__fill_1
XFILLER_0_61_180 VGND VGND VPWR VPWR sky130_fd_sc_hd__fill_1
XFILLER_0_55_57 VPWR VGND VPWR VGND sky130_ef_sc_hd__decap_12
X_3090_ clknet_2_3__leaf_clock _0007_ VGND VGND VPWR VPWR net50 sky130_fd_sc_hd__dfxtp_1
X_2110_ _1127_ _1157_ VGND VGND VPWR VPWR _1194_ sky130_fd_sc_hd__and2_1
X_2041_ _1118_ _1124_ _1011_ VGND VGND VPWR VPWR _1125_ sky130_fd_sc_hd__mux2_1
X_2943_ _0323_ VGND VGND VPWR VPWR _0563_ sky130_fd_sc_hd__inv_2
XFILLER_0_17_306 VGND VGND VPWR VPWR sky130_fd_sc_hd__fill_2
X_2874_ _0347_ _0354_ _0429_ VGND VGND VPWR VPWR _0495_ sky130_fd_sc_hd__mux2_4
XFILLER_0_25_383 VGND VGND VPWR VPWR sky130_fd_sc_hd__decap_8
XFILLER_0_25_372 VGND VGND VPWR VPWR sky130_fd_sc_hd__decap_3
XFILLER_0_25_350 VGND VGND VPWR VPWR sky130_fd_sc_hd__decap_6
XFILLER_0_4_233 VPWR VGND VPWR VGND sky130_ef_sc_hd__decap_12
X_1756_ _0825_ _0839_ VGND VGND VPWR VPWR _0840_ sky130_fd_sc_hd__and2_4
X_1825_ _0882_ _0884_ VGND VGND VPWR VPWR _0909_ sky130_fd_sc_hd__nand2b_1
X_2308_ net22 _1093_ VGND VGND VPWR VPWR _1392_ sky130_fd_sc_hd__nand2_1
X_1687_ _0769_ _0735_ _0745_ VGND VGND VPWR VPWR _0771_ sky130_fd_sc_hd__and3_1
X_2239_ _1170_ VGND VGND VPWR VPWR _1323_ sky130_fd_sc_hd__buf_2
XTAP_TAPCELL_ROW_0_143 VGND VPWR sky130_fd_sc_hd__tapvpwrvgnd_1
XTAP_TAPCELL_ROW_51_510 VGND VPWR sky130_fd_sc_hd__tapvpwrvgnd_1
XFILLER_0_35_169 VGND VGND VPWR VPWR sky130_fd_sc_hd__decap_8
XFILLER_0_0_81 VGND VGND VPWR VPWR sky130_fd_sc_hd__decap_3
XFILLER_0_50_117 VGND VGND VPWR VPWR sky130_fd_sc_hd__decap_8
XFILLER_0_43_180 VGND VGND VPWR VPWR sky130_fd_sc_hd__decap_6
XFILLER_0_8_3 VPWR VGND VPWR VGND sky130_ef_sc_hd__decap_12
XFILLER_0_58_239 VGND VGND VPWR VPWR sky130_fd_sc_hd__decap_8
XFILLER_0_41_15 VPWR VGND VPWR VGND sky130_ef_sc_hd__decap_12
XTAP_TAPCELL_ROW_14_245 VGND VPWR sky130_fd_sc_hd__tapvpwrvgnd_1
X_2590_ _0180_ _1292_ _1488_ _0187_ VGND VGND VPWR VPWR _0189_ sky130_fd_sc_hd__a31o_1
XFILLER_0_26_169 VGND VGND VPWR VPWR sky130_fd_sc_hd__fill_2
XFILLER_0_26_147 VGND VGND VPWR VPWR sky130_fd_sc_hd__fill_1
XFILLER_0_26_136 VGND VGND VPWR VPWR sky130_fd_sc_hd__decap_4
XFILLER_0_22_342 VGND VGND VPWR VPWR sky130_fd_sc_hd__fill_1
XFILLER_0_1_225 VGND VGND VPWR VPWR sky130_fd_sc_hd__decap_4
X_1610_ _0243_ _0199_ VGND VGND VPWR VPWR _0667_ sky130_fd_sc_hd__and2_1
X_1541_ accumulator.state\[0\] accumulator.state\[1\] VGND VGND VPWR VPWR _1444_ sky130_fd_sc_hd__and2b_1
XFILLER_0_5_48 VGND VGND VPWR VPWR sky130_fd_sc_hd__decap_8
XFILLER_0_5_15 VGND VGND VPWR VPWR sky130_fd_sc_hd__decap_6
XFILLER_0_1_247 VGND VGND VPWR VPWR sky130_fd_sc_hd__decap_4
XTAP_TAPCELL_ROW_65_602 VGND VPWR sky130_fd_sc_hd__tapvpwrvgnd_1
X_2024_ _1084_ VGND VGND VPWR VPWR _1108_ sky130_fd_sc_hd__buf_2
X_3073_ net45 net90 VGND VGND VPWR VPWR _0690_ sky130_fd_sc_hd__nand2_1
XFILLER_0_64_209 VPWR VGND VPWR VGND sky130_ef_sc_hd__decap_12
X_2926_ _0545_ _0319_ _0426_ VGND VGND VPWR VPWR _0546_ sky130_fd_sc_hd__mux2_4
X_2857_ _0473_ _0474_ _0477_ VGND VGND VPWR VPWR _0478_ sky130_fd_sc_hd__mux2_4
XPHY_EDGE_ROW_17_Left_87 VGND VGND VPWR VPWR sky130_fd_sc_hd__decap_3
XFILLER_0_17_169 VPWR VGND VPWR VGND sky130_ef_sc_hd__decap_12
X_2788_ _1412_ _0405_ _0387_ VGND VGND VPWR VPWR _0406_ sky130_fd_sc_hd__a21oi_1
X_1739_ _0713_ _0822_ VGND VGND VPWR VPWR _0823_ sky130_fd_sc_hd__xor2_4
X_1808_ _0889_ _0891_ VGND VGND VPWR VPWR _0892_ sky130_fd_sc_hd__xnor2_2
XFILLER_0_48_250 VGND VGND VPWR VPWR sky130_fd_sc_hd__fill_2
XTAP_TAPCELL_ROW_28_348 VGND VPWR sky130_fd_sc_hd__tapvpwrvgnd_1
XFILLER_0_51_404 VGND VGND VPWR VPWR sky130_fd_sc_hd__decap_3
XTAP_TAPCELL_ROW_11_226 VGND VPWR sky130_fd_sc_hd__tapvpwrvgnd_1
XFILLER_0_31_150 VGND VGND VPWR VPWR sky130_fd_sc_hd__decap_6
XFILLER_0_36_48 VGND VGND VPWR VPWR sky130_fd_sc_hd__decap_8
XFILLER_0_36_15 VPWR VGND VPWR VGND sky130_ef_sc_hd__decap_12
X_2711_ _0169_ _0245_ VGND VGND VPWR VPWR _0322_ sky130_fd_sc_hd__nor2_2
XFILLER_0_54_253 VGND VGND VPWR VPWR sky130_fd_sc_hd__decap_8
XFILLER_0_39_261 VPWR VGND VPWR VGND sky130_ef_sc_hd__decap_12
X_2642_ _1540_ _0035_ VGND VGND VPWR VPWR _0246_ sky130_fd_sc_hd__nand2_1
X_2573_ _1265_ _1527_ VGND VGND VPWR VPWR _0170_ sky130_fd_sc_hd__and2_1
XFILLER_0_22_150 VGND VGND VPWR VPWR sky130_fd_sc_hd__fill_1
XFILLER_0_10_345 VPWR VGND VPWR VGND sky130_ef_sc_hd__decap_12
XFILLER_0_10_389 VPWR VGND VPWR VGND sky130_ef_sc_hd__decap_12
X_2007_ net45 net90 VGND VGND VPWR VPWR _1091_ sky130_fd_sc_hd__xnor2_4
X_3056_ _0661_ _0669_ _0668_ VGND VGND VPWR VPWR _0673_ sky130_fd_sc_hd__a21oi_2
XFILLER_0_60_245 VGND VGND VPWR VPWR sky130_fd_sc_hd__decap_6
XTAP_TAPCELL_ROW_33_384 VGND VPWR sky130_fd_sc_hd__tapvpwrvgnd_1
X_2909_ net87 _1487_ VGND VGND VPWR VPWR _0529_ sky130_fd_sc_hd__nand2_1
XFILLER_0_5_361 VPWR VGND VPWR VGND sky130_ef_sc_hd__decap_12
XFILLER_0_18_412 VGND VGND VPWR VPWR sky130_fd_sc_hd__decap_3
XFILLER_0_13_194 VGND VGND VPWR VPWR sky130_fd_sc_hd__fill_1
XFILLER_0_68_389 VPWR VGND VPWR VGND sky130_ef_sc_hd__decap_12
XFILLER_0_28_209 VGND VGND VPWR VPWR sky130_fd_sc_hd__decap_4
XFILLER_0_51_245 VPWR VGND VPWR VGND sky130_ef_sc_hd__decap_12
XFILLER_0_51_223 VGND VGND VPWR VPWR sky130_fd_sc_hd__fill_1
XFILLER_0_36_264 VPWR VGND VPWR VGND sky130_ef_sc_hd__decap_12
XFILLER_0_63_57 VPWR VGND VPWR VGND sky130_ef_sc_hd__decap_12
XTAP_TAPCELL_ROW_47_476 VGND VPWR sky130_fd_sc_hd__tapvpwrvgnd_1
XFILLER_0_2_49 VGND VGND VPWR VPWR sky130_fd_sc_hd__fill_2
XFILLER_0_2_27 VGND VGND VPWR VPWR sky130_fd_sc_hd__fill_1
X_2625_ _0216_ _0222_ _0226_ VGND VGND VPWR VPWR _0227_ sky130_fd_sc_hd__and3_1
X_2487_ _0069_ _0074_ VGND VGND VPWR VPWR _0075_ sky130_fd_sc_hd__nor2_1
X_2556_ _0148_ _0150_ VGND VGND VPWR VPWR _0151_ sky130_fd_sc_hd__nor2_2
XPHY_EDGE_ROW_34_Left_104 VGND VGND VPWR VPWR sky130_fd_sc_hd__decap_3
XFILLER_0_10_186 VGND VGND VPWR VPWR sky130_fd_sc_hd__decap_8
XFILLER_0_69_109 VGND VGND VPWR VPWR sky130_fd_sc_hd__decap_3
XFILLER_0_49_3 VPWR VGND VPWR VGND sky130_ef_sc_hd__decap_12
X_3108_ clknet_2_0__leaf_clock _0025_ VGND VGND VPWR VPWR net38 sky130_fd_sc_hd__dfxtp_1
XFILLER_0_10_197 VGND VGND VPWR VPWR sky130_fd_sc_hd__decap_3
XFILLER_0_65_337 VGND VGND VPWR VPWR sky130_fd_sc_hd__decap_6
XFILLER_0_65_315 VPWR VGND VPWR VGND sky130_ef_sc_hd__decap_12
XPHY_EDGE_ROW_43_Left_113 VGND VGND VPWR VPWR sky130_fd_sc_hd__decap_3
X_3039_ _0639_ _0654_ VGND VGND VPWR VPWR _0656_ sky130_fd_sc_hd__or2_1
XFILLER_0_18_253 VGND VGND VPWR VPWR sky130_fd_sc_hd__decap_8
XPHY_EDGE_ROW_52_Left_122 VGND VGND VPWR VPWR sky130_fd_sc_hd__decap_3
XFILLER_0_33_223 VGND VGND VPWR VPWR sky130_fd_sc_hd__fill_1
XFILLER_0_68_120 VPWR VGND VPWR VGND sky130_ef_sc_hd__decap_12
XPHY_EDGE_ROW_61_Left_131 VGND VGND VPWR VPWR sky130_fd_sc_hd__decap_3
XFILLER_0_56_304 VGND VGND VPWR VPWR sky130_fd_sc_hd__decap_4
XFILLER_0_33_27 VPWR VGND VPWR VGND sky130_ef_sc_hd__decap_12
XTAP_TAPCELL_ROW_44_457 VGND VPWR sky130_fd_sc_hd__tapvpwrvgnd_1
Xinput14 io_inScaleA[5] VGND VGND VPWR VPWR net14 sky130_fd_sc_hd__buf_1
X_2410_ net53 _1093_ VGND VGND VPWR VPWR _1499_ sky130_fd_sc_hd__and2_1
X_2341_ _1219_ _1171_ _1180_ _1146_ VGND VGND VPWR VPWR _1425_ sky130_fd_sc_hd__or4b_1
XFILLER_0_24_278 VGND VGND VPWR VPWR sky130_fd_sc_hd__fill_1
X_2272_ _1297_ net70 VGND VGND VPWR VPWR _1356_ sky130_fd_sc_hd__nor2_1
XFILLER_0_47_337 VGND VGND VPWR VPWR sky130_fd_sc_hd__decap_6
XFILLER_0_47_304 VPWR VGND VPWR VGND sky130_ef_sc_hd__decap_12
XFILLER_0_55_381 VGND VGND VPWR VPWR sky130_fd_sc_hd__decap_8
X_1987_ net42 _1056_ VGND VGND VPWR VPWR _1071_ sky130_fd_sc_hd__or2_1
X_2608_ _0094_ _0207_ VGND VGND VPWR VPWR _0208_ sky130_fd_sc_hd__xor2_2
X_2539_ _0063_ _0130_ _0131_ VGND VGND VPWR VPWR _0132_ sky130_fd_sc_hd__a21bo_1
XFILLER_0_38_304 VGND VGND VPWR VPWR sky130_fd_sc_hd__decap_4
XFILLER_0_46_392 VGND VGND VPWR VPWR sky130_fd_sc_hd__fill_1
XTAP_TAPCELL_ROW_41_438 VGND VPWR sky130_fd_sc_hd__tapvpwrvgnd_1
XPHY_EDGE_ROW_5_Left_75 VGND VGND VPWR VPWR sky130_fd_sc_hd__decap_3
XFILLER_0_0_109 VGND VGND VPWR VPWR sky130_fd_sc_hd__decap_3
XFILLER_0_21_259 VPWR VGND VPWR VGND sky130_ef_sc_hd__decap_12
XFILLER_0_44_15 VPWR VGND VPWR VGND sky130_ef_sc_hd__decap_12
XFILLER_0_28_27 VGND VGND VPWR VPWR sky130_fd_sc_hd__fill_1
XTAP_TAPCELL_ROW_6_193 VGND VPWR sky130_fd_sc_hd__tapvpwrvgnd_1
XFILLER_0_56_123 VGND VGND VPWR VPWR sky130_fd_sc_hd__decap_4
X_2890_ _0376_ _0464_ _0504_ _0510_ _0315_ VGND VGND VPWR VPWR _0512_ sky130_fd_sc_hd__o32a_1
XFILLER_0_8_209 VPWR VGND VPWR VGND sky130_ef_sc_hd__decap_12
X_1910_ _0993_ _0991_ VGND VGND VPWR VPWR _0994_ sky130_fd_sc_hd__nand2_1
X_1772_ _0854_ _0855_ VGND VGND VPWR VPWR _0856_ sky130_fd_sc_hd__nor2_1
XFILLER_0_8_15 VGND VGND VPWR VPWR sky130_fd_sc_hd__decap_4
X_1841_ _0805_ _0817_ _0924_ _0802_ VGND VGND VPWR VPWR _0925_ sky130_fd_sc_hd__o31a_4
X_2324_ net22 _1367_ VGND VGND VPWR VPWR _1408_ sky130_fd_sc_hd__nand2_1
X_2186_ _1269_ VGND VGND VPWR VPWR _1270_ sky130_fd_sc_hd__buf_2
X_2255_ _1196_ _1113_ _1280_ VGND VGND VPWR VPWR _1339_ sky130_fd_sc_hd__and3_1
XFILLER_0_18_82 VGND VGND VPWR VPWR sky130_fd_sc_hd__fill_2
XFILLER_0_47_167 VGND VGND VPWR VPWR sky130_fd_sc_hd__fill_1
XFILLER_0_34_70 VGND VGND VPWR VPWR sky130_fd_sc_hd__decap_3
XFILLER_0_28_392 VGND VGND VPWR VPWR sky130_fd_sc_hd__fill_1
XFILLER_0_7_242 VPWR VGND VPWR VGND sky130_ef_sc_hd__decap_12
XFILLER_0_7_264 VPWR VGND VPWR VGND sky130_ef_sc_hd__decap_12
XFILLER_0_11_281 VGND VGND VPWR VPWR sky130_fd_sc_hd__decap_8
XTAP_TAPCELL_ROW_54_530 VGND VPWR sky130_fd_sc_hd__tapvpwrvgnd_1
XTAP_TAPCELL_ROW_3_174 VGND VPWR sky130_fd_sc_hd__tapvpwrvgnd_1
XFILLER_0_14_29 VPWR VGND VPWR VGND sky130_ef_sc_hd__decap_12
XFILLER_0_39_15 VPWR VGND VPWR VGND sky130_ef_sc_hd__decap_12
XFILLER_0_55_69 VPWR VGND VPWR VGND sky130_ef_sc_hd__decap_12
X_2040_ _1120_ _1123_ _0993_ VGND VGND VPWR VPWR _1124_ sky130_fd_sc_hd__mux2_1
XFILLER_0_69_281 VPWR VGND VPWR VGND sky130_ef_sc_hd__decap_12
X_2873_ _0374_ _0455_ VGND VGND VPWR VPWR _0494_ sky130_fd_sc_hd__or2_4
X_2942_ _0556_ _0562_ _0523_ VGND VGND VPWR VPWR _0014_ sky130_fd_sc_hd__o21a_1
XFILLER_0_17_318 VGND VGND VPWR VPWR sky130_fd_sc_hd__fill_1
XFILLER_0_4_245 VGND VGND VPWR VPWR sky130_fd_sc_hd__decap_6
X_1686_ _0735_ _0769_ _0745_ VGND VGND VPWR VPWR _0770_ sky130_fd_sc_hd__a21oi_2
X_1755_ _0144_ _0785_ _0824_ VGND VGND VPWR VPWR _0839_ sky130_fd_sc_hd__o21ai_1
X_1824_ _0895_ _0906_ _0907_ VGND VGND VPWR VPWR _0908_ sky130_fd_sc_hd__o21bai_4
X_2307_ _1389_ _1390_ VGND VGND VPWR VPWR _1391_ sky130_fd_sc_hd__or2_1
X_2238_ _1093_ VGND VGND VPWR VPWR _1322_ sky130_fd_sc_hd__clkbuf_4
XFILLER_0_29_81 VPWR VGND VPWR VGND sky130_ef_sc_hd__decap_12
XTAP_TAPCELL_ROW_0_144 VGND VPWR sky130_fd_sc_hd__tapvpwrvgnd_1
X_2169_ _1131_ _1136_ _1147_ VGND VGND VPWR VPWR _1253_ sky130_fd_sc_hd__mux2_1
XFILLER_0_63_413 VGND VGND VPWR VPWR sky130_fd_sc_hd__fill_2
XFILLER_0_50_107 VGND VGND VPWR VPWR sky130_fd_sc_hd__decap_3
XFILLER_0_35_148 VGND VGND VPWR VPWR sky130_fd_sc_hd__decap_3
XFILLER_0_16_351 VPWR VGND VPWR VGND sky130_ef_sc_hd__decap_12
XFILLER_0_9_91 VGND VGND VPWR VPWR sky130_fd_sc_hd__decap_8
XFILLER_0_41_27 VGND VGND VPWR VPWR sky130_fd_sc_hd__decap_6
XTAP_TAPCELL_ROW_14_246 VGND VPWR sky130_fd_sc_hd__tapvpwrvgnd_1
XFILLER_0_34_181 VGND VGND VPWR VPWR sky130_fd_sc_hd__decap_3
XFILLER_0_22_365 VGND VGND VPWR VPWR sky130_fd_sc_hd__fill_1
XTAP_TAPCELL_ROW_65_603 VGND VPWR sky130_fd_sc_hd__tapvpwrvgnd_1
XFILLER_0_49_229 VGND VGND VPWR VPWR sky130_fd_sc_hd__fill_1
X_2023_ _1106_ VGND VGND VPWR VPWR _1107_ sky130_fd_sc_hd__clkbuf_4
X_3072_ _0674_ _0688_ VGND VGND VPWR VPWR _0689_ sky130_fd_sc_hd__or2_1
X_2925_ _0363_ VGND VGND VPWR VPWR _0545_ sky130_fd_sc_hd__inv_2
X_2856_ _0476_ VGND VGND VPWR VPWR _0477_ sky130_fd_sc_hd__inv_2
XFILLER_0_32_118 VGND VGND VPWR VPWR sky130_fd_sc_hd__decap_6
XFILLER_0_9_337 VPWR VGND VPWR VGND sky130_ef_sc_hd__decap_12
X_1807_ _0878_ _0890_ VGND VGND VPWR VPWR _0891_ sky130_fd_sc_hd__nor2_1
XFILLER_0_17_126 VGND VGND VPWR VPWR sky130_fd_sc_hd__fill_1
XFILLER_0_17_137 VPWR VGND VPWR VGND sky130_ef_sc_hd__decap_12
X_2787_ _1418_ _0404_ VGND VGND VPWR VPWR _0405_ sky130_fd_sc_hd__xnor2_1
XFILLER_0_25_192 VGND VGND VPWR VPWR sky130_fd_sc_hd__decap_8
XFILLER_0_0_281 VGND VGND VPWR VPWR sky130_fd_sc_hd__fill_2
X_1669_ _0440_ _0747_ _0723_ _0737_ VGND VGND VPWR VPWR _0753_ sky130_fd_sc_hd__o22ai_1
X_1738_ _0819_ _0821_ _0608_ VGND VGND VPWR VPWR _0822_ sky130_fd_sc_hd__o21ba_4
XFILLER_0_36_413 VGND VGND VPWR VPWR sky130_fd_sc_hd__fill_2
XTAP_TAPCELL_ROW_28_349 VGND VPWR sky130_fd_sc_hd__tapvpwrvgnd_1
XTAP_TAPCELL_ROW_11_227 VGND VPWR sky130_fd_sc_hd__tapvpwrvgnd_1
XFILLER_0_16_181 VPWR VGND VPWR VGND sky130_ef_sc_hd__decap_12
XFILLER_0_36_27 VGND VGND VPWR VPWR sky130_fd_sc_hd__fill_1
XFILLER_0_52_15 VPWR VGND VPWR VGND sky130_ef_sc_hd__decap_12
X_2710_ _0319_ VGND VGND VPWR VPWR _0321_ sky130_fd_sc_hd__inv_2
XFILLER_0_54_221 VPWR VGND VPWR VGND sky130_ef_sc_hd__decap_12
XFILLER_0_39_273 VGND VGND VPWR VPWR sky130_fd_sc_hd__decap_6
X_2641_ _0184_ _0244_ VGND VGND VPWR VPWR _0245_ sky130_fd_sc_hd__nor2_1
X_2572_ _0168_ VGND VGND VPWR VPWR _0169_ sky130_fd_sc_hd__buf_2
XFILLER_0_22_195 VGND VGND VPWR VPWR sky130_fd_sc_hd__fill_1
XFILLER_0_10_357 VGND VGND VPWR VPWR sky130_fd_sc_hd__decap_6
X_3055_ _0501_ _0671_ _0672_ _0482_ VGND VGND VPWR VPWR _0028_ sky130_fd_sc_hd__o211a_1
X_2006_ _1070_ _1089_ VGND VGND VPWR VPWR _1090_ sky130_fd_sc_hd__xor2_4
X_2839_ _0338_ _0340_ net68 VGND VGND VPWR VPWR _0459_ sky130_fd_sc_hd__mux2_4
XFILLER_0_45_243 VPWR VGND VPWR VGND sky130_ef_sc_hd__decap_12
X_2908_ _0524_ _0528_ _0523_ VGND VGND VPWR VPWR _0010_ sky130_fd_sc_hd__o21a_1
XFILLER_0_5_373 VPWR VGND VPWR VGND sky130_ef_sc_hd__decap_12
XFILLER_0_13_140 VPWR VGND VPWR VGND sky130_ef_sc_hd__decap_12
XFILLER_0_68_335 VPWR VGND VPWR VGND sky130_ef_sc_hd__decap_12
XFILLER_0_36_276 VPWR VGND VPWR VGND sky130_ef_sc_hd__decap_12
XFILLER_0_22_18 VGND VGND VPWR VPWR sky130_fd_sc_hd__decap_8
XFILLER_0_47_15 VPWR VGND VPWR VGND sky130_ef_sc_hd__decap_12
XFILLER_0_63_69 VPWR VGND VPWR VGND sky130_ef_sc_hd__decap_12
XFILLER_0_59_335 VGND VGND VPWR VPWR sky130_fd_sc_hd__fill_1
XFILLER_0_59_313 VGND VGND VPWR VPWR sky130_fd_sc_hd__fill_1
XTAP_TAPCELL_ROW_47_477 VGND VPWR sky130_fd_sc_hd__tapvpwrvgnd_1
X_2624_ _1474_ _0225_ VGND VGND VPWR VPWR _0226_ sky130_fd_sc_hd__xnor2_2
XFILLER_0_42_279 VPWR VGND VPWR VGND sky130_ef_sc_hd__decap_12
XFILLER_0_2_321 VPWR VGND VPWR VGND sky130_ef_sc_hd__decap_12
XFILLER_0_12_73 VGND VGND VPWR VPWR sky130_fd_sc_hd__fill_1
XFILLER_0_15_405 VGND VGND VPWR VPWR sky130_fd_sc_hd__decap_6
X_2486_ _0072_ _0073_ VGND VGND VPWR VPWR _0074_ sky130_fd_sc_hd__nand2b_2
X_2555_ _1188_ _1179_ _0149_ VGND VGND VPWR VPWR _0150_ sky130_fd_sc_hd__o21ba_1
XFILLER_0_2_365 VPWR VGND VPWR VGND sky130_ef_sc_hd__decap_12
XFILLER_0_10_165 VGND VGND VPWR VPWR sky130_fd_sc_hd__fill_2
XFILLER_0_37_70 VPWR VGND VPWR VGND sky130_ef_sc_hd__decap_12
X_3107_ clknet_2_2__leaf_clock _0024_ VGND VGND VPWR VPWR net37 sky130_fd_sc_hd__dfxtp_1
X_3038_ _0639_ _0654_ VGND VGND VPWR VPWR _0655_ sky130_fd_sc_hd__nand2_1
XFILLER_0_65_327 VGND VGND VPWR VPWR sky130_fd_sc_hd__decap_8
XTAP_TAPCELL_ROW_21_300 VGND VPWR sky130_fd_sc_hd__tapvpwrvgnd_1
XFILLER_0_33_257 VGND VGND VPWR VPWR sky130_fd_sc_hd__fill_2
XFILLER_0_33_213 VGND VGND VPWR VPWR sky130_fd_sc_hd__fill_1
XFILLER_0_5_181 VPWR VGND VPWR VGND sky130_ef_sc_hd__decap_12
XFILLER_0_68_165 VGND VGND VPWR VPWR sky130_fd_sc_hd__decap_3
XFILLER_0_68_132 VGND VGND VPWR VPWR sky130_fd_sc_hd__decap_8
XTAP_TAPCELL_ROW_44_458 VGND VPWR sky130_fd_sc_hd__tapvpwrvgnd_1
XFILLER_0_33_39 VGND VGND VPWR VPWR sky130_fd_sc_hd__fill_2
XFILLER_0_49_390 VGND VGND VPWR VPWR sky130_fd_sc_hd__fill_2
XFILLER_0_3_129 VPWR VGND VPWR VGND sky130_ef_sc_hd__decap_12
XFILLER_0_3_107 VGND VGND VPWR VPWR sky130_fd_sc_hd__decap_4
Xinput15 io_inScaleA[6] VGND VGND VPWR VPWR net15 sky130_fd_sc_hd__buf_8
X_2271_ _1321_ _1353_ _1354_ VGND VGND VPWR VPWR _1355_ sky130_fd_sc_hd__a21boi_2
X_2340_ _1422_ _1423_ _1106_ VGND VGND VPWR VPWR _1424_ sky130_fd_sc_hd__a21o_1
XFILLER_0_32_290 VPWR VGND VPWR VGND sky130_ef_sc_hd__decap_12
XFILLER_0_59_198 VPWR VGND VPWR VGND sky130_ef_sc_hd__decap_12
XFILLER_0_47_316 VPWR VGND VPWR VGND sky130_ef_sc_hd__decap_12
XFILLER_0_7_413 VGND VGND VPWR VPWR sky130_fd_sc_hd__fill_2
X_1986_ _1061_ _1066_ _1065_ VGND VGND VPWR VPWR _1070_ sky130_fd_sc_hd__a21o_4
XFILLER_0_61_3 VPWR VGND VPWR VGND sky130_ef_sc_hd__decap_12
X_2607_ _0180_ _1391_ _1443_ _0206_ VGND VGND VPWR VPWR _0207_ sky130_fd_sc_hd__a31o_1
XFILLER_0_55_393 VPWR VGND VPWR VGND sky130_ef_sc_hd__decap_12
XFILLER_0_30_216 VPWR VGND VPWR VGND sky130_ef_sc_hd__decap_12
XPHY_EDGE_ROW_21_Left_91 VGND VGND VPWR VPWR sky130_fd_sc_hd__decap_3
XFILLER_0_48_80 VGND VGND VPWR VPWR sky130_fd_sc_hd__decap_4
X_2469_ _0053_ _0054_ VGND VGND VPWR VPWR _0055_ sky130_fd_sc_hd__nor2_1
X_2538_ _1099_ _1460_ _0060_ VGND VGND VPWR VPWR _0131_ sky130_fd_sc_hd__or3b_1
XFILLER_0_2_184 VGND VGND VPWR VPWR sky130_fd_sc_hd__fill_1
XFILLER_0_65_113 VGND VGND VPWR VPWR sky130_fd_sc_hd__decap_4
XTAP_TAPCELL_ROW_41_439 VGND VPWR sky130_fd_sc_hd__tapvpwrvgnd_1
XTAP_TAPCELL_ROW_57_550 VGND VPWR sky130_fd_sc_hd__tapvpwrvgnd_1
XFILLER_0_44_27 VGND VGND VPWR VPWR sky130_fd_sc_hd__fill_1
XTAP_TAPCELL_ROW_6_194 VGND VPWR sky130_fd_sc_hd__tapvpwrvgnd_1
XFILLER_0_60_15 VPWR VGND VPWR VGND sky130_ef_sc_hd__decap_12
XFILLER_0_56_168 VGND VGND VPWR VPWR sky130_fd_sc_hd__decap_8
XFILLER_0_56_157 VGND VGND VPWR VPWR sky130_fd_sc_hd__decap_8
XFILLER_0_56_146 VGND VGND VPWR VPWR sky130_fd_sc_hd__decap_6
XFILLER_0_56_113 VGND VGND VPWR VPWR sky130_fd_sc_hd__fill_1
XFILLER_0_37_360 VPWR VGND VPWR VGND sky130_ef_sc_hd__decap_12
X_1840_ _0834_ _0920_ _0922_ _0923_ VGND VGND VPWR VPWR _0924_ sky130_fd_sc_hd__o211a_1
XFILLER_0_69_57 VPWR VGND VPWR VGND sky130_ef_sc_hd__decap_12
XFILLER_0_52_385 VGND VGND VPWR VPWR sky130_fd_sc_hd__decap_3
XFILLER_0_52_352 VPWR VGND VPWR VGND sky130_ef_sc_hd__decap_12
XFILLER_0_37_393 VGND VGND VPWR VPWR sky130_fd_sc_hd__decap_4
XFILLER_0_37_382 VGND VGND VPWR VPWR sky130_fd_sc_hd__fill_2
X_1771_ _0835_ _0837_ VGND VGND VPWR VPWR _0855_ sky130_fd_sc_hd__xnor2_2
X_2254_ _1330_ _1337_ VGND VGND VPWR VPWR _1338_ sky130_fd_sc_hd__nor2_1
X_2323_ _1361_ _1343_ _1349_ _1269_ VGND VGND VPWR VPWR _1407_ sky130_fd_sc_hd__a211o_1
X_2185_ _1268_ VGND VGND VPWR VPWR _1269_ sky130_fd_sc_hd__buf_2
XFILLER_0_47_113 VGND VGND VPWR VPWR sky130_fd_sc_hd__decap_8
XFILLER_0_47_102 VGND VGND VPWR VPWR sky130_fd_sc_hd__decap_8
XFILLER_0_26_6 VPWR VGND VPWR VGND sky130_ef_sc_hd__decap_12
XFILLER_0_34_93 VGND VGND VPWR VPWR sky130_fd_sc_hd__fill_1
Xclone18 _1111_ _1112_ _1077_ VGND VGND VPWR VPWR net73 sky130_fd_sc_hd__mux2_4
X_1969_ net39 _1052_ VGND VGND VPWR VPWR _1053_ sky130_fd_sc_hd__xor2_2
XFILLER_0_7_254 VGND VGND VPWR VPWR sky130_fd_sc_hd__decap_4
XFILLER_0_7_276 VGND VGND VPWR VPWR sky130_fd_sc_hd__fill_1
XFILLER_0_43_396 VPWR VGND VPWR VGND sky130_ef_sc_hd__decap_12
XTAP_TAPCELL_ROW_54_531 VGND VPWR sky130_fd_sc_hd__tapvpwrvgnd_1
XFILLER_0_14_19 VGND VGND VPWR VPWR sky130_fd_sc_hd__decap_8
XFILLER_0_30_29 VPWR VGND VPWR VGND sky130_ef_sc_hd__decap_12
XFILLER_0_19_371 VPWR VGND VPWR VGND sky130_ef_sc_hd__decap_12
XFILLER_0_19_393 VPWR VGND VPWR VGND sky130_ef_sc_hd__decap_12
XFILLER_0_55_15 VPWR VGND VPWR VGND sky130_ef_sc_hd__decap_12
XFILLER_0_39_27 VPWR VGND VPWR VGND sky130_ef_sc_hd__decap_12
XFILLER_0_57_411 VGND VGND VPWR VPWR sky130_fd_sc_hd__decap_4
XFILLER_0_69_293 VPWR VGND VPWR VGND sky130_ef_sc_hd__decap_12
XTAP_TAPCELL_ROW_60_567 VGND VPWR sky130_fd_sc_hd__tapvpwrvgnd_1
X_2941_ _0488_ _0557_ _0561_ _0514_ VGND VGND VPWR VPWR _0562_ sky130_fd_sc_hd__a22o_1
X_2872_ _0493_ VGND VGND VPWR VPWR _0006_ sky130_fd_sc_hd__clkbuf_1
XFILLER_0_29_179 VPWR VGND VPWR VGND sky130_ef_sc_hd__decap_12
XFILLER_0_29_113 VPWR VGND VPWR VGND sky130_ef_sc_hd__decap_12
XFILLER_0_25_341 VGND VGND VPWR VPWR sky130_fd_sc_hd__fill_1
X_1823_ _0894_ _0884_ _0885_ VGND VGND VPWR VPWR _0907_ sky130_fd_sc_hd__and3_1
XTAP_TAPCELL_ROW_17_266 VGND VPWR sky130_fd_sc_hd__tapvpwrvgnd_1
XFILLER_0_52_193 VGND VGND VPWR VPWR sky130_fd_sc_hd__decap_3
X_1685_ _0719_ _0733_ VGND VGND VPWR VPWR _0769_ sky130_fd_sc_hd__or2b_1
XFILLER_0_4_279 VGND VGND VPWR VPWR sky130_fd_sc_hd__decap_3
XFILLER_0_4_268 VGND VGND VPWR VPWR sky130_fd_sc_hd__fill_1
X_1754_ _0835_ _0837_ VGND VGND VPWR VPWR _0838_ sky130_fd_sc_hd__or2_1
XTAP_TAPCELL_ROW_68_623 VGND VPWR sky130_fd_sc_hd__tapvpwrvgnd_1
X_2237_ _1319_ _1320_ VGND VGND VPWR VPWR _1321_ sky130_fd_sc_hd__or2_1
X_2306_ net33 _1093_ VGND VGND VPWR VPWR _1390_ sky130_fd_sc_hd__nand2_1
XFILLER_0_29_93 VGND VGND VPWR VPWR sky130_fd_sc_hd__decap_4
X_2099_ _1175_ _1182_ VGND VGND VPWR VPWR _1183_ sky130_fd_sc_hd__and2_1
XFILLER_0_45_81 VGND VGND VPWR VPWR sky130_fd_sc_hd__fill_2
X_2168_ _1193_ _1166_ VGND VGND VPWR VPWR _1252_ sky130_fd_sc_hd__and2_1
XTAP_TAPCELL_ROW_0_145 VGND VPWR sky130_fd_sc_hd__tapvpwrvgnd_1
XFILLER_0_16_363 VGND VGND VPWR VPWR sky130_fd_sc_hd__fill_1
XPHY_EDGE_ROW_17_Right_17 VGND VGND VPWR VPWR sky130_fd_sc_hd__decap_3
XPHY_EDGE_ROW_26_Right_26 VGND VGND VPWR VPWR sky130_fd_sc_hd__decap_3
XPHY_EDGE_ROW_35_Right_35 VGND VGND VPWR VPWR sky130_fd_sc_hd__decap_3
XTAP_TAPCELL_ROW_14_247 VGND VPWR sky130_fd_sc_hd__tapvpwrvgnd_1
XFILLER_0_22_300 VGND VGND VPWR VPWR sky130_fd_sc_hd__decap_8
XTAP_TAPCELL_ROW_65_604 VGND VPWR sky130_fd_sc_hd__tapvpwrvgnd_1
XPHY_EDGE_ROW_44_Right_44 VGND VGND VPWR VPWR sky130_fd_sc_hd__decap_3
X_3071_ _0468_ _0681_ VGND VGND VPWR VPWR _0688_ sky130_fd_sc_hd__or2b_1
XPHY_EDGE_ROW_53_Right_53 VGND VGND VPWR VPWR sky130_fd_sc_hd__decap_3
X_2022_ _1105_ VGND VGND VPWR VPWR _1106_ sky130_fd_sc_hd__buf_2
XFILLER_0_9_349 VPWR VGND VPWR VGND sky130_ef_sc_hd__decap_12
XFILLER_0_15_40 VPWR VGND VPWR VGND sky130_ef_sc_hd__decap_12
XFILLER_0_15_73 VPWR VGND VPWR VGND sky130_ef_sc_hd__decap_12
XFILLER_0_57_296 VGND VGND VPWR VPWR sky130_fd_sc_hd__fill_1
X_2786_ _0181_ _1412_ VGND VGND VPWR VPWR _0404_ sky130_fd_sc_hd__nand2_1
X_2855_ _0467_ _0475_ _0312_ _0300_ VGND VGND VPWR VPWR _0476_ sky130_fd_sc_hd__a211o_4
X_2924_ _0468_ _0475_ VGND VGND VPWR VPWR _0544_ sky130_fd_sc_hd__nand2_1
X_1806_ _0777_ _0864_ _0836_ _0133_ _0877_ VGND VGND VPWR VPWR _0890_ sky130_fd_sc_hd__o221a_1
XFILLER_0_17_149 VPWR VGND VPWR VGND sky130_ef_sc_hd__decap_12
XPHY_EDGE_ROW_62_Right_62 VGND VGND VPWR VPWR sky130_fd_sc_hd__decap_3
XFILLER_0_40_141 VGND VGND VPWR VPWR sky130_fd_sc_hd__decap_3
X_1668_ net13 _0747_ _0748_ _0751_ VGND VGND VPWR VPWR _0752_ sky130_fd_sc_hd__a31o_1
X_1737_ _0820_ _0699_ VGND VGND VPWR VPWR _0821_ sky130_fd_sc_hd__nor2_1
X_1599_ net10 net13 _0375_ VGND VGND VPWR VPWR _0560_ sky130_fd_sc_hd__and3_1
XFILLER_0_48_296 VGND VGND VPWR VPWR sky130_fd_sc_hd__fill_2
XFILLER_0_48_285 VGND VGND VPWR VPWR sky130_fd_sc_hd__fill_1
XFILLER_0_48_230 VPWR VGND VPWR VGND sky130_ef_sc_hd__decap_12
XTAP_TAPCELL_ROW_11_228 VGND VPWR sky130_fd_sc_hd__tapvpwrvgnd_1
XFILLER_0_16_193 VGND VGND VPWR VPWR sky130_fd_sc_hd__decap_3
XFILLER_0_52_49 VGND VGND VPWR VPWR sky130_fd_sc_hd__fill_2
XFILLER_0_52_27 VGND VGND VPWR VPWR sky130_fd_sc_hd__fill_1
X_2640_ _0238_ _0242_ VGND VGND VPWR VPWR _0244_ sky130_fd_sc_hd__nand2_1
XFILLER_0_54_266 VGND VGND VPWR VPWR sky130_fd_sc_hd__fill_2
XFILLER_0_54_233 VPWR VGND VPWR VGND sky130_ef_sc_hd__decap_12
X_2571_ net65 VGND VGND VPWR VPWR _0168_ sky130_fd_sc_hd__buf_2
XFILLER_0_22_163 VPWR VGND VPWR VGND sky130_ef_sc_hd__decap_12
X_3054_ _0662_ _0501_ VGND VGND VPWR VPWR _0672_ sky130_fd_sc_hd__nand2_1
X_2005_ _1072_ _1071_ VGND VGND VPWR VPWR _1089_ sky130_fd_sc_hd__or2b_2
XFILLER_0_45_255 VGND VGND VPWR VPWR sky130_fd_sc_hd__fill_2
XFILLER_0_45_222 VGND VGND VPWR VPWR sky130_fd_sc_hd__fill_2
X_2907_ net53 _1487_ _0514_ _0527_ VGND VGND VPWR VPWR _0528_ sky130_fd_sc_hd__a22o_1
XFILLER_0_60_269 VGND VGND VPWR VPWR sky130_fd_sc_hd__fill_2
XFILLER_0_60_225 VPWR VGND VPWR VGND sky130_ef_sc_hd__decap_12
X_2769_ _0333_ _0382_ _0384_ VGND VGND VPWR VPWR _0385_ sky130_fd_sc_hd__a21oi_1
X_2838_ _0447_ VGND VGND VPWR VPWR _0458_ sky130_fd_sc_hd__clkbuf_4
XFILLER_0_5_385 VGND VGND VPWR VPWR sky130_fd_sc_hd__decap_6
XFILLER_0_13_152 VGND VGND VPWR VPWR sky130_fd_sc_hd__decap_3
XFILLER_0_68_347 VPWR VGND VPWR VGND sky130_ef_sc_hd__decap_12
XTAP_TAPCELL_ROW_24_320 VGND VPWR sky130_fd_sc_hd__tapvpwrvgnd_1
XFILLER_0_51_225 VGND VGND VPWR VPWR sky130_fd_sc_hd__decap_6
XFILLER_0_36_288 VGND VGND VPWR VPWR sky130_fd_sc_hd__decap_8
XFILLER_0_36_222 VGND VGND VPWR VPWR sky130_fd_sc_hd__fill_1
XFILLER_0_47_27 VPWR VGND VPWR VGND sky130_ef_sc_hd__decap_12
XFILLER_0_63_15 VPWR VGND VPWR VGND sky130_ef_sc_hd__decap_12
XFILLER_0_2_29 VGND VGND VPWR VPWR sky130_fd_sc_hd__fill_2
XFILLER_0_67_391 VGND VGND VPWR VPWR sky130_fd_sc_hd__fill_1
XTAP_TAPCELL_ROW_47_478 VGND VPWR sky130_fd_sc_hd__tapvpwrvgnd_1
X_2623_ _1473_ _0217_ _0223_ _0224_ VGND VGND VPWR VPWR _0225_ sky130_fd_sc_hd__o211a_1
XFILLER_0_42_247 VGND VGND VPWR VPWR sky130_fd_sc_hd__decap_4
XFILLER_0_42_236 VGND VGND VPWR VPWR sky130_fd_sc_hd__decap_4
X_2554_ _1056_ _1322_ VGND VGND VPWR VPWR _0149_ sky130_fd_sc_hd__nor2_1
XFILLER_0_2_333 VPWR VGND VPWR VGND sky130_ef_sc_hd__decap_12
XFILLER_0_6_138 VGND VGND VPWR VPWR sky130_fd_sc_hd__fill_2
XFILLER_0_12_85 VGND VGND VPWR VPWR sky130_fd_sc_hd__fill_2
X_2485_ _0070_ _0071_ VGND VGND VPWR VPWR _0073_ sky130_fd_sc_hd__or2_1
XFILLER_0_2_377 VPWR VGND VPWR VGND sky130_ef_sc_hd__decap_12
XFILLER_0_10_122 VGND VGND VPWR VPWR sky130_fd_sc_hd__decap_3
X_3106_ clknet_2_3__leaf_clock _0023_ VGND VGND VPWR VPWR net36 sky130_fd_sc_hd__dfxtp_1
XFILLER_0_37_82 VGND VGND VPWR VPWR sky130_fd_sc_hd__decap_6
X_3037_ _0652_ _0653_ VGND VGND VPWR VPWR _0654_ sky130_fd_sc_hd__or2_1
XFILLER_0_33_225 VPWR VGND VPWR VGND sky130_ef_sc_hd__decap_12
XFILLER_0_5_193 VGND VGND VPWR VPWR sky130_fd_sc_hd__decap_4
XTAP_TAPCELL_ROW_44_459 VGND VPWR sky130_fd_sc_hd__tapvpwrvgnd_1
XFILLER_0_64_383 VPWR VGND VPWR VGND sky130_ef_sc_hd__decap_12
Xinput16 io_inScaleA[7] VGND VGND VPWR VPWR net16 sky130_fd_sc_hd__buf_6
XFILLER_0_24_225 VGND VGND VPWR VPWR sky130_fd_sc_hd__fill_1
X_2270_ _1319_ _1320_ VGND VGND VPWR VPWR _1354_ sky130_fd_sc_hd__nand2_1
XFILLER_0_58_15 VPWR VGND VPWR VGND sky130_ef_sc_hd__decap_12
XFILLER_0_59_144 VGND VGND VPWR VPWR sky130_fd_sc_hd__decap_6
XFILLER_0_59_111 VGND VGND VPWR VPWR sky130_fd_sc_hd__fill_1
XFILLER_0_62_309 VGND VGND VPWR VPWR sky130_fd_sc_hd__decap_8
XFILLER_0_55_361 VGND VGND VPWR VPWR sky130_fd_sc_hd__decap_4
XFILLER_0_47_328 VGND VGND VPWR VPWR sky130_fd_sc_hd__decap_8
XFILLER_0_23_40 VGND VGND VPWR VPWR sky130_fd_sc_hd__decap_3
X_1985_ net45 VGND VGND VPWR VPWR _1069_ sky130_fd_sc_hd__inv_2
XFILLER_0_15_225 VGND VGND VPWR VPWR sky130_fd_sc_hd__fill_1
X_2606_ _0135_ _0093_ _0095_ VGND VGND VPWR VPWR _0206_ sky130_fd_sc_hd__and3_1
X_2537_ _0120_ _0127_ _0129_ _0123_ VGND VGND VPWR VPWR _0130_ sky130_fd_sc_hd__a22oi_1
XFILLER_0_30_228 VGND VGND VPWR VPWR sky130_fd_sc_hd__fill_2
XFILLER_0_2_141 VPWR VGND VPWR VGND sky130_ef_sc_hd__decap_12
X_2399_ _1483_ _1482_ _1293_ VGND VGND VPWR VPWR _1486_ sky130_fd_sc_hd__and3b_1
XFILLER_0_54_3 VPWR VGND VPWR VGND sky130_ef_sc_hd__decap_12
X_2468_ net32 _1237_ _1188_ VGND VGND VPWR VPWR _0054_ sky130_fd_sc_hd__mux2_1
XFILLER_0_38_317 VGND VGND VPWR VPWR sky130_fd_sc_hd__decap_8
XFILLER_0_65_169 VGND VGND VPWR VPWR sky130_fd_sc_hd__fill_2
XFILLER_0_28_29 VPWR VGND VPWR VGND sky130_ef_sc_hd__decap_12
XTAP_TAPCELL_ROW_57_551 VGND VPWR sky130_fd_sc_hd__tapvpwrvgnd_1
XTAP_TAPCELL_ROW_6_195 VGND VPWR sky130_fd_sc_hd__tapvpwrvgnd_1
XFILLER_0_60_27 VGND VGND VPWR VPWR sky130_fd_sc_hd__fill_1
XFILLER_0_37_372 VGND VGND VPWR VPWR sky130_fd_sc_hd__fill_1
X_1770_ _0144_ _0807_ _0853_ VGND VGND VPWR VPWR _0854_ sky130_fd_sc_hd__or3_1
XFILLER_0_69_69 VPWR VGND VPWR VGND sky130_ef_sc_hd__decap_12
X_2322_ _1101_ _1330_ _1337_ _1405_ VGND VGND VPWR VPWR _1406_ sky130_fd_sc_hd__o31a_1
X_2253_ _1333_ _1336_ _1106_ VGND VGND VPWR VPWR _1337_ sky130_fd_sc_hd__a21oi_1
X_2184_ _1080_ _1100_ VGND VGND VPWR VPWR _1268_ sky130_fd_sc_hd__xnor2_2
XFILLER_0_18_51 VGND VGND VPWR VPWR sky130_fd_sc_hd__decap_8
XFILLER_0_34_83 VGND VGND VPWR VPWR sky130_fd_sc_hd__fill_1
XFILLER_0_62_139 VGND VGND VPWR VPWR sky130_fd_sc_hd__fill_1
XFILLER_0_47_169 VPWR VGND VPWR VGND sky130_ef_sc_hd__decap_12
X_1899_ _0981_ _0982_ _0034_ VGND VGND VPWR VPWR _0983_ sky130_fd_sc_hd__a21oi_1
X_1968_ _1050_ _1051_ _1042_ VGND VGND VPWR VPWR _1052_ sky130_fd_sc_hd__a21o_1
XFILLER_0_7_211 VPWR VGND VPWR VGND sky130_ef_sc_hd__decap_12
Xclone1 _1076_ _1069_ VGND VGND VPWR VPWR net56 sky130_fd_sc_hd__xnor2_2
XFILLER_0_66_401 VPWR VGND VPWR VGND sky130_ef_sc_hd__decap_12
XFILLER_0_38_114 VGND VGND VPWR VPWR sky130_fd_sc_hd__decap_8
XFILLER_0_26_309 VGND VGND VPWR VPWR sky130_fd_sc_hd__decap_4
XFILLER_0_19_383 VGND VGND VPWR VPWR sky130_fd_sc_hd__decap_8
XFILLER_0_61_172 VGND VGND VPWR VPWR sky130_fd_sc_hd__decap_8
XFILLER_0_39_39 VGND VGND VPWR VPWR sky130_fd_sc_hd__fill_2
XFILLER_0_34_342 VPWR VGND VPWR VGND sky130_ef_sc_hd__decap_12
XFILLER_0_55_27 VPWR VGND VPWR VGND sky130_ef_sc_hd__decap_12
X_2940_ _0526_ _0559_ _0509_ VGND VGND VPWR VPWR _0561_ sky130_fd_sc_hd__mux2_4
XFILLER_0_29_125 VGND VGND VPWR VPWR sky130_fd_sc_hd__decap_3
XTAP_TAPCELL_ROW_17_267 VGND VPWR sky130_fd_sc_hd__tapvpwrvgnd_1
XTAP_TAPCELL_ROW_60_568 VGND VPWR sky130_fd_sc_hd__tapvpwrvgnd_1
X_2871_ _0492_ _0482_ VGND VGND VPWR VPWR _0493_ sky130_fd_sc_hd__and2_4
XFILLER_0_29_169 VGND VGND VPWR VPWR sky130_fd_sc_hd__decap_4
XFILLER_0_25_364 VGND VGND VPWR VPWR sky130_fd_sc_hd__decap_8
X_1753_ _0768_ _0836_ _0823_ _0778_ VGND VGND VPWR VPWR _0837_ sky130_fd_sc_hd__o22a_1
X_1822_ _0904_ _0905_ VGND VGND VPWR VPWR _0906_ sky130_fd_sc_hd__or2b_1
X_1684_ _0767_ VGND VGND VPWR VPWR _0768_ sky130_fd_sc_hd__buf_2
XFILLER_0_20_85 VPWR VGND VPWR VGND sky130_ef_sc_hd__decap_12
XTAP_TAPCELL_ROW_68_624 VGND VPWR sky130_fd_sc_hd__tapvpwrvgnd_1
X_2305_ _1192_ _1378_ _1386_ _1359_ _1388_ VGND VGND VPWR VPWR _1389_ sky130_fd_sc_hd__a32o_1
X_2167_ _1107_ _1206_ _1221_ _1250_ VGND VGND VPWR VPWR _1251_ sky130_fd_sc_hd__o31a_1
X_2236_ net50 _1312_ _1078_ VGND VGND VPWR VPWR _1320_ sky130_fd_sc_hd__mux2_2
XFILLER_0_61_92 VGND VGND VPWR VPWR sky130_fd_sc_hd__fill_1
XFILLER_0_61_81 VGND VGND VPWR VPWR sky130_fd_sc_hd__decap_4
X_2098_ _1109_ _1176_ _1181_ VGND VGND VPWR VPWR _1182_ sky130_fd_sc_hd__or3_1
XFILLER_0_0_73 VGND VGND VPWR VPWR sky130_fd_sc_hd__fill_1
XTAP_TAPCELL_ROW_0_146 VGND VPWR sky130_fd_sc_hd__tapvpwrvgnd_1
XFILLER_0_58_209 VPWR VGND VPWR VGND sky130_ef_sc_hd__decap_12
XTAP_TAPCELL_ROW_14_248 VGND VPWR sky130_fd_sc_hd__tapvpwrvgnd_1
XFILLER_0_66_15 VPWR VGND VPWR VGND sky130_ef_sc_hd__decap_12
XTAP_TAPCELL_ROW_65_605 VGND VPWR sky130_fd_sc_hd__tapvpwrvgnd_1
X_2021_ _1082_ _1104_ VGND VGND VPWR VPWR _1105_ sky130_fd_sc_hd__xnor2_4
X_3070_ _0501_ _0685_ _0686_ _0482_ VGND VGND VPWR VPWR _0030_ sky130_fd_sc_hd__o211a_1
XFILLER_0_9_306 VPWR VGND VPWR VGND sky130_ef_sc_hd__decap_12
XFILLER_0_15_52 VGND VGND VPWR VPWR sky130_fd_sc_hd__decap_4
XFILLER_0_15_85 VPWR VGND VPWR VGND sky130_ef_sc_hd__decap_12
X_2923_ _0441_ VGND VGND VPWR VPWR _0543_ sky130_fd_sc_hd__buf_2
X_2785_ _0366_ VGND VGND VPWR VPWR _0403_ sky130_fd_sc_hd__inv_2
X_2854_ _0341_ _0393_ _0349_ _0352_ VGND VGND VPWR VPWR _0475_ sky130_fd_sc_hd__or4_4
XFILLER_0_40_153 VGND VGND VPWR VPWR sky130_fd_sc_hd__decap_3
XFILLER_0_40_131 VGND VGND VPWR VPWR sky130_fd_sc_hd__decap_8
XFILLER_0_31_95 VGND VGND VPWR VPWR sky130_fd_sc_hd__decap_3
X_1736_ _0647_ _0320_ net13 _0667_ VGND VGND VPWR VPWR _0820_ sky130_fd_sc_hd__and4_1
X_1805_ _0852_ _0888_ VGND VGND VPWR VPWR _0889_ sky130_fd_sc_hd__or2_1
XFILLER_0_13_312 VPWR VGND VPWR VGND sky130_ef_sc_hd__decap_12
XFILLER_0_13_334 VGND VGND VPWR VPWR sky130_fd_sc_hd__fill_2
XFILLER_0_13_367 VPWR VGND VPWR VGND sky130_ef_sc_hd__decap_12
X_1667_ _0749_ _0750_ VGND VGND VPWR VPWR _0751_ sky130_fd_sc_hd__nor2_1
XFILLER_0_0_294 VPWR VGND VPWR VGND sky130_ef_sc_hd__decap_12
X_1598_ _0500_ _0540_ VGND VGND VPWR VPWR _0550_ sky130_fd_sc_hd__xor2_2
X_2219_ _1301_ _1302_ _1106_ VGND VGND VPWR VPWR _1303_ sky130_fd_sc_hd__a21oi_1
XFILLER_0_48_253 VPWR VGND VPWR VGND sky130_ef_sc_hd__decap_12
XFILLER_0_48_242 VGND VGND VPWR VPWR sky130_fd_sc_hd__decap_8
XTAP_TAPCELL_ROW_11_229 VGND VPWR sky130_fd_sc_hd__tapvpwrvgnd_1
XFILLER_0_31_197 VGND VGND VPWR VPWR sky130_fd_sc_hd__decap_8
XFILLER_0_6_3 VGND VGND VPWR VPWR sky130_fd_sc_hd__decap_4
XFILLER_0_16_172 VGND VGND VPWR VPWR sky130_fd_sc_hd__fill_2
XFILLER_0_36_29 VPWR VGND VPWR VGND sky130_ef_sc_hd__decap_12
XTAP_TAPCELL_ROW_27_340 VGND VPWR sky130_fd_sc_hd__tapvpwrvgnd_1
XFILLER_0_54_245 VGND VGND VPWR VPWR sky130_fd_sc_hd__decap_6
X_2570_ _0137_ _0154_ _0152_ _0165_ VGND VGND VPWR VPWR _0167_ sky130_fd_sc_hd__o31a_4
XFILLER_0_6_309 VPWR VGND VPWR VGND sky130_ef_sc_hd__decap_12
XFILLER_0_22_197 VPWR VGND VPWR VGND sky130_ef_sc_hd__decap_12
XFILLER_0_22_175 VPWR VGND VPWR VGND sky130_ef_sc_hd__decap_12
X_2004_ _1068_ _1087_ VGND VGND VPWR VPWR _1088_ sky130_fd_sc_hd__xor2_2
X_3053_ _0661_ _0670_ VGND VGND VPWR VPWR _0671_ sky130_fd_sc_hd__xnor2_1
X_2906_ _0486_ _0526_ _0509_ VGND VGND VPWR VPWR _0527_ sky130_fd_sc_hd__mux2_4
XFILLER_0_42_83 VGND VGND VPWR VPWR sky130_fd_sc_hd__fill_1
XFILLER_0_9_125 VGND VGND VPWR VPWR sky130_fd_sc_hd__fill_2
XFILLER_0_9_169 VPWR VGND VPWR VGND sky130_ef_sc_hd__decap_12
XFILLER_0_18_404 VGND VGND VPWR VPWR sky130_fd_sc_hd__decap_8
XFILLER_0_60_237 VGND VGND VPWR VPWR sky130_fd_sc_hd__fill_1
X_2768_ net64 _0383_ VGND VGND VPWR VPWR _0384_ sky130_fd_sc_hd__and2_1
X_2699_ _0275_ _0307_ VGND VGND VPWR VPWR _0308_ sky130_fd_sc_hd__xnor2_2
X_2837_ _0439_ _0457_ VGND VGND VPWR VPWR _0003_ sky130_fd_sc_hd__nor2_1
X_1719_ _0789_ _0795_ _0801_ VGND VGND VPWR VPWR _0803_ sky130_fd_sc_hd__or3_1
XFILLER_0_68_359 VGND VGND VPWR VPWR sky130_fd_sc_hd__decap_4
XTAP_TAPCELL_ROW_24_321 VGND VPWR sky130_fd_sc_hd__tapvpwrvgnd_1
XFILLER_0_36_212 VGND VGND VPWR VPWR sky130_fd_sc_hd__fill_1
XFILLER_0_47_39 VPWR VGND VPWR VGND sky130_ef_sc_hd__decap_12
XFILLER_0_63_27 VPWR VGND VPWR VGND sky130_ef_sc_hd__decap_12
XFILLER_0_59_337 VGND VGND VPWR VPWR sky130_fd_sc_hd__decap_4
XTAP_TAPCELL_ROW_47_479 VGND VPWR sky130_fd_sc_hd__tapvpwrvgnd_1
XFILLER_0_27_223 VGND VGND VPWR VPWR sky130_fd_sc_hd__fill_1
X_2622_ _0088_ _0099_ _0180_ VGND VGND VPWR VPWR _0224_ sky130_fd_sc_hd__a21o_1
X_2553_ _1099_ _1103_ _1426_ VGND VGND VPWR VPWR _0148_ sky130_fd_sc_hd__nor3_1
XTAP_TAPCELL_ROW_30_357 VGND VPWR sky130_fd_sc_hd__tapvpwrvgnd_1
XFILLER_0_2_389 VPWR VGND VPWR VGND sky130_ef_sc_hd__decap_12
XFILLER_0_2_345 VPWR VGND VPWR VGND sky130_ef_sc_hd__decap_12
X_2484_ _0070_ _0071_ VGND VGND VPWR VPWR _0072_ sky130_fd_sc_hd__and2_1
X_3105_ clknet_2_3__leaf_clock _0022_ VGND VGND VPWR VPWR net35 sky130_fd_sc_hd__dfxtp_1
XFILLER_0_37_94 VPWR VGND VPWR VGND sky130_ef_sc_hd__decap_12
XTAP_TAPCELL_ROW_38_413 VGND VPWR sky130_fd_sc_hd__tapvpwrvgnd_1
X_3036_ _0476_ _0651_ VGND VGND VPWR VPWR _0653_ sky130_fd_sc_hd__nor2_1
XFILLER_0_33_237 VPWR VGND VPWR VGND sky130_ef_sc_hd__decap_12
XFILLER_0_18_223 VGND VGND VPWR VPWR sky130_fd_sc_hd__fill_2
XFILLER_0_41_281 VGND VGND VPWR VPWR sky130_fd_sc_hd__fill_2
XFILLER_0_49_370 VGND VGND VPWR VPWR sky130_fd_sc_hd__decap_3
XPHY_EDGE_ROW_30_Left_100 VGND VGND VPWR VPWR sky130_fd_sc_hd__decap_3
XFILLER_0_64_395 VPWR VGND VPWR VGND sky130_ef_sc_hd__decap_12
XFILLER_0_58_27 VGND VGND VPWR VPWR sky130_fd_sc_hd__fill_1
XFILLER_0_32_281 VGND VGND VPWR VPWR sky130_fd_sc_hd__decap_4
Xinput17 io_inScaleB[6] VGND VGND VPWR VPWR net17 sky130_fd_sc_hd__clkbuf_1
XFILLER_0_59_167 VGND VGND VPWR VPWR sky130_fd_sc_hd__fill_1
X_1984_ _1061_ _1067_ VGND VGND VPWR VPWR _1068_ sky130_fd_sc_hd__xor2_4
X_2605_ _1442_ _0204_ VGND VGND VPWR VPWR _0205_ sky130_fd_sc_hd__xor2_2
X_2536_ _0128_ VGND VGND VPWR VPWR _0129_ sky130_fd_sc_hd__inv_2
X_2467_ _1099_ _0052_ VGND VGND VPWR VPWR _0053_ sky130_fd_sc_hd__nor2_1
XFILLER_0_2_153 VGND VGND VPWR VPWR sky130_fd_sc_hd__decap_4
X_2398_ _1292_ _1484_ VGND VGND VPWR VPWR _1485_ sky130_fd_sc_hd__nand2_1
XFILLER_0_47_3 VPWR VGND VPWR VGND sky130_ef_sc_hd__decap_12
XFILLER_0_3_84 VGND VGND VPWR VPWR sky130_fd_sc_hd__fill_2
X_3019_ net38 _0543_ _0482_ _0635_ VGND VGND VPWR VPWR _0025_ sky130_fd_sc_hd__o211a_1
XFILLER_0_61_310 VPWR VGND VPWR VGND sky130_ef_sc_hd__decap_12
XTAP_TAPCELL_ROW_57_552 VGND VPWR sky130_fd_sc_hd__tapvpwrvgnd_1
XFILLER_0_44_29 VGND VGND VPWR VPWR sky130_fd_sc_hd__decap_8
XFILLER_0_64_192 VGND VGND VPWR VPWR sky130_fd_sc_hd__decap_4
XTAP_TAPCELL_ROW_40_430 VGND VPWR sky130_fd_sc_hd__tapvpwrvgnd_1
XFILLER_0_69_15 VPWR VGND VPWR VGND sky130_ef_sc_hd__decap_12
X_2321_ _1175_ _1182_ _1268_ _1106_ VGND VGND VPWR VPWR _1405_ sky130_fd_sc_hd__a211o_1
XFILLER_0_20_240 VGND VGND VPWR VPWR sky130_fd_sc_hd__decap_8
XFILLER_0_20_251 VGND VGND VPWR VPWR sky130_fd_sc_hd__fill_1
X_2183_ _1107_ _1260_ _1266_ VGND VGND VPWR VPWR _1267_ sky130_fd_sc_hd__a21o_1
X_2252_ _1334_ _1335_ _1174_ VGND VGND VPWR VPWR _1336_ sky130_fd_sc_hd__a21o_1
XFILLER_0_18_74 VGND VGND VPWR VPWR sky130_fd_sc_hd__decap_3
XFILLER_0_18_85 VPWR VGND VPWR VGND sky130_ef_sc_hd__decap_12
XTAP_TAPCELL_ROW_63_588 VGND VPWR sky130_fd_sc_hd__tapvpwrvgnd_1
XFILLER_0_28_351 VGND VGND VPWR VPWR sky130_fd_sc_hd__fill_2
XFILLER_0_7_223 VGND VGND VPWR VPWR sky130_fd_sc_hd__fill_1
XFILLER_0_55_192 VPWR VGND VPWR VGND sky130_ef_sc_hd__decap_12
XFILLER_0_55_181 VGND VGND VPWR VPWR sky130_fd_sc_hd__decap_6
XFILLER_0_50_83 VGND VGND VPWR VPWR sky130_fd_sc_hd__fill_1
X_1898_ net6 net7 net2 net3 VGND VGND VPWR VPWR _0982_ sky130_fd_sc_hd__a22o_1
X_1967_ _0996_ _1014_ VGND VGND VPWR VPWR _1051_ sky130_fd_sc_hd__nand2_1
X_2519_ _1493_ _1513_ VGND VGND VPWR VPWR _0110_ sky130_fd_sc_hd__or2_1
XFILLER_0_59_81 VGND VGND VPWR VPWR sky130_fd_sc_hd__decap_8
XFILLER_0_11_295 VGND VGND VPWR VPWR sky130_fd_sc_hd__decap_4
XFILLER_0_66_413 VGND VGND VPWR VPWR sky130_fd_sc_hd__fill_2
Xclone2 _1076_ net45 VGND VGND VPWR VPWR net57 sky130_fd_sc_hd__xnor2_2
XPHY_EDGE_ROW_9_Left_79 VGND VGND VPWR VPWR sky130_fd_sc_hd__decap_3
XFILLER_0_34_365 VPWR VGND VPWR VGND sky130_ef_sc_hd__decap_12
XFILLER_0_34_354 VGND VGND VPWR VPWR sky130_fd_sc_hd__fill_2
XFILLER_0_55_39 VPWR VGND VPWR VGND sky130_ef_sc_hd__decap_12
XFILLER_0_69_251 VGND VGND VPWR VPWR sky130_fd_sc_hd__fill_1
X_2870_ net49 _1476_ _0490_ _0483_ VGND VGND VPWR VPWR _0492_ sky130_fd_sc_hd__a22o_1
XTAP_TAPCELL_ROW_17_268 VGND VPWR sky130_fd_sc_hd__tapvpwrvgnd_1
XTAP_TAPCELL_ROW_60_569 VGND VPWR sky130_fd_sc_hd__tapvpwrvgnd_1
X_1752_ _0819_ _0821_ VGND VGND VPWR VPWR _0836_ sky130_fd_sc_hd__xnor2_2
X_1821_ _0886_ _0892_ VGND VGND VPWR VPWR _0905_ sky130_fd_sc_hd__xor2_2
X_1683_ _0763_ _0766_ VGND VGND VPWR VPWR _0767_ sky130_fd_sc_hd__nand2_1
X_2304_ _1107_ _1183_ _1387_ _1102_ VGND VGND VPWR VPWR _1388_ sky130_fd_sc_hd__a211oi_2
XFILLER_0_40_357 VGND VGND VPWR VPWR sky130_fd_sc_hd__decap_6
XFILLER_0_20_97 VGND VGND VPWR VPWR sky130_fd_sc_hd__fill_1
XTAP_TAPCELL_ROW_68_625 VGND VPWR sky130_fd_sc_hd__tapvpwrvgnd_1
X_2235_ _1294_ _1296_ _1318_ _1098_ VGND VGND VPWR VPWR _1319_ sky130_fd_sc_hd__o22a_1
X_2166_ _1222_ _1233_ _1246_ _1249_ VGND VGND VPWR VPWR _1250_ sky130_fd_sc_hd__a211o_1
XFILLER_0_31_6 VPWR VGND VPWR VGND sky130_ef_sc_hd__decap_12
X_2097_ _1180_ net73 VGND VGND VPWR VPWR _1181_ sky130_fd_sc_hd__nand2b_4
XTAP_TAPCELL_ROW_0_147 VGND VPWR sky130_fd_sc_hd__tapvpwrvgnd_1
XFILLER_0_63_405 VGND VGND VPWR VPWR sky130_fd_sc_hd__decap_8
X_2999_ _0423_ net80 _0401_ _0605_ VGND VGND VPWR VPWR _0616_ sky130_fd_sc_hd__a2bb2o_4
XPHY_EDGE_ROW_3_Right_3 VGND VGND VPWR VPWR sky130_fd_sc_hd__decap_3
XFILLER_0_0_41 VPWR VGND VPWR VGND sky130_ef_sc_hd__decap_12
XFILLER_0_0_85 VPWR VGND VPWR VGND sky130_ef_sc_hd__decap_12
XFILLER_0_43_140 VPWR VGND VPWR VGND sky130_ef_sc_hd__decap_12
XFILLER_0_31_335 VGND VGND VPWR VPWR sky130_fd_sc_hd__fill_1
XFILLER_0_3_281 VPWR VGND VPWR VGND sky130_ef_sc_hd__decap_12
XTAP_TAPCELL_ROW_8_203 VGND VPWR sky130_fd_sc_hd__tapvpwrvgnd_1
XFILLER_0_9_61 VGND VGND VPWR VPWR sky130_fd_sc_hd__fill_1
XFILLER_0_22_324 VGND VGND VPWR VPWR sky130_fd_sc_hd__fill_1
XTAP_TAPCELL_ROW_14_249 VGND VPWR sky130_fd_sc_hd__tapvpwrvgnd_1
XFILLER_0_66_27 VGND VGND VPWR VPWR sky130_fd_sc_hd__fill_1
XTAP_TAPCELL_ROW_65_606 VGND VPWR sky130_fd_sc_hd__tapvpwrvgnd_1
X_2020_ _1081_ _1084_ _1077_ VGND VGND VPWR VPWR _1104_ sky130_fd_sc_hd__o21ai_4
XPHY_EDGE_ROW_59_Left_129 VGND VGND VPWR VPWR sky130_fd_sc_hd__decap_3
XFILLER_0_45_405 VGND VGND VPWR VPWR sky130_fd_sc_hd__decap_6
X_2853_ _0372_ _0428_ VGND VGND VPWR VPWR _0474_ sky130_fd_sc_hd__nand2_1
X_2922_ _0439_ _0542_ VGND VGND VPWR VPWR _0012_ sky130_fd_sc_hd__nor2_1
XFILLER_0_31_30 VPWR VGND VPWR VGND sky130_ef_sc_hd__decap_12
XFILLER_0_9_318 VPWR VGND VPWR VGND sky130_ef_sc_hd__decap_12
XFILLER_0_15_97 VGND VGND VPWR VPWR sky130_fd_sc_hd__decap_8
XPHY_EDGE_ROW_68_Left_138 VGND VGND VPWR VPWR sky130_fd_sc_hd__decap_3
X_2784_ _0302_ VGND VGND VPWR VPWR _0402_ sky130_fd_sc_hd__inv_2
XFILLER_0_31_74 VGND VGND VPWR VPWR sky130_fd_sc_hd__decap_3
XFILLER_0_25_184 VGND VGND VPWR VPWR sky130_fd_sc_hd__decap_3
X_1666_ net13 _0210_ VGND VGND VPWR VPWR _0750_ sky130_fd_sc_hd__nand2b_1
X_1735_ _0408_ _0598_ VGND VGND VPWR VPWR _0819_ sky130_fd_sc_hd__xnor2_2
XFILLER_0_13_324 VGND VGND VPWR VPWR sky130_fd_sc_hd__decap_4
XFILLER_0_13_379 VPWR VGND VPWR VGND sky130_ef_sc_hd__decap_12
X_1804_ _0887_ _0767_ _0876_ _0777_ VGND VGND VPWR VPWR _0888_ sky130_fd_sc_hd__o22a_1
XFILLER_0_56_93 VGND VGND VPWR VPWR sky130_fd_sc_hd__decap_4
X_1597_ _0511_ _0530_ VGND VGND VPWR VPWR _0540_ sky130_fd_sc_hd__xnor2_2
X_2149_ _1226_ _1232_ VGND VGND VPWR VPWR _1233_ sky130_fd_sc_hd__and2_1
X_2218_ _1216_ _1220_ _1174_ VGND VGND VPWR VPWR _1302_ sky130_fd_sc_hd__a21o_1
XFILLER_0_63_279 VGND VGND VPWR VPWR sky130_fd_sc_hd__fill_1
XFILLER_0_48_265 VPWR VGND VPWR VGND sky130_ef_sc_hd__decap_12
XFILLER_0_31_110 VGND VGND VPWR VPWR sky130_fd_sc_hd__fill_2
XFILLER_0_16_162 VGND VGND VPWR VPWR sky130_fd_sc_hd__fill_1
XFILLER_0_31_165 VGND VGND VPWR VPWR sky130_fd_sc_hd__decap_3
XFILLER_0_52_29 VPWR VGND VPWR VGND sky130_ef_sc_hd__decap_12
XTAP_TAPCELL_ROW_27_341 VGND VPWR sky130_fd_sc_hd__tapvpwrvgnd_1
XFILLER_0_62_290 VGND VGND VPWR VPWR sky130_fd_sc_hd__decap_4
XFILLER_0_22_121 VGND VGND VPWR VPWR sky130_fd_sc_hd__decap_8
XFILLER_0_22_187 VGND VGND VPWR VPWR sky130_fd_sc_hd__decap_8
X_2003_ _1078_ _1086_ VGND VGND VPWR VPWR _1087_ sky130_fd_sc_hd__nand2_1
XFILLER_0_26_41 VGND VGND VPWR VPWR sky130_fd_sc_hd__decap_6
X_3052_ _0668_ _0669_ VGND VGND VPWR VPWR _0670_ sky130_fd_sc_hd__or2b_1
XFILLER_0_60_205 VGND VGND VPWR VPWR sky130_fd_sc_hd__decap_4
X_2905_ _0506_ _0525_ _0458_ VGND VGND VPWR VPWR _0526_ sky130_fd_sc_hd__mux2_4
XFILLER_0_45_213 VGND VGND VPWR VPWR sky130_fd_sc_hd__fill_1
X_2836_ net44 _1487_ _0315_ _0456_ VGND VGND VPWR VPWR _0457_ sky130_fd_sc_hd__o2bb2a_1
X_2767_ _0381_ VGND VGND VPWR VPWR _0383_ sky130_fd_sc_hd__inv_2
X_2698_ _0169_ _0306_ VGND VGND VPWR VPWR _0307_ sky130_fd_sc_hd__nor2_1
X_1649_ _0731_ _0732_ VGND VGND VPWR VPWR _0733_ sky130_fd_sc_hd__nor2_1
XFILLER_0_6_40 VGND VGND VPWR VPWR sky130_fd_sc_hd__decap_6
X_1718_ _0789_ _0795_ _0801_ VGND VGND VPWR VPWR _0802_ sky130_fd_sc_hd__o21ai_1
XFILLER_0_13_198 VGND VGND VPWR VPWR sky130_fd_sc_hd__decap_8
XFILLER_0_67_81 VPWR VGND VPWR VGND sky130_ef_sc_hd__decap_12
XFILLER_0_8_170 VPWR VGND VPWR VGND sky130_ef_sc_hd__decap_12
XFILLER_0_63_39 VPWR VGND VPWR VGND sky130_ef_sc_hd__decap_12
XFILLER_0_59_305 VGND VGND VPWR VPWR sky130_fd_sc_hd__decap_8
XFILLER_0_67_393 VPWR VGND VPWR VGND sky130_ef_sc_hd__decap_12
XTAP_TAPCELL_ROW_30_358 VGND VPWR sky130_fd_sc_hd__tapvpwrvgnd_1
XFILLER_0_27_279 VGND VGND VPWR VPWR sky130_fd_sc_hd__fill_1
X_2621_ _0180_ _1353_ VGND VGND VPWR VPWR _0223_ sky130_fd_sc_hd__nand2_1
X_2552_ _0142_ _0146_ _0143_ VGND VGND VPWR VPWR _0147_ sky130_fd_sc_hd__o21a_1
X_2483_ net31 _1243_ _1187_ VGND VGND VPWR VPWR _0071_ sky130_fd_sc_hd__mux2_1
XFILLER_0_2_357 VGND VGND VPWR VPWR sky130_fd_sc_hd__decap_6
XTAP_TAPCELL_ROW_38_414 VGND VPWR sky130_fd_sc_hd__tapvpwrvgnd_1
X_3104_ clknet_2_3__leaf_clock _0021_ VGND VGND VPWR VPWR net34 sky130_fd_sc_hd__dfxtp_1
X_3035_ _0476_ _0651_ VGND VGND VPWR VPWR _0652_ sky130_fd_sc_hd__and2_1
X_2819_ _0437_ _0439_ VGND VGND VPWR VPWR _0001_ sky130_fd_sc_hd__nor2_1
XFILLER_0_33_249 VGND VGND VPWR VPWR sky130_fd_sc_hd__decap_8
XFILLER_0_68_146 VGND VGND VPWR VPWR sky130_fd_sc_hd__decap_6
XFILLER_0_64_341 VGND VGND VPWR VPWR sky130_fd_sc_hd__fill_2
XFILLER_0_49_393 VGND VGND VPWR VPWR sky130_fd_sc_hd__fill_2
XFILLER_0_49_382 VGND VGND VPWR VPWR sky130_fd_sc_hd__decap_8
Xinput18 io_inScaleB[7] VGND VGND VPWR VPWR net18 sky130_fd_sc_hd__buf_1
XTAP_TAPCELL_ROW_43_450 VGND VPWR sky130_fd_sc_hd__tapvpwrvgnd_1
XFILLER_0_7_405 VGND VGND VPWR VPWR sky130_fd_sc_hd__decap_8
X_2604_ _0180_ _1402_ _1441_ _0203_ VGND VGND VPWR VPWR _0204_ sky130_fd_sc_hd__a31o_1
XFILLER_0_23_86 VPWR VGND VPWR VGND sky130_ef_sc_hd__decap_12
XFILLER_0_15_205 VGND VGND VPWR VPWR sky130_fd_sc_hd__fill_1
X_1983_ _1065_ _1066_ VGND VGND VPWR VPWR _1067_ sky130_fd_sc_hd__or2b_2
X_2535_ _0058_ _0074_ VGND VGND VPWR VPWR _0128_ sky130_fd_sc_hd__and2_1
XFILLER_0_48_72 VGND VGND VPWR VPWR sky130_fd_sc_hd__fill_1
X_2466_ _1270_ _1447_ VGND VGND VPWR VPWR _0052_ sky130_fd_sc_hd__nand2_1
X_2397_ _1482_ _1483_ VGND VGND VPWR VPWR _1484_ sky130_fd_sc_hd__and2b_1
X_3018_ _0633_ _0634_ _1487_ VGND VGND VPWR VPWR _0635_ sky130_fd_sc_hd__a21o_1
XFILLER_0_61_366 VGND VGND VPWR VPWR sky130_fd_sc_hd__fill_1
XFILLER_0_61_322 VGND VGND VPWR VPWR sky130_fd_sc_hd__decap_4
XFILLER_0_69_27 VGND VGND VPWR VPWR sky130_fd_sc_hd__fill_1
XFILLER_0_60_29 VPWR VGND VPWR VGND sky130_ef_sc_hd__decap_12
XFILLER_0_52_377 VGND VGND VPWR VPWR sky130_fd_sc_hd__decap_8
XTAP_TAPCELL_ROW_40_431 VGND VPWR sky130_fd_sc_hd__tapvpwrvgnd_1
XFILLER_0_8_19 VGND VGND VPWR VPWR sky130_fd_sc_hd__fill_1
X_2320_ net59 net61 _1392_ VGND VGND VPWR VPWR _1404_ sky130_fd_sc_hd__nand3_2
X_2251_ _1207_ _1195_ _1219_ VGND VGND VPWR VPWR _1335_ sky130_fd_sc_hd__a21o_1
XFILLER_0_20_230 VGND VGND VPWR VPWR sky130_fd_sc_hd__fill_1
XFILLER_0_20_274 VPWR VGND VPWR VGND sky130_ef_sc_hd__decap_12
X_2182_ _1233_ _1222_ _1105_ _1246_ VGND VGND VPWR VPWR _1266_ sky130_fd_sc_hd__a211oi_2
XPHY_EDGE_ROW_25_Left_95 VGND VGND VPWR VPWR sky130_fd_sc_hd__decap_3
XFILLER_0_18_97 VGND VGND VPWR VPWR sky130_fd_sc_hd__decap_8
XTAP_TAPCELL_ROW_63_589 VGND VPWR sky130_fd_sc_hd__tapvpwrvgnd_1
XFILLER_0_47_149 VPWR VGND VPWR VGND sky130_ef_sc_hd__decap_12
XFILLER_0_47_127 VGND VGND VPWR VPWR sky130_fd_sc_hd__decap_4
XFILLER_0_34_85 VGND VGND VPWR VPWR sky130_fd_sc_hd__decap_8
XFILLER_0_34_41 VGND VGND VPWR VPWR sky130_fd_sc_hd__decap_6
XFILLER_0_28_363 VGND VGND VPWR VPWR sky130_fd_sc_hd__fill_1
XFILLER_0_7_202 VGND VGND VPWR VPWR sky130_fd_sc_hd__fill_2
X_1966_ _0996_ _1014_ VGND VGND VPWR VPWR _1050_ sky130_fd_sc_hd__or2_1
XFILLER_0_43_322 VGND VGND VPWR VPWR sky130_fd_sc_hd__fill_2
X_1897_ _0980_ VGND VGND VPWR VPWR _0981_ sky130_fd_sc_hd__inv_2
X_2518_ _1494_ _1512_ VGND VGND VPWR VPWR _0109_ sky130_fd_sc_hd__and2_1
X_2449_ _1098_ _1406_ VGND VGND VPWR VPWR _1540_ sky130_fd_sc_hd__or2_1
XFILLER_0_38_127 VPWR VGND VPWR VGND sky130_ef_sc_hd__decap_12
Xclone3 _1091_ VGND VGND VPWR VPWR net58 sky130_fd_sc_hd__buf_6
XFILLER_0_46_171 VPWR VGND VPWR VGND sky130_ef_sc_hd__decap_12
XFILLER_0_34_377 VPWR VGND VPWR VGND sky130_ef_sc_hd__decap_12
XFILLER_0_34_300 VGND VGND VPWR VPWR sky130_fd_sc_hd__decap_8
X_1820_ _0898_ _0903_ _0901_ VGND VGND VPWR VPWR _0904_ sky130_fd_sc_hd__o21a_1
XTAP_TAPCELL_ROW_17_269 VGND VPWR sky130_fd_sc_hd__tapvpwrvgnd_1
XFILLER_0_52_141 VPWR VGND VPWR VGND sky130_ef_sc_hd__decap_12
X_1751_ _0133_ _0770_ _0771_ VGND VGND VPWR VPWR _0835_ sky130_fd_sc_hd__or3_4
X_1682_ _0764_ _0765_ VGND VGND VPWR VPWR _0766_ sky130_fd_sc_hd__and2_1
XTAP_TAPCELL_ROW_68_626 VGND VPWR sky130_fd_sc_hd__tapvpwrvgnd_1
X_2303_ _1326_ _1329_ _1361_ VGND VGND VPWR VPWR _1387_ sky130_fd_sc_hd__a21oi_1
X_2234_ _1270_ _1304_ _1317_ VGND VGND VPWR VPWR _1318_ sky130_fd_sc_hd__o21ai_1
XFILLER_0_29_30 VPWR VGND VPWR VGND sky130_ef_sc_hd__decap_12
XTAP_TAPCELL_ROW_51_504 VGND VPWR sky130_fd_sc_hd__tapvpwrvgnd_1
X_2165_ _1248_ VGND VGND VPWR VPWR _1249_ sky130_fd_sc_hd__buf_2
XFILLER_0_45_95 VGND VGND VPWR VPWR sky130_fd_sc_hd__fill_2
XFILLER_0_45_51 VGND VGND VPWR VPWR sky130_fd_sc_hd__decap_4
X_2096_ _1056_ _1179_ _1077_ VGND VGND VPWR VPWR _1180_ sky130_fd_sc_hd__mux2_4
XFILLER_0_24_6 VPWR VGND VPWR VGND sky130_ef_sc_hd__decap_12
XTAP_TAPCELL_ROW_0_148 VGND VPWR sky130_fd_sc_hd__tapvpwrvgnd_1
XFILLER_0_43_152 VPWR VGND VPWR VGND sky130_ef_sc_hd__decap_12
X_2998_ _0498_ _0603_ VGND VGND VPWR VPWR _0615_ sky130_fd_sc_hd__nor2_1
XFILLER_0_35_108 VGND VGND VPWR VPWR sky130_fd_sc_hd__decap_4
XFILLER_0_0_53 VGND VGND VPWR VPWR sky130_fd_sc_hd__decap_3
XFILLER_0_0_97 VPWR VGND VPWR VGND sky130_ef_sc_hd__decap_12
X_1949_ _1004_ _1005_ _0970_ VGND VGND VPWR VPWR _1033_ sky130_fd_sc_hd__and3_1
XFILLER_0_31_369 VGND VGND VPWR VPWR sky130_fd_sc_hd__decap_3
XFILLER_0_31_303 VPWR VGND VPWR VGND sky130_ef_sc_hd__decap_12
XFILLER_0_3_293 VPWR VGND VPWR VGND sky130_ef_sc_hd__decap_12
XTAP_TAPCELL_ROW_8_204 VGND VPWR sky130_fd_sc_hd__tapvpwrvgnd_1
XFILLER_0_66_266 VGND VGND VPWR VPWR sky130_fd_sc_hd__decap_6
XFILLER_0_34_174 VGND VGND VPWR VPWR sky130_fd_sc_hd__fill_1
XFILLER_0_34_141 VGND VGND VPWR VPWR sky130_fd_sc_hd__decap_4
XFILLER_0_22_369 VGND VGND VPWR VPWR sky130_fd_sc_hd__decap_8
XFILLER_0_22_336 VGND VGND VPWR VPWR sky130_fd_sc_hd__decap_6
XFILLER_0_1_208 VGND VGND VPWR VPWR sky130_fd_sc_hd__fill_2
XFILLER_0_1_219 VGND VGND VPWR VPWR sky130_fd_sc_hd__decap_4
XFILLER_0_19_160 VGND VGND VPWR VPWR sky130_fd_sc_hd__fill_2
XFILLER_0_19_182 VGND VGND VPWR VPWR sky130_fd_sc_hd__decap_3
XTAP_TAPCELL_ROW_65_607 VGND VPWR sky130_fd_sc_hd__tapvpwrvgnd_1
XPHY_EDGE_ROW_13_Right_13 VGND VGND VPWR VPWR sky130_fd_sc_hd__decap_3
XFILLER_0_15_21 VPWR VGND VPWR VGND sky130_ef_sc_hd__decap_12
XFILLER_0_57_288 VGND VGND VPWR VPWR sky130_fd_sc_hd__decap_8
X_2783_ _0400_ VGND VGND VPWR VPWR _0401_ sky130_fd_sc_hd__buf_2
X_2852_ _0434_ _0472_ _0372_ VGND VGND VPWR VPWR _0473_ sky130_fd_sc_hd__mux2_4
X_2921_ _0465_ _0504_ _0539_ _0315_ _0541_ VGND VGND VPWR VPWR _0542_ sky130_fd_sc_hd__o221a_1
XFILLER_0_31_42 VPWR VGND VPWR VGND sky130_ef_sc_hd__decap_12
XPHY_EDGE_ROW_22_Right_22 VGND VGND VPWR VPWR sky130_fd_sc_hd__decap_3
X_1803_ _0647_ _0320_ VGND VGND VPWR VPWR _0887_ sky130_fd_sc_hd__or2b_1
XFILLER_0_40_177 VGND VGND VPWR VPWR sky130_fd_sc_hd__fill_1
X_1734_ _0792_ _0785_ VGND VGND VPWR VPWR _0818_ sky130_fd_sc_hd__nor2_1
X_1665_ _0199_ _0166_ VGND VGND VPWR VPWR _0749_ sky130_fd_sc_hd__nand2_1
XFILLER_0_13_303 VGND VGND VPWR VPWR sky130_fd_sc_hd__fill_2
X_1596_ _0188_ _0521_ VGND VGND VPWR VPWR _0530_ sky130_fd_sc_hd__xnor2_4
XFILLER_0_56_83 VGND VGND VPWR VPWR sky130_fd_sc_hd__fill_1
X_2217_ _1226_ _1232_ _1222_ VGND VGND VPWR VPWR _1301_ sky130_fd_sc_hd__a21o_1
XPHY_EDGE_ROW_31_Right_31 VGND VGND VPWR VPWR sky130_fd_sc_hd__decap_3
XFILLER_0_48_277 VGND VGND VPWR VPWR sky130_fd_sc_hd__decap_8
X_2148_ _1193_ _1231_ _1108_ VGND VGND VPWR VPWR _1232_ sky130_fd_sc_hd__a21o_1
X_2079_ _0969_ _1115_ _1147_ VGND VGND VPWR VPWR _1163_ sky130_fd_sc_hd__o21a_1
XPHY_EDGE_ROW_40_Right_40 VGND VGND VPWR VPWR sky130_fd_sc_hd__decap_3
XFILLER_0_8_363 VGND VGND VPWR VPWR sky130_fd_sc_hd__fill_1
XPHY_EDGE_ROW_12_Left_82 VGND VGND VPWR VPWR sky130_fd_sc_hd__decap_3
XTAP_TAPCELL_ROW_27_342 VGND VPWR sky130_fd_sc_hd__tapvpwrvgnd_1
XFILLER_0_39_288 VGND VGND VPWR VPWR sky130_fd_sc_hd__decap_8
XTAP_TAPCELL_ROW_10_220 VGND VPWR sky130_fd_sc_hd__tapvpwrvgnd_1
X_3051_ _0652_ _0666_ VGND VGND VPWR VPWR _0669_ sky130_fd_sc_hd__or2_1
X_2002_ _1080_ net55 VGND VGND VPWR VPWR _1086_ sky130_fd_sc_hd__nand2b_1
X_2904_ _0515_ _0414_ _0426_ VGND VGND VPWR VPWR _0525_ sky130_fd_sc_hd__mux2_1
X_2766_ _0330_ _0381_ VGND VGND VPWR VPWR _0382_ sky130_fd_sc_hd__or2_1
X_2835_ _0454_ _0455_ _0374_ VGND VGND VPWR VPWR _0456_ sky130_fd_sc_hd__mux2_1
XTAP_TAPCELL_ROW_33_378 VGND VPWR sky130_fd_sc_hd__tapvpwrvgnd_1
XFILLER_0_13_111 VGND VGND VPWR VPWR sky130_fd_sc_hd__fill_1
XFILLER_0_67_93 VGND VGND VPWR VPWR sky130_fd_sc_hd__decap_6
X_2697_ _0268_ _0272_ VGND VGND VPWR VPWR _0306_ sky130_fd_sc_hd__and2_1
X_1648_ _0720_ _0721_ _0730_ VGND VGND VPWR VPWR _0732_ sky130_fd_sc_hd__and3_1
XFILLER_0_6_85 VPWR VGND VPWR VGND sky130_ef_sc_hd__decap_12
X_1717_ _0796_ _0800_ VGND VGND VPWR VPWR _0801_ sky130_fd_sc_hd__xnor2_1
XFILLER_0_13_177 VGND VGND VPWR VPWR sky130_fd_sc_hd__decap_3
XFILLER_0_13_188 VGND VGND VPWR VPWR sky130_fd_sc_hd__decap_6
X_1579_ net9 net13 VGND VGND VPWR VPWR _0353_ sky130_fd_sc_hd__nand2_1
XFILLER_0_68_317 VGND VGND VPWR VPWR sky130_fd_sc_hd__fill_2
XFILLER_0_8_182 VPWR VGND VPWR VGND sky130_ef_sc_hd__decap_12
XFILLER_0_67_361 VPWR VGND VPWR VGND sky130_ef_sc_hd__decap_12
X_2620_ _0220_ VGND VGND VPWR VPWR _0222_ sky130_fd_sc_hd__inv_2
XTAP_TAPCELL_ROW_30_359 VGND VPWR sky130_fd_sc_hd__tapvpwrvgnd_1
XFILLER_0_27_225 VPWR VGND VPWR VGND sky130_ef_sc_hd__decap_12
X_2482_ _1098_ _1103_ _1358_ VGND VGND VPWR VPWR _0070_ sky130_fd_sc_hd__or3b_1
X_2551_ _1186_ _1189_ VGND VGND VPWR VPWR _0146_ sky130_fd_sc_hd__nand2_1
XTAP_TAPCELL_ROW_38_415 VGND VPWR sky130_fd_sc_hd__tapvpwrvgnd_1
X_3103_ clknet_2_0__leaf_clock _0020_ VGND VGND VPWR VPWR net32 sky130_fd_sc_hd__dfxtp_1
X_3034_ net40 _0650_ _1188_ VGND VGND VPWR VPWR _0651_ sky130_fd_sc_hd__mux2_1
XFILLER_0_53_51 VGND VGND VPWR VPWR sky130_fd_sc_hd__decap_4
XTAP_TAPCELL_ROW_46_470 VGND VPWR sky130_fd_sc_hd__tapvpwrvgnd_1
X_2749_ _0242_ _0362_ VGND VGND VPWR VPWR _0363_ sky130_fd_sc_hd__xnor2_2
XFILLER_0_41_294 VPWR VGND VPWR VGND sky130_ef_sc_hd__decap_12
X_2818_ _0438_ VGND VGND VPWR VPWR _0439_ sky130_fd_sc_hd__buf_2
XFILLER_0_1_391 VGND VGND VPWR VPWR sky130_fd_sc_hd__fill_1
XFILLER_0_56_309 VPWR VGND VPWR VGND sky130_ef_sc_hd__decap_12
Xinput19 io_resetAcc VGND VGND VPWR VPWR net19 sky130_fd_sc_hd__clkbuf_1
XFILLER_0_24_239 VGND VGND VPWR VPWR sky130_fd_sc_hd__decap_4
XFILLER_0_58_29 VPWR VGND VPWR VGND sky130_ef_sc_hd__decap_12
XFILLER_0_67_180 VGND VGND VPWR VPWR sky130_fd_sc_hd__decap_6
XFILLER_0_59_169 VPWR VGND VPWR VGND sky130_ef_sc_hd__decap_12
XTAP_TAPCELL_ROW_43_451 VGND VPWR sky130_fd_sc_hd__tapvpwrvgnd_1
XFILLER_0_23_65 VPWR VGND VPWR VGND sky130_ef_sc_hd__decap_12
XFILLER_0_23_32 VGND VGND VPWR VPWR sky130_fd_sc_hd__decap_8
X_1982_ net41 _1064_ VGND VGND VPWR VPWR _1066_ sky130_fd_sc_hd__or2_1
X_2603_ _0180_ _1403_ VGND VGND VPWR VPWR _0203_ sky130_fd_sc_hd__nor2_1
X_2534_ _0123_ _0126_ VGND VGND VPWR VPWR _0127_ sky130_fd_sc_hd__and2_1
XFILLER_0_23_98 VPWR VGND VPWR VGND sky130_ef_sc_hd__decap_12
X_2465_ _1533_ _1539_ _0048_ _0050_ _1537_ VGND VGND VPWR VPWR _0051_ sky130_fd_sc_hd__o311a_1
X_2396_ net51 _1309_ _1187_ VGND VGND VPWR VPWR _1483_ sky130_fd_sc_hd__mux2_2
XFILLER_0_38_309 VGND VGND VPWR VPWR sky130_fd_sc_hd__fill_1
X_3017_ _0623_ _0632_ VGND VGND VPWR VPWR _0634_ sky130_fd_sc_hd__nand2_1
XFILLER_0_65_117 VGND VGND VPWR VPWR sky130_fd_sc_hd__fill_1
XFILLER_0_65_106 VGND VGND VPWR VPWR sky130_fd_sc_hd__decap_3
XFILLER_0_61_334 VGND VGND VPWR VPWR sky130_fd_sc_hd__fill_2
XPHY_EDGE_ROW_69_Right_69 VGND VGND VPWR VPWR sky130_fd_sc_hd__decap_3
XFILLER_0_64_161 VPWR VGND VPWR VGND sky130_ef_sc_hd__decap_12
XFILLER_0_52_301 VGND VGND VPWR VPWR sky130_fd_sc_hd__decap_6
XTAP_TAPCELL_ROW_40_432 VGND VPWR sky130_fd_sc_hd__tapvpwrvgnd_1
XFILLER_0_12_209 VGND VGND VPWR VPWR sky130_fd_sc_hd__decap_6
X_2250_ _1207_ _1218_ _1323_ VGND VGND VPWR VPWR _1334_ sky130_fd_sc_hd__a21o_1
XPHY_EDGE_ROW_0_Left_70 VGND VGND VPWR VPWR sky130_fd_sc_hd__decap_3
XFILLER_0_20_286 VPWR VGND VPWR VGND sky130_ef_sc_hd__decap_12
X_2181_ _1263_ _1264_ VGND VGND VPWR VPWR _1265_ sky130_fd_sc_hd__nand2_1
XFILLER_0_18_65 VGND VGND VPWR VPWR sky130_fd_sc_hd__decap_3
XFILLER_0_50_41 VPWR VGND VPWR VGND sky130_ef_sc_hd__decap_12
X_1965_ _1043_ _1047_ _1048_ VGND VGND VPWR VPWR _1049_ sky130_fd_sc_hd__a21o_4
XFILLER_0_7_225 VGND VGND VPWR VPWR sky130_fd_sc_hd__decap_8
XFILLER_0_7_258 VGND VGND VPWR VPWR sky130_fd_sc_hd__fill_1
X_2517_ _0087_ _0104_ _0106_ _0107_ VGND VGND VPWR VPWR _0108_ sky130_fd_sc_hd__a31o_1
XFILLER_0_43_345 VGND VGND VPWR VPWR sky130_fd_sc_hd__decap_3
X_1896_ net6 net7 net2 net3 VGND VGND VPWR VPWR _0980_ sky130_fd_sc_hd__and4_1
X_2448_ _1537_ _1538_ VGND VGND VPWR VPWR _1539_ sky130_fd_sc_hd__nand2_1
XFILLER_0_52_3 VPWR VGND VPWR VGND sky130_ef_sc_hd__decap_12
X_2379_ _1102_ _1462_ _1463_ VGND VGND VPWR VPWR _1464_ sky130_fd_sc_hd__or3_1
XTAP_TAPCELL_ROW_3_168 VGND VPWR sky130_fd_sc_hd__tapvpwrvgnd_1
XFILLER_0_38_139 VGND VGND VPWR VPWR sky130_fd_sc_hd__fill_1
XFILLER_0_19_331 VGND VGND VPWR VPWR sky130_fd_sc_hd__fill_1
XFILLER_0_46_183 VGND VGND VPWR VPWR sky130_fd_sc_hd__fill_1
XFILLER_0_34_389 VPWR VGND VPWR VGND sky130_ef_sc_hd__decap_12
XFILLER_0_44_109 VGND VGND VPWR VPWR sky130_fd_sc_hd__decap_4
XFILLER_0_37_183 VGND VGND VPWR VPWR sky130_fd_sc_hd__decap_3
XFILLER_0_37_150 VGND VGND VPWR VPWR sky130_fd_sc_hd__fill_1
XFILLER_0_25_334 VGND VGND VPWR VPWR sky130_fd_sc_hd__fill_2
X_1750_ _0832_ _0833_ VGND VGND VPWR VPWR _0834_ sky130_fd_sc_hd__or2_4
XFILLER_0_52_197 VGND VGND VPWR VPWR sky130_fd_sc_hd__decap_6
XFILLER_0_52_153 VGND VGND VPWR VPWR sky130_fd_sc_hd__fill_1
X_1681_ net2 net3 VGND VGND VPWR VPWR _0765_ sky130_fd_sc_hd__or2_1
XFILLER_0_20_55 VGND VGND VPWR VPWR sky130_fd_sc_hd__decap_8
XFILLER_0_20_66 VPWR VGND VPWR VGND sky130_ef_sc_hd__decap_12
XTAP_TAPCELL_ROW_68_627 VGND VPWR sky130_fd_sc_hd__tapvpwrvgnd_1
X_2233_ _1307_ _1316_ _1102_ VGND VGND VPWR VPWR _1317_ sky130_fd_sc_hd__a21o_1
X_2302_ _1101_ _1379_ _1385_ VGND VGND VPWR VPWR _1386_ sky130_fd_sc_hd__or3_1
X_2164_ _1247_ VGND VGND VPWR VPWR _1248_ sky130_fd_sc_hd__buf_2
XFILLER_0_29_42 VPWR VGND VPWR VGND sky130_ef_sc_hd__decap_12
XFILLER_0_61_51 VGND VGND VPWR VPWR sky130_fd_sc_hd__decap_4
XTAP_TAPCELL_ROW_51_505 VGND VPWR sky130_fd_sc_hd__tapvpwrvgnd_1
X_2095_ _1177_ _1178_ VGND VGND VPWR VPWR _1179_ sky130_fd_sc_hd__nor2_1
XTAP_TAPCELL_ROW_0_149 VGND VPWR sky130_fd_sc_hd__tapvpwrvgnd_1
XFILLER_0_43_186 VGND VGND VPWR VPWR sky130_fd_sc_hd__fill_1
XFILLER_0_43_164 VGND VGND VPWR VPWR sky130_fd_sc_hd__decap_4
XFILLER_0_43_131 VGND VGND VPWR VPWR sky130_fd_sc_hd__fill_1
X_2997_ _0490_ _0603_ _0614_ _0523_ VGND VGND VPWR VPWR _0022_ sky130_fd_sc_hd__o211a_1
XFILLER_0_31_315 VPWR VGND VPWR VGND sky130_ef_sc_hd__decap_12
X_1948_ _1016_ _1019_ _1025_ VGND VGND VPWR VPWR _1032_ sky130_fd_sc_hd__and3_1
X_1879_ net83 _0930_ VGND VGND VPWR VPWR _0963_ sky130_fd_sc_hd__xnor2_4
XFILLER_0_16_301 VGND VGND VPWR VPWR sky130_fd_sc_hd__decap_6
XFILLER_0_16_378 VPWR VGND VPWR VGND sky130_ef_sc_hd__decap_12
XFILLER_0_3_250 VPWR VGND VPWR VGND sky130_ef_sc_hd__decap_12
XTAP_TAPCELL_ROW_8_205 VGND VPWR sky130_fd_sc_hd__tapvpwrvgnd_1
XFILLER_0_66_289 VGND VGND VPWR VPWR sky130_fd_sc_hd__decap_3
XFILLER_0_22_348 VPWR VGND VPWR VGND sky130_ef_sc_hd__decap_12
XFILLER_0_66_29 VPWR VGND VPWR VGND sky130_ef_sc_hd__decap_12
XTAP_TAPCELL_ROW_65_608 VGND VPWR sky130_fd_sc_hd__tapvpwrvgnd_1
X_2920_ net24 _1476_ VGND VGND VPWR VPWR _0541_ sky130_fd_sc_hd__nand2_1
XFILLER_0_15_33 VGND VGND VPWR VPWR sky130_fd_sc_hd__fill_2
X_2851_ _0453_ _0471_ _0446_ VGND VGND VPWR VPWR _0472_ sky130_fd_sc_hd__mux2_4
X_2782_ _0299_ _0399_ VGND VGND VPWR VPWR _0400_ sky130_fd_sc_hd__nor2_1
XFILLER_0_31_54 VGND VGND VPWR VPWR sky130_fd_sc_hd__fill_2
X_1733_ _0812_ _0815_ _0816_ VGND VGND VPWR VPWR _0817_ sky130_fd_sc_hd__nor3_1
X_1802_ _0791_ _0851_ VGND VGND VPWR VPWR _0886_ sky130_fd_sc_hd__nor2_1
XTAP_TAPCELL_ROW_13_240 VGND VPWR sky130_fd_sc_hd__tapvpwrvgnd_1
X_1595_ _0419_ _0451_ VGND VGND VPWR VPWR _0521_ sky130_fd_sc_hd__xnor2_2
XFILLER_0_0_253 VPWR VGND VPWR VGND sky130_ef_sc_hd__decap_12
X_1664_ _0210_ _0166_ VGND VGND VPWR VPWR _0748_ sky130_fd_sc_hd__or2_1
XFILLER_0_13_337 VGND VGND VPWR VPWR sky130_fd_sc_hd__fill_1
X_2216_ _1297_ _1298_ _1299_ _1248_ VGND VGND VPWR VPWR _1300_ sky130_fd_sc_hd__a211oi_1
X_2147_ net29 _1230_ net58 VGND VGND VPWR VPWR _1231_ sky130_fd_sc_hd__mux2_4
XFILLER_0_63_204 VGND VGND VPWR VPWR sky130_fd_sc_hd__decap_8
X_2078_ _0936_ _0961_ _1115_ VGND VGND VPWR VPWR _1162_ sky130_fd_sc_hd__mux2_1
XFILLER_0_16_197 VPWR VGND VPWR VGND sky130_ef_sc_hd__decap_12
XFILLER_0_39_223 VGND VGND VPWR VPWR sky130_fd_sc_hd__fill_1
XTAP_TAPCELL_ROW_10_221 VGND VPWR sky130_fd_sc_hd__tapvpwrvgnd_1
X_2001_ _1081_ _1082_ _1084_ VGND VGND VPWR VPWR _1085_ sky130_fd_sc_hd__nor3_1
X_3050_ _0652_ _0666_ VGND VGND VPWR VPWR _0668_ sky130_fd_sc_hd__and2_1
X_2903_ _0450_ _0504_ VGND VGND VPWR VPWR _0524_ sky130_fd_sc_hd__nor2_1
XFILLER_0_9_117 VGND VGND VPWR VPWR sky130_fd_sc_hd__decap_8
X_2765_ _0332_ _0380_ VGND VGND VPWR VPWR _0381_ sky130_fd_sc_hd__xnor2_1
X_2696_ _0267_ _0304_ VGND VGND VPWR VPWR _0305_ sky130_fd_sc_hd__xnor2_2
XFILLER_0_53_281 VGND VGND VPWR VPWR sky130_fd_sc_hd__decap_4
X_2834_ _0433_ _0427_ _0401_ VGND VGND VPWR VPWR _0455_ sky130_fd_sc_hd__mux2_4
XTAP_TAPCELL_ROW_33_379 VGND VPWR sky130_fd_sc_hd__tapvpwrvgnd_1
X_1716_ _0798_ _0799_ VGND VGND VPWR VPWR _0800_ sky130_fd_sc_hd__nand2_1
X_1647_ _0720_ _0721_ _0730_ VGND VGND VPWR VPWR _0731_ sky130_fd_sc_hd__a21oi_1
XFILLER_0_6_20 VGND VGND VPWR VPWR sky130_fd_sc_hd__fill_2
X_1578_ _0309_ _0331_ VGND VGND VPWR VPWR _0342_ sky130_fd_sc_hd__nor2_1
XTAP_TAPCELL_ROW_49_490 VGND VPWR sky130_fd_sc_hd__tapvpwrvgnd_1
Xrebuffer20 net76 VGND VGND VPWR VPWR net75 sky130_fd_sc_hd__dlygate4sd1_1
XFILLER_0_8_194 VGND VGND VPWR VPWR sky130_fd_sc_hd__fill_2
XFILLER_0_4_3 VPWR VGND VPWR VGND sky130_ef_sc_hd__decap_12
XFILLER_0_67_373 VPWR VGND VPWR VGND sky130_ef_sc_hd__decap_12
X_2550_ _0142_ _0143_ VGND VGND VPWR VPWR _0145_ sky130_fd_sc_hd__nand2b_2
XFILLER_0_27_237 VPWR VGND VPWR VGND sky130_ef_sc_hd__decap_12
XFILLER_0_12_45 VPWR VGND VPWR VGND sky130_ef_sc_hd__decap_12
XFILLER_0_12_67 VGND VGND VPWR VPWR sky130_fd_sc_hd__decap_6
X_2481_ _0066_ _0068_ VGND VGND VPWR VPWR _0069_ sky130_fd_sc_hd__nor2_2
XFILLER_0_50_295 VPWR VGND VPWR VGND sky130_ef_sc_hd__decap_12
XFILLER_0_50_284 VGND VGND VPWR VPWR sky130_fd_sc_hd__decap_3
XFILLER_0_50_262 VGND VGND VPWR VPWR sky130_fd_sc_hd__fill_2
XFILLER_0_10_148 VGND VGND VPWR VPWR sky130_fd_sc_hd__fill_2
XTAP_TAPCELL_ROW_38_416 VGND VPWR sky130_fd_sc_hd__tapvpwrvgnd_1
XFILLER_0_37_53 VGND VGND VPWR VPWR sky130_fd_sc_hd__decap_3
X_3102_ clknet_2_3__leaf_clock _0019_ VGND VGND VPWR VPWR net31 sky130_fd_sc_hd__dfxtp_1
X_3033_ _1058_ VGND VGND VPWR VPWR _0650_ sky130_fd_sc_hd__inv_2
XFILLER_0_58_373 VGND VGND VPWR VPWR sky130_fd_sc_hd__fill_1
XTAP_TAPCELL_ROW_46_471 VGND VPWR sky130_fd_sc_hd__tapvpwrvgnd_1
XFILLER_0_18_215 VGND VGND VPWR VPWR sky130_fd_sc_hd__fill_2
X_2748_ _0168_ _0238_ VGND VGND VPWR VPWR _0362_ sky130_fd_sc_hd__nor2_1
X_2679_ _0284_ _0285_ VGND VGND VPWR VPWR _0286_ sky130_fd_sc_hd__xor2_2
X_2817_ net19 net21 VGND VGND VPWR VPWR _0438_ sky130_fd_sc_hd__or2_1
XFILLER_0_5_197 VGND VGND VPWR VPWR sky130_fd_sc_hd__fill_1
XFILLER_0_64_321 VPWR VGND VPWR VGND sky130_ef_sc_hd__decap_12
XFILLER_0_17_281 VGND VGND VPWR VPWR sky130_fd_sc_hd__decap_8
XFILLER_0_55_365 VGND VGND VPWR VPWR sky130_fd_sc_hd__fill_1
XTAP_TAPCELL_ROW_43_452 VGND VPWR sky130_fd_sc_hd__tapvpwrvgnd_1
XFILLER_0_23_77 VGND VGND VPWR VPWR sky130_fd_sc_hd__decap_3
X_1981_ net41 _1064_ VGND VGND VPWR VPWR _1065_ sky130_fd_sc_hd__and2_1
X_2602_ _1457_ _0201_ VGND VGND VPWR VPWR _0202_ sky130_fd_sc_hd__xor2_2
X_2533_ _0124_ _0125_ _0068_ VGND VGND VPWR VPWR _0126_ sky130_fd_sc_hd__a21o_1
XFILLER_0_2_178 VGND VGND VPWR VPWR sky130_fd_sc_hd__decap_6
XFILLER_0_11_413 VGND VGND VPWR VPWR sky130_fd_sc_hd__fill_2
X_2464_ _1535_ _1536_ _0049_ VGND VGND VPWR VPWR _0050_ sky130_fd_sc_hd__o21bai_1
X_2395_ _1192_ _1479_ _1480_ _1481_ _1359_ VGND VGND VPWR VPWR _1482_ sky130_fd_sc_hd__a32o_1
XFILLER_0_3_54 VGND VGND VPWR VPWR sky130_fd_sc_hd__fill_2
XFILLER_0_64_95 VPWR VGND VPWR VGND sky130_ef_sc_hd__decap_12
Xwire55 _1085_ VGND VGND VPWR VPWR net55 sky130_fd_sc_hd__buf_1
X_3016_ _0623_ _0632_ VGND VGND VPWR VPWR _0633_ sky130_fd_sc_hd__or2_1
XFILLER_0_3_65 VPWR VGND VPWR VGND sky130_ef_sc_hd__decap_12
XFILLER_0_58_181 VGND VGND VPWR VPWR sky130_fd_sc_hd__fill_1
XFILLER_0_46_365 VGND VGND VPWR VPWR sky130_fd_sc_hd__decap_3
XFILLER_0_69_413 VGND VGND VPWR VPWR sky130_fd_sc_hd__fill_2
XFILLER_0_56_107 VGND VGND VPWR VPWR sky130_fd_sc_hd__decap_6
XFILLER_0_49_192 VPWR VGND VPWR VGND sky130_ef_sc_hd__decap_12
XTAP_TAPCELL_ROW_40_433 VGND VPWR sky130_fd_sc_hd__tapvpwrvgnd_1
XFILLER_0_69_29 VPWR VGND VPWR VGND sky130_ef_sc_hd__decap_12
XFILLER_0_64_173 VGND VGND VPWR VPWR sky130_fd_sc_hd__decap_6
X_2180_ net25 _1203_ _1187_ VGND VGND VPWR VPWR _1264_ sky130_fd_sc_hd__mux2_2
XFILLER_0_20_298 VGND VGND VPWR VPWR sky130_fd_sc_hd__decap_8
XFILLER_0_50_53 VPWR VGND VPWR VGND sky130_ef_sc_hd__decap_12
XFILLER_0_28_365 VGND VGND VPWR VPWR sky130_fd_sc_hd__decap_8
X_1964_ _1042_ _1046_ net38 VGND VGND VPWR VPWR _1048_ sky130_fd_sc_hd__o21a_1
X_1895_ _0969_ _0963_ _0978_ _0933_ VGND VGND VPWR VPWR _0979_ sky130_fd_sc_hd__a31oi_1
X_2516_ _1289_ _1290_ _1506_ _1505_ VGND VGND VPWR VPWR _0107_ sky130_fd_sc_hd__a31o_1
XFILLER_0_59_51 VGND VGND VPWR VPWR sky130_fd_sc_hd__decap_4
X_2447_ _1535_ _1536_ VGND VGND VPWR VPWR _1538_ sky130_fd_sc_hd__or2_1
X_2378_ _1278_ _1285_ _1361_ VGND VGND VPWR VPWR _1463_ sky130_fd_sc_hd__o21a_1
XFILLER_0_45_3 VPWR VGND VPWR VGND sky130_ef_sc_hd__decap_12
XTAP_TAPCELL_ROW_3_169 VGND VPWR sky130_fd_sc_hd__tapvpwrvgnd_1
XTAP_TAPCELL_ROW_54_525 VGND VPWR sky130_fd_sc_hd__tapvpwrvgnd_1
XFILLER_0_38_107 VGND VGND VPWR VPWR sky130_fd_sc_hd__fill_1
XFILLER_0_61_143 VPWR VGND VPWR VGND sky130_ef_sc_hd__decap_12
XFILLER_0_61_110 VGND VGND VPWR VPWR sky130_fd_sc_hd__fill_2
XFILLER_0_69_265 VPWR VGND VPWR VGND sky130_ef_sc_hd__decap_12
XFILLER_0_69_221 VGND VGND VPWR VPWR sky130_fd_sc_hd__decap_3
XFILLER_0_37_173 VGND VGND VPWR VPWR sky130_fd_sc_hd__fill_1
XFILLER_0_25_324 VGND VGND VPWR VPWR sky130_fd_sc_hd__decap_4
X_2301_ _1361_ _1384_ VGND VGND VPWR VPWR _1385_ sky130_fd_sc_hd__nor2_1
X_1680_ net6 net7 VGND VGND VPWR VPWR _0764_ sky130_fd_sc_hd__or2_1
XFILLER_0_0_413 VGND VGND VPWR VPWR sky130_fd_sc_hd__fill_2
XFILLER_0_20_78 VGND VGND VPWR VPWR sky130_fd_sc_hd__decap_6
XTAP_TAPCELL_ROW_68_628 VGND VPWR sky130_fd_sc_hd__tapvpwrvgnd_1
X_2232_ _1308_ _1315_ _1106_ VGND VGND VPWR VPWR _1316_ sky130_fd_sc_hd__a21o_1
X_2163_ _1082_ _1104_ VGND VGND VPWR VPWR _1247_ sky130_fd_sc_hd__xor2_2
XFILLER_0_29_54 VGND VGND VPWR VPWR sky130_fd_sc_hd__fill_2
XFILLER_0_61_85 VGND VGND VPWR VPWR sky130_fd_sc_hd__fill_1
XTAP_TAPCELL_ROW_51_506 VGND VPWR sky130_fd_sc_hd__tapvpwrvgnd_1
XTAP_TAPCELL_ROW_16_260 VGND VPWR sky130_fd_sc_hd__tapvpwrvgnd_1
XFILLER_0_17_7 VGND VGND VPWR VPWR sky130_fd_sc_hd__decap_4
X_2094_ net45 net43 net42 net41 VGND VGND VPWR VPWR _1178_ sky130_fd_sc_hd__or4_1
XFILLER_0_43_110 VGND VGND VPWR VPWR sky130_fd_sc_hd__fill_2
X_2996_ net35 _0441_ _0504_ _0561_ _0613_ VGND VGND VPWR VPWR _0614_ sky130_fd_sc_hd__o221a_1
XFILLER_0_31_327 VGND VGND VPWR VPWR sky130_fd_sc_hd__decap_8
XFILLER_0_28_195 VGND VGND VPWR VPWR sky130_fd_sc_hd__fill_1
XFILLER_0_28_173 VGND VGND VPWR VPWR sky130_fd_sc_hd__decap_3
XFILLER_0_24_390 VPWR VGND VPWR VGND sky130_ef_sc_hd__decap_12
X_1947_ _1021_ _1025_ _1027_ VGND VGND VPWR VPWR _1031_ sky130_fd_sc_hd__o21a_1
XFILLER_0_3_262 VPWR VGND VPWR VGND sky130_ef_sc_hd__decap_12
XFILLER_0_9_31 VGND VGND VPWR VPWR sky130_fd_sc_hd__decap_8
XFILLER_0_9_53 VGND VGND VPWR VPWR sky130_fd_sc_hd__decap_3
X_1878_ _0936_ _0958_ _0961_ VGND VGND VPWR VPWR _0962_ sky130_fd_sc_hd__a21boi_1
XTAP_TAPCELL_ROW_8_206 VGND VPWR sky130_fd_sc_hd__tapvpwrvgnd_1
XFILLER_0_66_235 VGND VGND VPWR VPWR sky130_fd_sc_hd__decap_3
XFILLER_0_54_408 VGND VGND VPWR VPWR sky130_fd_sc_hd__decap_3
XFILLER_0_34_154 VPWR VGND VPWR VGND sky130_ef_sc_hd__decap_12
XFILLER_0_30_382 VPWR VGND VPWR VGND sky130_ef_sc_hd__decap_12
X_2850_ _0379_ _0344_ _0429_ VGND VGND VPWR VPWR _0471_ sky130_fd_sc_hd__mux2_4
XFILLER_0_57_279 VGND VGND VPWR VPWR sky130_fd_sc_hd__fill_1
X_2781_ _0377_ _0398_ _0288_ VGND VGND VPWR VPWR _0399_ sky130_fd_sc_hd__a21oi_1
X_1732_ _0793_ _0794_ VGND VGND VPWR VPWR _0816_ sky130_fd_sc_hd__xnor2_1
X_1663_ _0210_ _0166_ VGND VGND VPWR VPWR _0747_ sky130_fd_sc_hd__nand2_1
X_1801_ _0882_ _0883_ _0874_ VGND VGND VPWR VPWR _0885_ sky130_fd_sc_hd__o21ai_1
XTAP_TAPCELL_ROW_13_241 VGND VPWR sky130_fd_sc_hd__tapvpwrvgnd_1
XFILLER_0_56_41 VPWR VGND VPWR VGND sky130_ef_sc_hd__decap_12
XPHY_EDGE_ROW_37_Left_107 VGND VGND VPWR VPWR sky130_fd_sc_hd__decap_3
X_1594_ _0353_ _0451_ VGND VGND VPWR VPWR _0511_ sky130_fd_sc_hd__nor2_1
XFILLER_0_21_393 VPWR VGND VPWR VGND sky130_ef_sc_hd__decap_12
XFILLER_0_0_287 VGND VGND VPWR VPWR sky130_fd_sc_hd__decap_3
XFILLER_0_0_265 VPWR VGND VPWR VGND sky130_ef_sc_hd__decap_12
XPHY_EDGE_ROW_7_Right_7 VGND VGND VPWR VPWR sky130_fd_sc_hd__decap_3
X_2215_ _1271_ _1239_ _1245_ VGND VGND VPWR VPWR _1299_ sky130_fd_sc_hd__and3_1
X_2146_ _1021_ _1227_ _1228_ _1126_ _1229_ VGND VGND VPWR VPWR _1230_ sky130_fd_sc_hd__a221o_1
X_2077_ _1158_ _1160_ _1147_ VGND VGND VPWR VPWR _1161_ sky130_fd_sc_hd__mux2_1
X_2979_ _0311_ _0308_ _0505_ VGND VGND VPWR VPWR _0597_ sky130_fd_sc_hd__mux2_4
XPHY_EDGE_ROW_46_Left_116 VGND VGND VPWR VPWR sky130_fd_sc_hd__decap_3
XTAP_TAPCELL_ROW_36_399 VGND VPWR sky130_fd_sc_hd__tapvpwrvgnd_1
XFILLER_0_8_321 VPWR VGND VPWR VGND sky130_ef_sc_hd__decap_12
XFILLER_0_8_365 VPWR VGND VPWR VGND sky130_ef_sc_hd__decap_12
XPHY_EDGE_ROW_55_Left_125 VGND VGND VPWR VPWR sky130_fd_sc_hd__decap_3
XFILLER_0_31_113 VGND VGND VPWR VPWR sky130_fd_sc_hd__fill_1
XFILLER_0_31_102 VGND VGND VPWR VPWR sky130_fd_sc_hd__decap_8
XFILLER_0_6_7 VGND VGND VPWR VPWR sky130_fd_sc_hd__fill_1
XPHY_EDGE_ROW_64_Left_134 VGND VGND VPWR VPWR sky130_fd_sc_hd__decap_3
XFILLER_0_39_279 VGND VGND VPWR VPWR sky130_fd_sc_hd__fill_1
XTAP_TAPCELL_ROW_10_222 VGND VPWR sky130_fd_sc_hd__tapvpwrvgnd_1
X_2000_ _1043_ _1083_ VGND VGND VPWR VPWR _1084_ sky130_fd_sc_hd__nand2_2
X_2833_ _0431_ _0453_ _0446_ VGND VGND VPWR VPWR _0454_ sky130_fd_sc_hd__mux2_4
X_2902_ _0513_ _0522_ _0523_ VGND VGND VPWR VPWR _0009_ sky130_fd_sc_hd__o21a_1
X_2695_ _0169_ _0303_ VGND VGND VPWR VPWR _0304_ sky130_fd_sc_hd__nor2_1
X_2764_ _0136_ _0330_ VGND VGND VPWR VPWR _0380_ sky130_fd_sc_hd__or2_1
X_1646_ _0728_ _0729_ VGND VGND VPWR VPWR _0730_ sky130_fd_sc_hd__or2_1
X_1715_ _0776_ _0787_ _0762_ _0778_ _0797_ VGND VGND VPWR VPWR _0799_ sky130_fd_sc_hd__o221ai_1
XFILLER_0_5_335 VGND VGND VPWR VPWR sky130_fd_sc_hd__fill_1
XFILLER_0_67_51 VGND VGND VPWR VPWR sky130_fd_sc_hd__decap_4
X_1577_ _0320_ _0199_ _0298_ VGND VGND VPWR VPWR _0331_ sky130_fd_sc_hd__a21oi_1
Xrebuffer10 net64 VGND VGND VPWR VPWR net65 sky130_fd_sc_hd__dlymetal6s2s_1
XTAP_TAPCELL_ROW_49_491 VGND VPWR sky130_fd_sc_hd__tapvpwrvgnd_1
Xrebuffer21 net77 VGND VGND VPWR VPWR net76 sky130_fd_sc_hd__dlygate4sd1_1
X_2129_ _1209_ _1210_ _1212_ _1114_ VGND VGND VPWR VPWR _1213_ sky130_fd_sc_hd__o22a_1
XFILLER_0_51_219 VGND VGND VPWR VPWR sky130_fd_sc_hd__decap_4
XFILLER_0_67_385 VGND VGND VPWR VPWR sky130_fd_sc_hd__decap_6
XFILLER_0_27_249 VPWR VGND VPWR VGND sky130_ef_sc_hd__decap_12
XFILLER_0_12_24 VGND VGND VPWR VPWR sky130_fd_sc_hd__decap_4
X_2480_ _1192_ _1388_ _0065_ VGND VGND VPWR VPWR _0068_ sky130_fd_sc_hd__a21oi_1
XFILLER_0_2_305 VGND VGND VPWR VPWR sky130_fd_sc_hd__decap_3
XFILLER_0_12_57 VGND VGND VPWR VPWR sky130_fd_sc_hd__decap_4
X_3101_ clknet_2_1__leaf_clock _0018_ VGND VGND VPWR VPWR net30 sky130_fd_sc_hd__dfxtp_1
XFILLER_0_10_138 VGND VGND VPWR VPWR sky130_fd_sc_hd__fill_2
XTAP_TAPCELL_ROW_46_472 VGND VPWR sky130_fd_sc_hd__tapvpwrvgnd_1
XTAP_TAPCELL_ROW_38_417 VGND VPWR sky130_fd_sc_hd__tapvpwrvgnd_1
X_3032_ _0644_ _0622_ _0648_ net66 _0642_ VGND VGND VPWR VPWR _0649_ sky130_fd_sc_hd__a41o_1
XFILLER_0_58_363 VGND VGND VPWR VPWR sky130_fd_sc_hd__fill_1
X_2816_ net22 _1476_ _0315_ _0436_ VGND VGND VPWR VPWR _0437_ sky130_fd_sc_hd__o2bb2a_1
XFILLER_0_18_205 VGND VGND VPWR VPWR sky130_fd_sc_hd__fill_1
X_2747_ _0357_ _0360_ VGND VGND VPWR VPWR _0361_ sky130_fd_sc_hd__nand2_1
X_2678_ _0139_ _0277_ _0169_ VGND VGND VPWR VPWR _0285_ sky130_fd_sc_hd__a21o_1
XFILLER_0_1_393 VPWR VGND VPWR VGND sky130_ef_sc_hd__decap_12
X_1629_ _0701_ _0712_ VGND VGND VPWR VPWR _0713_ sky130_fd_sc_hd__xnor2_4
XFILLER_0_68_105 VGND VGND VPWR VPWR sky130_fd_sc_hd__fill_2
XFILLER_0_64_333 VGND VGND VPWR VPWR sky130_fd_sc_hd__decap_8
XFILLER_0_49_363 VGND VGND VPWR VPWR sky130_fd_sc_hd__fill_2
XFILLER_0_32_285 VGND VGND VPWR VPWR sky130_fd_sc_hd__fill_1
XFILLER_0_59_105 VGND VGND VPWR VPWR sky130_fd_sc_hd__decap_6
XFILLER_0_67_160 VGND VGND VPWR VPWR sky130_fd_sc_hd__decap_8
XTAP_TAPCELL_ROW_43_453 VGND VPWR sky130_fd_sc_hd__tapvpwrvgnd_1
X_1980_ _1063_ _1062_ _1039_ VGND VGND VPWR VPWR _1064_ sky130_fd_sc_hd__mux2_1
X_2601_ _0198_ _0200_ _0135_ VGND VGND VPWR VPWR _0201_ sky130_fd_sc_hd__mux2_1
Xrebuffer1 _0391_ VGND VGND VPWR VPWR net91 sky130_fd_sc_hd__dlygate4sd1_1
X_2463_ _1099_ _1428_ _1529_ VGND VGND VPWR VPWR _0049_ sky130_fd_sc_hd__o21ai_1
X_2532_ _1099_ _1534_ _1536_ VGND VGND VPWR VPWR _0125_ sky130_fd_sc_hd__or3b_1
XFILLER_0_2_157 VGND VGND VPWR VPWR sky130_fd_sc_hd__fill_1
XFILLER_0_64_41 VPWR VGND VPWR VGND sky130_ef_sc_hd__decap_12
X_2394_ _1086_ _1181_ VGND VGND VPWR VPWR _1481_ sky130_fd_sc_hd__nor2_1
X_3015_ _0630_ _0631_ VGND VGND VPWR VPWR _0632_ sky130_fd_sc_hd__nor2_2
XFILLER_0_3_77 VGND VGND VPWR VPWR sky130_fd_sc_hd__fill_1
XFILLER_0_46_333 VGND VGND VPWR VPWR sky130_fd_sc_hd__decap_8
XFILLER_0_46_344 VPWR VGND VPWR VGND sky130_ef_sc_hd__decap_12
XFILLER_0_14_230 VGND VGND VPWR VPWR sky130_fd_sc_hd__fill_1
XFILLER_0_14_241 VGND VGND VPWR VPWR sky130_fd_sc_hd__decap_8
XTAP_TAPCELL_ROW_6_189 VGND VPWR sky130_fd_sc_hd__tapvpwrvgnd_1
XFILLER_0_50_98 VGND VGND VPWR VPWR sky130_fd_sc_hd__decap_3
XFILLER_0_50_65 VPWR VGND VPWR VGND sky130_ef_sc_hd__decap_12
X_1963_ net38 _1042_ _1046_ VGND VGND VPWR VPWR _1047_ sky130_fd_sc_hd__or3_4
X_1894_ _0936_ _0961_ _0977_ VGND VGND VPWR VPWR _0978_ sky130_fd_sc_hd__nand3_1
X_2515_ _1507_ _0105_ VGND VGND VPWR VPWR _0106_ sky130_fd_sc_hd__nor2_1
X_2446_ _1535_ _1536_ VGND VGND VPWR VPWR _1537_ sky130_fd_sc_hd__nand2_1
Xclkbuf_2_0__f_clock clknet_0_clock VGND VGND VPWR VPWR clknet_2_0__leaf_clock sky130_fd_sc_hd__clkbuf_16
XFILLER_0_11_200 VGND VGND VPWR VPWR sky130_fd_sc_hd__fill_1
XFILLER_0_11_299 VGND VGND VPWR VPWR sky130_fd_sc_hd__fill_1
XTAP_TAPCELL_ROW_54_526 VGND VPWR sky130_fd_sc_hd__tapvpwrvgnd_1
XFILLER_0_38_3 VPWR VGND VPWR VGND sky130_ef_sc_hd__decap_12
X_2377_ _1393_ _1461_ _1249_ VGND VGND VPWR VPWR _1462_ sky130_fd_sc_hd__o21a_1
XTAP_TAPCELL_ROW_62_581 VGND VPWR sky130_fd_sc_hd__tapvpwrvgnd_1
XFILLER_0_46_141 VGND VGND VPWR VPWR sky130_fd_sc_hd__decap_4
XFILLER_0_34_325 VGND VGND VPWR VPWR sky130_fd_sc_hd__fill_1
XTAP_TAPCELL_ROW_19_280 VGND VPWR sky130_fd_sc_hd__tapvpwrvgnd_1
XFILLER_0_61_155 VPWR VGND VPWR VGND sky130_ef_sc_hd__decap_12
XFILLER_0_42_391 VPWR VGND VPWR VGND sky130_ef_sc_hd__decap_12
XFILLER_0_6_282 VGND VGND VPWR VPWR sky130_fd_sc_hd__fill_1
XFILLER_0_6_293 VPWR VGND VPWR VGND sky130_ef_sc_hd__decap_12
XFILLER_0_69_277 VGND VGND VPWR VPWR sky130_fd_sc_hd__decap_3
XFILLER_0_29_108 VGND VGND VPWR VPWR sky130_fd_sc_hd__fill_1
XPHY_EDGE_ROW_29_Left_99 VGND VGND VPWR VPWR sky130_fd_sc_hd__decap_3
XFILLER_0_40_339 VGND VGND VPWR VPWR sky130_fd_sc_hd__decap_6
X_2300_ _1381_ _1383_ _1174_ VGND VGND VPWR VPWR _1384_ sky130_fd_sc_hd__mux2_1
X_2231_ _1311_ _1314_ _1174_ VGND VGND VPWR VPWR _1315_ sky130_fd_sc_hd__a21o_1
XTAP_TAPCELL_ROW_68_629 VGND VPWR sky130_fd_sc_hd__tapvpwrvgnd_1
X_2162_ _1173_ _1239_ _1245_ VGND VGND VPWR VPWR _1246_ sky130_fd_sc_hd__and3_1
X_2093_ net40 net39 net38 net37 VGND VGND VPWR VPWR _1177_ sky130_fd_sc_hd__or4_1
XTAP_TAPCELL_ROW_51_507 VGND VPWR sky130_fd_sc_hd__tapvpwrvgnd_1
X_2995_ _0376_ _0585_ _0612_ _0315_ VGND VGND VPWR VPWR _0613_ sky130_fd_sc_hd__a211o_1
XFILLER_0_28_141 VGND VGND VPWR VPWR sky130_fd_sc_hd__decap_6
XTAP_TAPCELL_ROW_16_261 VGND VPWR sky130_fd_sc_hd__tapvpwrvgnd_1
X_1946_ _1026_ _1029_ VGND VGND VPWR VPWR _1030_ sky130_fd_sc_hd__xor2_2
XFILLER_0_3_274 VGND VGND VPWR VPWR sky130_fd_sc_hd__decap_6
XTAP_TAPCELL_ROW_8_207 VGND VPWR sky130_fd_sc_hd__tapvpwrvgnd_1
X_1877_ _0960_ _0959_ VGND VGND VPWR VPWR _0961_ sky130_fd_sc_hd__xnor2_2
X_2429_ _1504_ _1500_ VGND VGND VPWR VPWR _1519_ sky130_fd_sc_hd__nor2_1
XFILLER_0_34_166 VGND VGND VPWR VPWR sky130_fd_sc_hd__decap_8
XFILLER_0_30_394 VPWR VGND VPWR VGND sky130_ef_sc_hd__decap_12
XFILLER_0_15_391 VGND VGND VPWR VPWR sky130_fd_sc_hd__fill_1
XFILLER_0_57_247 VPWR VGND VPWR VGND sky130_ef_sc_hd__decap_12
XFILLER_0_25_100 VGND VGND VPWR VPWR sky130_fd_sc_hd__fill_1
X_1800_ _0874_ _0882_ _0883_ VGND VGND VPWR VPWR _0884_ sky130_fd_sc_hd__or3_4
XTAP_TAPCELL_ROW_13_242 VGND VPWR sky130_fd_sc_hd__tapvpwrvgnd_1
X_2780_ _0317_ _0378_ _0396_ _0305_ _0302_ VGND VGND VPWR VPWR _0398_ sky130_fd_sc_hd__a311o_1
XFILLER_0_25_177 VGND VGND VPWR VPWR sky130_fd_sc_hd__fill_2
X_1731_ _0813_ _0814_ VGND VGND VPWR VPWR _0815_ sky130_fd_sc_hd__nor2b_1
X_1662_ _0735_ _0745_ VGND VGND VPWR VPWR _0746_ sky130_fd_sc_hd__nor2_1
XFILLER_0_13_328 VGND VGND VPWR VPWR sky130_fd_sc_hd__fill_1
XFILLER_0_56_53 VPWR VGND VPWR VGND sky130_ef_sc_hd__decap_12
X_2214_ _1109_ _1252_ _1257_ VGND VGND VPWR VPWR _1298_ sky130_fd_sc_hd__a21o_1
XFILLER_0_0_277 VGND VGND VPWR VPWR sky130_fd_sc_hd__decap_3
XFILLER_0_0_222 VGND VGND VPWR VPWR sky130_fd_sc_hd__fill_2
X_1593_ _0480_ _0491_ VGND VGND VPWR VPWR _0500_ sky130_fd_sc_hd__nor2_2
X_2145_ _1209_ _1199_ VGND VGND VPWR VPWR _1229_ sky130_fd_sc_hd__nor2_1
XFILLER_0_22_6 VPWR VGND VPWR VGND sky130_ef_sc_hd__decap_12
X_2076_ _1159_ VGND VGND VPWR VPWR _1160_ sky130_fd_sc_hd__inv_2
X_2978_ _0596_ VGND VGND VPWR VPWR _0019_ sky130_fd_sc_hd__clkbuf_1
XFILLER_0_8_333 VPWR VGND VPWR VGND sky130_ef_sc_hd__decap_12
XFILLER_0_8_377 VPWR VGND VPWR VGND sky130_ef_sc_hd__decap_12
XFILLER_0_16_133 VGND VGND VPWR VPWR sky130_fd_sc_hd__fill_1
X_1929_ _0992_ _0122_ _0967_ _0994_ VGND VGND VPWR VPWR _1013_ sky130_fd_sc_hd__o31a_1
XFILLER_0_31_169 VGND VGND VPWR VPWR sky130_fd_sc_hd__decap_6
XFILLER_0_12_361 VGND VGND VPWR VPWR sky130_fd_sc_hd__decap_3
XFILLER_0_39_225 VPWR VGND VPWR VGND sky130_ef_sc_hd__decap_12
XFILLER_0_62_294 VGND VGND VPWR VPWR sky130_fd_sc_hd__fill_1
XTAP_TAPCELL_ROW_10_223 VGND VPWR sky130_fd_sc_hd__tapvpwrvgnd_1
XFILLER_0_10_309 VPWR VGND VPWR VGND sky130_ef_sc_hd__decap_12
X_2763_ _0340_ VGND VGND VPWR VPWR _0379_ sky130_fd_sc_hd__inv_2
XFILLER_0_60_209 VGND VGND VPWR VPWR sky130_fd_sc_hd__fill_1
X_2832_ _0329_ _0337_ _0429_ VGND VGND VPWR VPWR _0453_ sky130_fd_sc_hd__mux2_4
XFILLER_0_42_88 VGND VGND VPWR VPWR sky130_fd_sc_hd__decap_8
XFILLER_0_42_44 VPWR VGND VPWR VGND sky130_ef_sc_hd__decap_12
X_2901_ _0481_ VGND VGND VPWR VPWR _0523_ sky130_fd_sc_hd__clkbuf_4
X_2694_ _0250_ _0256_ _0261_ VGND VGND VPWR VPWR _0303_ sky130_fd_sc_hd__and3_1
X_1645_ _0722_ _0727_ VGND VGND VPWR VPWR _0729_ sky130_fd_sc_hd__and2_1
X_1714_ _0144_ _0775_ _0786_ _0797_ VGND VGND VPWR VPWR _0798_ sky130_fd_sc_hd__or4_1
X_1576_ net10 VGND VGND VPWR VPWR _0320_ sky130_fd_sc_hd__buf_2
XFILLER_0_13_103 VGND VGND VPWR VPWR sky130_fd_sc_hd__fill_1
XFILLER_0_13_125 VGND VGND VPWR VPWR sky130_fd_sc_hd__fill_2
XFILLER_0_13_169 VGND VGND VPWR VPWR sky130_fd_sc_hd__decap_8
XPHY_EDGE_ROW_16_Left_86 VGND VGND VPWR VPWR sky130_fd_sc_hd__decap_3
XFILLER_0_68_309 VGND VGND VPWR VPWR sky130_fd_sc_hd__decap_8
XTAP_TAPCELL_ROW_49_492 VGND VPWR sky130_fd_sc_hd__tapvpwrvgnd_1
Xrebuffer22 net78 VGND VGND VPWR VPWR net77 sky130_fd_sc_hd__dlygate4sd1_1
XFILLER_0_36_206 VGND VGND VPWR VPWR sky130_fd_sc_hd__decap_6
X_2059_ _1114_ _1125_ _1142_ VGND VGND VPWR VPWR _1143_ sky130_fd_sc_hd__o21a_1
X_2128_ _1011_ _1211_ VGND VGND VPWR VPWR _1212_ sky130_fd_sc_hd__or2_1
XTAP_TAPCELL_ROW_24_315 VGND VPWR sky130_fd_sc_hd__tapvpwrvgnd_1
XFILLER_0_8_141 VGND VGND VPWR VPWR sky130_fd_sc_hd__decap_6
XFILLER_0_50_253 VGND VGND VPWR VPWR sky130_fd_sc_hd__fill_2
XFILLER_0_50_220 VGND VGND VPWR VPWR sky130_fd_sc_hd__decap_8
X_3100_ clknet_2_1__leaf_clock _0017_ VGND VGND VPWR VPWR net29 sky130_fd_sc_hd__dfxtp_1
XTAP_TAPCELL_ROW_38_418 VGND VPWR sky130_fd_sc_hd__tapvpwrvgnd_1
XFILLER_0_37_88 VGND VGND VPWR VPWR sky130_fd_sc_hd__fill_1
X_3031_ _0632_ VGND VGND VPWR VPWR _0648_ sky130_fd_sc_hd__inv_2
XTAP_TAPCELL_ROW_46_473 VGND VPWR sky130_fd_sc_hd__tapvpwrvgnd_1
X_2746_ _0193_ _0359_ VGND VGND VPWR VPWR _0360_ sky130_fd_sc_hd__xor2_1
X_2815_ _0376_ _0428_ _0435_ VGND VGND VPWR VPWR _0436_ sky130_fd_sc_hd__a21oi_1
XFILLER_0_5_111 VGND VGND VPWR VPWR sky130_fd_sc_hd__fill_1
XFILLER_0_14_401 VGND VGND VPWR VPWR sky130_fd_sc_hd__decap_8
XFILLER_0_68_3 VPWR VGND VPWR VGND sky130_ef_sc_hd__decap_12
X_2677_ _0145_ _0283_ VGND VGND VPWR VPWR _0284_ sky130_fd_sc_hd__xnor2_2
XFILLER_0_1_361 VPWR VGND VPWR VGND sky130_ef_sc_hd__decap_12
X_1628_ _0711_ _0703_ VGND VGND VPWR VPWR _0712_ sky130_fd_sc_hd__xor2_4
X_1559_ net1 net5 VGND VGND VPWR VPWR _0133_ sky130_fd_sc_hd__nand2_2
XFILLER_0_64_356 VGND VGND VPWR VPWR sky130_fd_sc_hd__decap_8
XFILLER_0_17_261 VPWR VGND VPWR VGND sky130_ef_sc_hd__decap_12
XFILLER_0_17_294 VPWR VGND VPWR VGND sky130_ef_sc_hd__decap_12
XFILLER_0_59_128 VGND VGND VPWR VPWR sky130_fd_sc_hd__fill_1
X_2600_ _0093_ _0094_ _0095_ _0096_ VGND VGND VPWR VPWR _0200_ sky130_fd_sc_hd__a31o_1
XFILLER_0_55_389 VGND VGND VPWR VPWR sky130_fd_sc_hd__decap_3
XFILLER_0_55_334 VGND VGND VPWR VPWR sky130_fd_sc_hd__fill_2
XTAP_TAPCELL_ROW_43_454 VGND VPWR sky130_fd_sc_hd__tapvpwrvgnd_1
X_2462_ _1540_ _0035_ _0042_ _0041_ VGND VGND VPWR VPWR _0048_ sky130_fd_sc_hd__a31oi_1
X_2531_ _1192_ _1388_ _0065_ VGND VGND VPWR VPWR _0124_ sky130_fd_sc_hd__nand3_1
X_2393_ _1107_ _1430_ _1432_ _1103_ VGND VGND VPWR VPWR _1480_ sky130_fd_sc_hd__a211o_1
XFILLER_0_64_53 VPWR VGND VPWR VGND sky130_ef_sc_hd__decap_12
X_3014_ _0446_ _0629_ VGND VGND VPWR VPWR _0631_ sky130_fd_sc_hd__and2_1
XFILLER_0_3_34 VPWR VGND VPWR VGND sky130_ef_sc_hd__decap_12
XFILLER_0_58_194 VGND VGND VPWR VPWR sky130_fd_sc_hd__fill_2
XFILLER_0_46_356 VGND VGND VPWR VPWR sky130_fd_sc_hd__decap_8
XFILLER_0_61_326 VGND VGND VPWR VPWR sky130_fd_sc_hd__fill_1
X_2729_ _0335_ _0338_ _0340_ VGND VGND VPWR VPWR _0341_ sky130_fd_sc_hd__or3_1
XFILLER_0_14_253 VPWR VGND VPWR VGND sky130_ef_sc_hd__decap_12
XTAP_TAPCELL_ROW_57_546 VGND VPWR sky130_fd_sc_hd__tapvpwrvgnd_1
XPHY_EDGE_ROW_29_Right_29 VGND VGND VPWR VPWR sky130_fd_sc_hd__decap_3
XFILLER_0_64_197 VPWR VGND VPWR VGND sky130_ef_sc_hd__decap_12
XFILLER_0_64_131 VGND VGND VPWR VPWR sky130_fd_sc_hd__decap_3
XPHY_EDGE_ROW_38_Right_38 VGND VGND VPWR VPWR sky130_fd_sc_hd__decap_3
XFILLER_0_37_389 VGND VGND VPWR VPWR sky130_fd_sc_hd__decap_3
XFILLER_0_37_356 VGND VGND VPWR VPWR sky130_fd_sc_hd__fill_1
XPHY_EDGE_ROW_47_Right_47 VGND VGND VPWR VPWR sky130_fd_sc_hd__decap_3
XFILLER_0_18_35 VGND VGND VPWR VPWR sky130_fd_sc_hd__fill_1
XPHY_EDGE_ROW_56_Right_56 VGND VGND VPWR VPWR sky130_fd_sc_hd__decap_3
X_1962_ _0995_ _1045_ VGND VGND VPWR VPWR _1046_ sky130_fd_sc_hd__xnor2_1
XFILLER_0_55_164 VGND VGND VPWR VPWR sky130_fd_sc_hd__decap_4
XFILLER_0_50_77 VGND VGND VPWR VPWR sky130_fd_sc_hd__decap_6
XFILLER_0_43_337 VGND VGND VPWR VPWR sky130_fd_sc_hd__decap_8
XFILLER_0_28_378 VGND VGND VPWR VPWR sky130_fd_sc_hd__decap_3
XFILLER_0_11_223 VGND VGND VPWR VPWR sky130_fd_sc_hd__fill_1
X_1893_ _0970_ _0974_ _0976_ VGND VGND VPWR VPWR _0977_ sky130_fd_sc_hd__a21o_1
X_2514_ _1293_ _1292_ VGND VGND VPWR VPWR _0105_ sky130_fd_sc_hd__and2_1
XPHY_EDGE_ROW_65_Right_65 VGND VGND VPWR VPWR sky130_fd_sc_hd__decap_3
X_2445_ net29 _1230_ _1187_ VGND VGND VPWR VPWR _1536_ sky130_fd_sc_hd__mux2_1
X_2376_ _1297_ _1311_ _1314_ VGND VGND VPWR VPWR _1461_ sky130_fd_sc_hd__and3_1
XFILLER_0_11_256 VGND VGND VPWR VPWR sky130_fd_sc_hd__decap_3
XFILLER_0_11_289 VGND VGND VPWR VPWR sky130_fd_sc_hd__decap_3
XTAP_TAPCELL_ROW_54_527 VGND VPWR sky130_fd_sc_hd__tapvpwrvgnd_1
XTAP_TAPCELL_ROW_19_281 VGND VPWR sky130_fd_sc_hd__tapvpwrvgnd_1
XTAP_TAPCELL_ROW_62_582 VGND VPWR sky130_fd_sc_hd__tapvpwrvgnd_1
XFILLER_0_46_197 VGND VGND VPWR VPWR sky130_fd_sc_hd__decap_4
XFILLER_0_61_167 VGND VGND VPWR VPWR sky130_fd_sc_hd__fill_1
XFILLER_0_37_120 VGND VGND VPWR VPWR sky130_fd_sc_hd__decap_6
XPHY_EDGE_ROW_4_Left_74 VGND VGND VPWR VPWR sky130_fd_sc_hd__decap_3
XFILLER_0_40_318 VGND VGND VPWR VPWR sky130_fd_sc_hd__decap_3
XFILLER_0_40_307 VGND VGND VPWR VPWR sky130_fd_sc_hd__fill_1
XFILLER_0_25_337 VGND VGND VPWR VPWR sky130_fd_sc_hd__decap_4
XFILLER_0_4_209 VPWR VGND VPWR VGND sky130_ef_sc_hd__decap_12
XFILLER_0_20_25 VGND VGND VPWR VPWR sky130_fd_sc_hd__decap_3
X_2230_ _1193_ _1313_ _1108_ VGND VGND VPWR VPWR _1314_ sky130_fd_sc_hd__a21o_1
XFILLER_0_45_55 VGND VGND VPWR VPWR sky130_fd_sc_hd__fill_1
X_2161_ _1193_ _1244_ _1219_ VGND VGND VPWR VPWR _1245_ sky130_fd_sc_hd__a21o_1
X_2092_ _1169_ _1172_ VGND VGND VPWR VPWR _1176_ sky130_fd_sc_hd__and2_4
XTAP_TAPCELL_ROW_51_508 VGND VPWR sky130_fd_sc_hd__tapvpwrvgnd_1
X_2994_ _0597_ _0611_ _0458_ VGND VGND VPWR VPWR _0612_ sky130_fd_sc_hd__mux2_2
XFILLER_0_28_153 VPWR VGND VPWR VGND sky130_ef_sc_hd__decap_12
X_1945_ _1027_ _1028_ VGND VGND VPWR VPWR _1029_ sky130_fd_sc_hd__nand2_1
XFILLER_0_0_57 VPWR VGND VPWR VGND sky130_ef_sc_hd__decap_12
XTAP_TAPCELL_ROW_16_262 VGND VPWR sky130_fd_sc_hd__tapvpwrvgnd_1
X_1876_ _0921_ _0817_ VGND VGND VPWR VPWR _0960_ sky130_fd_sc_hd__or2_1
XTAP_TAPCELL_ROW_8_208 VGND VPWR sky130_fd_sc_hd__tapvpwrvgnd_1
XFILLER_0_9_99 VGND VGND VPWR VPWR sky130_fd_sc_hd__decap_3
X_2428_ _1510_ _1517_ VGND VGND VPWR VPWR _1518_ sky130_fd_sc_hd__nand2_1
X_2359_ _1402_ _1441_ _1442_ VGND VGND VPWR VPWR _1443_ sky130_fd_sc_hd__a21o_1
XFILLER_0_50_3 VPWR VGND VPWR VGND sky130_ef_sc_hd__decap_12
XFILLER_0_66_215 VPWR VGND VPWR VGND sky130_ef_sc_hd__decap_12
XFILLER_0_66_204 VGND VGND VPWR VPWR sky130_fd_sc_hd__fill_1
XFILLER_0_19_197 VGND VGND VPWR VPWR sky130_fd_sc_hd__fill_2
XFILLER_0_30_373 VGND VGND VPWR VPWR sky130_fd_sc_hd__fill_1
XFILLER_0_65_281 VPWR VGND VPWR VGND sky130_ef_sc_hd__decap_12
XFILLER_0_57_259 VPWR VGND VPWR VGND sky130_ef_sc_hd__decap_12
XFILLER_0_53_410 VGND VGND VPWR VPWR sky130_fd_sc_hd__decap_4
XFILLER_0_25_134 VPWR VGND VPWR VGND sky130_ef_sc_hd__decap_12
XTAP_TAPCELL_ROW_13_243 VGND VPWR sky130_fd_sc_hd__tapvpwrvgnd_1
XFILLER_0_40_159 VPWR VGND VPWR VGND sky130_ef_sc_hd__decap_12
XFILLER_0_25_156 VPWR VGND VPWR VGND sky130_ef_sc_hd__decap_12
X_1661_ _0743_ _0744_ VGND VGND VPWR VPWR _0745_ sky130_fd_sc_hd__or2b_1
X_1730_ _0811_ _0809_ VGND VGND VPWR VPWR _0814_ sky130_fd_sc_hd__xor2_2
X_1592_ _0460_ _0470_ _0451_ VGND VGND VPWR VPWR _0491_ sky130_fd_sc_hd__o21a_1
XFILLER_0_56_65 VPWR VGND VPWR VGND sky130_ef_sc_hd__decap_12
X_2213_ _1173_ VGND VGND VPWR VPWR _1297_ sky130_fd_sc_hd__buf_2
X_2144_ _1116_ _1129_ _1132_ VGND VGND VPWR VPWR _1228_ sky130_fd_sc_hd__mux2_1
XTAP_TAPCELL_ROW_64_600 VGND VPWR sky130_fd_sc_hd__tapvpwrvgnd_1
XFILLER_0_48_215 VGND VGND VPWR VPWR sky130_fd_sc_hd__fill_1
X_2075_ _0975_ _0957_ _1044_ VGND VGND VPWR VPWR _1159_ sky130_fd_sc_hd__mux2_1
XFILLER_0_56_292 VGND VGND VPWR VPWR sky130_fd_sc_hd__fill_2
X_2977_ _0482_ _0595_ VGND VGND VPWR VPWR _0596_ sky130_fd_sc_hd__and2_1
XFILLER_0_8_345 VPWR VGND VPWR VGND sky130_ef_sc_hd__decap_12
XFILLER_0_8_389 VPWR VGND VPWR VGND sky130_ef_sc_hd__decap_12
X_1859_ _0898_ _0942_ VGND VGND VPWR VPWR _0943_ sky130_fd_sc_hd__nand2_1
X_1928_ _1003_ _1011_ VGND VGND VPWR VPWR _1012_ sky130_fd_sc_hd__xnor2_2
XFILLER_0_54_207 VGND VGND VPWR VPWR sky130_fd_sc_hd__decap_4
XFILLER_0_39_237 VPWR VGND VPWR VGND sky130_ef_sc_hd__decap_12
XFILLER_0_39_215 VGND VGND VPWR VPWR sky130_fd_sc_hd__decap_8
XFILLER_0_39_204 VGND VGND VPWR VPWR sky130_fd_sc_hd__fill_2
XFILLER_0_62_273 VGND VGND VPWR VPWR sky130_fd_sc_hd__fill_1
X_2900_ net52 _1487_ _0514_ _0520_ VGND VGND VPWR VPWR _0522_ sky130_fd_sc_hd__a22o_1
XFILLER_0_26_68 VGND VGND VPWR VPWR sky130_fd_sc_hd__decap_3
X_2762_ _0326_ VGND VGND VPWR VPWR _0378_ sky130_fd_sc_hd__inv_2
XFILLER_0_42_67 VPWR VGND VPWR VGND sky130_ef_sc_hd__decap_12
XFILLER_0_42_56 VGND VGND VPWR VPWR sky130_fd_sc_hd__fill_1
XFILLER_0_38_292 VPWR VGND VPWR VGND sky130_ef_sc_hd__decap_12
X_2831_ _0439_ _0452_ VGND VGND VPWR VPWR _0002_ sky130_fd_sc_hd__nor2_1
X_1713_ _0768_ _0784_ VGND VGND VPWR VPWR _0797_ sky130_fd_sc_hd__or2_1
XFILLER_0_5_337 VPWR VGND VPWR VGND sky130_ef_sc_hd__decap_12
X_2693_ _0261_ _0301_ VGND VGND VPWR VPWR _0302_ sky130_fd_sc_hd__xnor2_2
X_1644_ _0722_ _0727_ VGND VGND VPWR VPWR _0728_ sky130_fd_sc_hd__nor2_1
XFILLER_0_6_78 VGND VGND VPWR VPWR sky130_fd_sc_hd__decap_6
X_1575_ net10 _0199_ _0298_ VGND VGND VPWR VPWR _0309_ sky130_fd_sc_hd__and3_1
XFILLER_0_21_181 VGND VGND VPWR VPWR sky130_fd_sc_hd__fill_1
XTAP_TAPCELL_ROW_49_493 VGND VPWR sky130_fd_sc_hd__tapvpwrvgnd_1
Xrebuffer23 _0084_ VGND VGND VPWR VPWR net78 sky130_fd_sc_hd__dlymetal6s2s_1
Xrebuffer12 _0077_ VGND VGND VPWR VPWR net67 sky130_fd_sc_hd__buf_2
X_2127_ _0993_ _1154_ VGND VGND VPWR VPWR _1211_ sky130_fd_sc_hd__or2_1
XFILLER_0_29_281 VGND VGND VPWR VPWR sky130_fd_sc_hd__fill_1
X_2058_ _1127_ _1134_ _1137_ _1034_ _1141_ VGND VGND VPWR VPWR _1142_ sky130_fd_sc_hd__a32oi_1
XTAP_TAPCELL_ROW_24_316 VGND VPWR sky130_fd_sc_hd__tapvpwrvgnd_1
XFILLER_0_44_273 VPWR VGND VPWR VGND sky130_ef_sc_hd__decap_12
XTAP_TAPCELL_ROW_32_371 VGND VPWR sky130_fd_sc_hd__tapvpwrvgnd_1
XFILLER_0_8_197 VPWR VGND VPWR VGND sky130_ef_sc_hd__decap_12
XFILLER_0_27_207 VGND VGND VPWR VPWR sky130_fd_sc_hd__decap_4
XFILLER_0_23_413 VGND VGND VPWR VPWR sky130_fd_sc_hd__fill_2
XFILLER_0_50_276 VGND VGND VPWR VPWR sky130_fd_sc_hd__decap_8
XTAP_TAPCELL_ROW_38_419 VGND VPWR sky130_fd_sc_hd__tapvpwrvgnd_1
X_3030_ _0501_ _0645_ _0646_ _0523_ VGND VGND VPWR VPWR _0026_ sky130_fd_sc_hd__o211a_1
XFILLER_0_58_365 VGND VGND VPWR VPWR sky130_fd_sc_hd__decap_8
XFILLER_0_58_343 VGND VGND VPWR VPWR sky130_fd_sc_hd__fill_2
XFILLER_0_53_55 VGND VGND VPWR VPWR sky130_fd_sc_hd__fill_1
XTAP_TAPCELL_ROW_46_474 VGND VPWR sky130_fd_sc_hd__tapvpwrvgnd_1
X_2745_ _0168_ _0358_ VGND VGND VPWR VPWR _0359_ sky130_fd_sc_hd__or2b_1
X_2676_ _0137_ _0280_ _0282_ _0146_ VGND VGND VPWR VPWR _0283_ sky130_fd_sc_hd__a22o_1
X_2814_ _0374_ net84 VGND VGND VPWR VPWR _0435_ sky130_fd_sc_hd__nor2_1
XFILLER_0_41_276 VGND VGND VPWR VPWR sky130_fd_sc_hd__decap_4
XFILLER_0_26_251 VGND VGND VPWR VPWR sky130_fd_sc_hd__fill_1
XFILLER_0_5_167 VGND VGND VPWR VPWR sky130_fd_sc_hd__fill_1
XFILLER_0_5_101 VGND VGND VPWR VPWR sky130_fd_sc_hd__fill_1
X_1558_ _0100_ _0111_ VGND VGND VPWR VPWR _0122_ sky130_fd_sc_hd__and2_2
XFILLER_0_1_373 VPWR VGND VPWR VGND sky130_ef_sc_hd__decap_12
X_1627_ _0704_ _0710_ VGND VGND VPWR VPWR _0711_ sky130_fd_sc_hd__xnor2_2
XFILLER_0_17_273 VGND VGND VPWR VPWR sky130_fd_sc_hd__decap_6
XFILLER_0_2_3 VPWR VGND VPWR VGND sky130_ef_sc_hd__decap_12
X_2530_ _0055_ _0121_ _0057_ VGND VGND VPWR VPWR _0123_ sky130_fd_sc_hd__o21a_1
XFILLER_0_23_243 VGND VGND VPWR VPWR sky130_fd_sc_hd__decap_6
XFILLER_0_23_221 VGND VGND VPWR VPWR sky130_fd_sc_hd__decap_3
XFILLER_0_2_137 VGND VGND VPWR VPWR sky130_fd_sc_hd__decap_3
XFILLER_0_2_104 VGND VGND VPWR VPWR sky130_fd_sc_hd__fill_1
XFILLER_0_11_405 VGND VGND VPWR VPWR sky130_fd_sc_hd__decap_8
X_2461_ _1265_ _1527_ _1533_ _1539_ _0046_ VGND VGND VPWR VPWR _0047_ sky130_fd_sc_hd__a2111o_1
X_2392_ _1421_ _1424_ _1270_ VGND VGND VPWR VPWR _1479_ sky130_fd_sc_hd__a21o_1
XFILLER_0_23_298 VGND VGND VPWR VPWR sky130_fd_sc_hd__fill_2
XFILLER_0_64_65 VPWR VGND VPWR VGND sky130_ef_sc_hd__decap_12
X_3013_ _0446_ _0629_ VGND VGND VPWR VPWR _0630_ sky130_fd_sc_hd__nor2_1
XFILLER_0_3_46 VGND VGND VPWR VPWR sky130_fd_sc_hd__decap_8
X_2728_ _0215_ _0339_ VGND VGND VPWR VPWR _0340_ sky130_fd_sc_hd__xnor2_2
X_2659_ _0258_ _0263_ _0079_ VGND VGND VPWR VPWR _0264_ sky130_fd_sc_hd__a21oi_1
XFILLER_0_14_265 VPWR VGND VPWR VGND sky130_ef_sc_hd__decap_12
XFILLER_0_69_405 VGND VGND VPWR VPWR sky130_fd_sc_hd__decap_8
XTAP_TAPCELL_ROW_57_547 VGND VPWR sky130_fd_sc_hd__tapvpwrvgnd_1
XFILLER_0_49_162 VGND VGND VPWR VPWR sky130_fd_sc_hd__decap_6
XFILLER_0_37_335 VGND VGND VPWR VPWR sky130_fd_sc_hd__fill_1
XFILLER_0_20_213 VGND VGND VPWR VPWR sky130_fd_sc_hd__fill_1
XFILLER_0_55_143 VGND VGND VPWR VPWR sky130_fd_sc_hd__decap_8
XFILLER_0_43_305 VGND VGND VPWR VPWR sky130_fd_sc_hd__fill_1
X_1892_ _0957_ _0975_ VGND VGND VPWR VPWR _0976_ sky130_fd_sc_hd__nand2_1
X_1961_ _0122_ _1044_ VGND VGND VPWR VPWR _1045_ sky130_fd_sc_hd__nand2_1
X_2513_ _0088_ _1474_ _0099_ _0101_ _0103_ VGND VGND VPWR VPWR _0104_ sky130_fd_sc_hd__a311o_1
XFILLER_0_50_89 VGND VGND VPWR VPWR sky130_fd_sc_hd__fill_2
XFILLER_0_3_413 VGND VGND VPWR VPWR sky130_fd_sc_hd__fill_2
X_2444_ _1098_ _1534_ VGND VGND VPWR VPWR _1535_ sky130_fd_sc_hd__or2_1
X_2375_ _1270_ _1261_ VGND VGND VPWR VPWR _1460_ sky130_fd_sc_hd__nand2_1
XFILLER_0_11_279 VGND VGND VPWR VPWR sky130_fd_sc_hd__fill_1
XTAP_TAPCELL_ROW_54_528 VGND VPWR sky130_fd_sc_hd__tapvpwrvgnd_1
XPHY_EDGE_ROW_20_Left_90 VGND VGND VPWR VPWR sky130_fd_sc_hd__decap_3
XTAP_TAPCELL_ROW_19_282 VGND VPWR sky130_fd_sc_hd__tapvpwrvgnd_1
XTAP_TAPCELL_ROW_62_583 VGND VPWR sky130_fd_sc_hd__tapvpwrvgnd_1
XFILLER_0_61_113 VPWR VGND VPWR VGND sky130_ef_sc_hd__decap_12
XFILLER_0_6_251 VGND VGND VPWR VPWR sky130_fd_sc_hd__fill_1
XTAP_TAPCELL_ROW_2_161 VGND VPWR sky130_fd_sc_hd__tapvpwrvgnd_1
XFILLER_0_37_165 VGND VGND VPWR VPWR sky130_fd_sc_hd__decap_3
XFILLER_0_37_132 VPWR VGND VPWR VGND sky130_ef_sc_hd__decap_12
XFILLER_0_25_305 VGND VGND VPWR VPWR sky130_fd_sc_hd__decap_4
XFILLER_0_60_190 VGND VGND VPWR VPWR sky130_fd_sc_hd__fill_1
XFILLER_0_33_393 VGND VGND VPWR VPWR sky130_fd_sc_hd__decap_3
XFILLER_0_0_405 VGND VGND VPWR VPWR sky130_fd_sc_hd__decap_8
XFILLER_0_20_37 VGND VGND VPWR VPWR sky130_fd_sc_hd__fill_2
X_2160_ net31 _1243_ net58 VGND VGND VPWR VPWR _1244_ sky130_fd_sc_hd__mux2_4
XFILLER_0_29_57 VPWR VGND VPWR VGND sky130_ef_sc_hd__decap_12
XTAP_TAPCELL_ROW_51_509 VGND VPWR sky130_fd_sc_hd__tapvpwrvgnd_1
X_2091_ _1109_ _1145_ _1167_ _1174_ VGND VGND VPWR VPWR _1175_ sky130_fd_sc_hd__a211o_1
Xmax_cap1 _1076_ VGND VGND VPWR VPWR net90 sky130_fd_sc_hd__buf_6
XFILLER_0_61_99 VGND VGND VPWR VPWR sky130_fd_sc_hd__decap_4
XFILLER_0_61_55 VGND VGND VPWR VPWR sky130_fd_sc_hd__fill_1
X_2993_ _0279_ _0286_ net82 VGND VGND VPWR VPWR _0611_ sky130_fd_sc_hd__mux2_1
XFILLER_0_43_113 VPWR VGND VPWR VGND sky130_ef_sc_hd__decap_12
XFILLER_0_28_165 VGND VGND VPWR VPWR sky130_fd_sc_hd__decap_8
XFILLER_0_28_132 VGND VGND VPWR VPWR sky130_fd_sc_hd__decap_8
XFILLER_0_0_69 VGND VGND VPWR VPWR sky130_fd_sc_hd__decap_4
X_1875_ _0833_ _0920_ _0923_ VGND VGND VPWR VPWR _0959_ sky130_fd_sc_hd__o21a_1
XFILLER_0_9_45 VGND VGND VPWR VPWR sky130_fd_sc_hd__decap_8
XFILLER_0_9_67 VPWR VGND VPWR VGND sky130_ef_sc_hd__decap_12
XTAP_TAPCELL_ROW_16_263 VGND VPWR sky130_fd_sc_hd__tapvpwrvgnd_1
X_1944_ _0992_ _0122_ _0967_ _0994_ _1012_ VGND VGND VPWR VPWR _1028_ sky130_fd_sc_hd__o311ai_4
X_2427_ _1511_ VGND VGND VPWR VPWR _1517_ sky130_fd_sc_hd__inv_2
XTAP_TAPCELL_ROW_8_209 VGND VPWR sky130_fd_sc_hd__tapvpwrvgnd_1
XTAP_TAPCELL_ROW_67_620 VGND VPWR sky130_fd_sc_hd__tapvpwrvgnd_1
X_2358_ _1389_ _1390_ VGND VGND VPWR VPWR _1442_ sky130_fd_sc_hd__xnor2_2
X_2289_ _1371_ _1372_ _1191_ VGND VGND VPWR VPWR _1373_ sky130_fd_sc_hd__o21a_1
XFILLER_0_43_3 VPWR VGND VPWR VGND sky130_ef_sc_hd__decap_12
XFILLER_0_66_249 VGND VGND VPWR VPWR sky130_fd_sc_hd__decap_3
XFILLER_0_34_135 VGND VGND VPWR VPWR sky130_fd_sc_hd__fill_1
XFILLER_0_15_393 VPWR VGND VPWR VGND sky130_ef_sc_hd__decap_12
XFILLER_0_30_363 VGND VGND VPWR VPWR sky130_fd_sc_hd__fill_1
XFILLER_0_57_216 VGND VGND VPWR VPWR sky130_fd_sc_hd__decap_3
XFILLER_0_65_293 VGND VGND VPWR VPWR sky130_fd_sc_hd__decap_4
XFILLER_0_25_146 VGND VGND VPWR VPWR sky130_fd_sc_hd__decap_3
XTAP_TAPCELL_ROW_13_244 VGND VPWR sky130_fd_sc_hd__tapvpwrvgnd_1
XFILLER_0_21_374 VGND VGND VPWR VPWR sky130_fd_sc_hd__fill_2
X_1660_ _0731_ _0742_ VGND VGND VPWR VPWR _0744_ sky130_fd_sc_hd__nand2_1
X_1591_ _0451_ _0460_ _0470_ VGND VGND VPWR VPWR _0480_ sky130_fd_sc_hd__nor3_2
XTAP_TAPCELL_ROW_64_601 VGND VPWR sky130_fd_sc_hd__tapvpwrvgnd_1
XFILLER_0_56_77 VGND VGND VPWR VPWR sky130_fd_sc_hd__decap_6
X_2212_ _1102_ net71 _1295_ VGND VGND VPWR VPWR _1296_ sky130_fd_sc_hd__or3_1
X_2143_ _1128_ _1201_ VGND VGND VPWR VPWR _1227_ sky130_fd_sc_hd__nor2_1
X_2074_ _0940_ _0954_ _1115_ VGND VGND VPWR VPWR _1158_ sky130_fd_sc_hd__mux2_1
XFILLER_0_15_7 VGND VGND VPWR VPWR sky130_fd_sc_hd__fill_2
X_2976_ net31 _1476_ _0514_ _0593_ _0594_ VGND VGND VPWR VPWR _0595_ sky130_fd_sc_hd__a221o_1
XFILLER_0_8_357 VGND VGND VPWR VPWR sky130_fd_sc_hd__decap_6
XFILLER_0_16_113 VGND VGND VPWR VPWR sky130_fd_sc_hd__decap_6
X_1858_ _0897_ _0896_ VGND VGND VPWR VPWR _0942_ sky130_fd_sc_hd__or2b_1
X_1927_ _1010_ VGND VGND VPWR VPWR _1011_ sky130_fd_sc_hd__buf_6
X_1789_ _0871_ _0872_ VGND VGND VPWR VPWR _0873_ sky130_fd_sc_hd__xor2_2
XFILLER_0_12_341 VPWR VGND VPWR VGND sky130_ef_sc_hd__decap_12
XTAP_TAPCELL_ROW_27_336 VGND VPWR sky130_fd_sc_hd__tapvpwrvgnd_1
XFILLER_0_62_230 VGND VGND VPWR VPWR sky130_fd_sc_hd__decap_4
XFILLER_0_39_249 VPWR VGND VPWR VGND sky130_ef_sc_hd__decap_12
XPHY_EDGE_ROW_33_Left_103 VGND VGND VPWR VPWR sky130_fd_sc_hd__decap_3
XFILLER_0_30_171 VGND VGND VPWR VPWR sky130_fd_sc_hd__fill_1
XPHY_EDGE_ROW_42_Left_112 VGND VGND VPWR VPWR sky130_fd_sc_hd__decap_3
XPHY_EDGE_ROW_51_Left_121 VGND VGND VPWR VPWR sky130_fd_sc_hd__decap_3
X_2830_ _0091_ _0441_ _0315_ _0450_ VGND VGND VPWR VPWR _0452_ sky130_fd_sc_hd__o22a_1
X_2692_ _0169_ _0257_ VGND VGND VPWR VPWR _0301_ sky130_fd_sc_hd__nor2_1
X_2761_ _0308_ _0311_ VGND VGND VPWR VPWR _0377_ sky130_fd_sc_hd__nor2_1
XFILLER_0_42_79 VGND VGND VPWR VPWR sky130_fd_sc_hd__decap_4
X_1643_ _0724_ _0726_ VGND VGND VPWR VPWR _0727_ sky130_fd_sc_hd__xnor2_1
XFILLER_0_5_305 VPWR VGND VPWR VGND sky130_ef_sc_hd__decap_12
XFILLER_0_5_349 VPWR VGND VPWR VGND sky130_ef_sc_hd__decap_12
X_1712_ _0792_ _0775_ VGND VGND VPWR VPWR _0796_ sky130_fd_sc_hd__nor2_1
XPHY_EDGE_ROW_60_Left_130 VGND VGND VPWR VPWR sky130_fd_sc_hd__decap_3
X_1574_ _0276_ _0287_ VGND VGND VPWR VPWR _0298_ sky130_fd_sc_hd__nor2_1
XTAP_TAPCELL_ROW_49_494 VGND VPWR sky130_fd_sc_hd__tapvpwrvgnd_1
Xrebuffer24 _0297_ VGND VGND VPWR VPWR net79 sky130_fd_sc_hd__dlygate4sd1_1
X_2057_ _1011_ _1140_ VGND VGND VPWR VPWR _1141_ sky130_fd_sc_hd__or2_1
X_2126_ _1148_ _1153_ _0993_ VGND VGND VPWR VPWR _1210_ sky130_fd_sc_hd__mux2_1
X_2959_ _0564_ _0577_ _0447_ VGND VGND VPWR VPWR _0578_ sky130_fd_sc_hd__mux2_1
XTAP_TAPCELL_ROW_32_372 VGND VPWR sky130_fd_sc_hd__tapvpwrvgnd_1
XTAP_TAPCELL_ROW_24_317 VGND VPWR sky130_fd_sc_hd__tapvpwrvgnd_1
XFILLER_0_8_121 VPWR VGND VPWR VGND sky130_ef_sc_hd__decap_12
XFILLER_0_44_285 VPWR VGND VPWR VGND sky130_ef_sc_hd__decap_12
XFILLER_0_67_333 VGND VGND VPWR VPWR sky130_fd_sc_hd__decap_3
XFILLER_0_37_57 VGND VGND VPWR VPWR sky130_fd_sc_hd__decap_3
XFILLER_0_58_377 VGND VGND VPWR VPWR sky130_fd_sc_hd__decap_3
XFILLER_0_53_67 VPWR VGND VPWR VGND sky130_ef_sc_hd__decap_12
X_2813_ _0431_ _0433_ _0400_ VGND VGND VPWR VPWR _0434_ sky130_fd_sc_hd__mux2_4
XTAP_TAPCELL_ROW_46_475 VGND VPWR sky130_fd_sc_hd__tapvpwrvgnd_1
X_2744_ _0190_ _0237_ VGND VGND VPWR VPWR _0358_ sky130_fd_sc_hd__or2b_1
X_2675_ _0137_ _0281_ VGND VGND VPWR VPWR _0282_ sky130_fd_sc_hd__nor2_1
XFILLER_0_41_255 VGND VGND VPWR VPWR sky130_fd_sc_hd__fill_2
XFILLER_0_26_296 VPWR VGND VPWR VGND sky130_ef_sc_hd__decap_12
XFILLER_0_5_135 VPWR VGND VPWR VGND sky130_ef_sc_hd__decap_12
X_1626_ _0706_ _0709_ VGND VGND VPWR VPWR _0710_ sky130_fd_sc_hd__xor2_2
X_1557_ _1530_ _0089_ _0078_ VGND VGND VPWR VPWR _0111_ sky130_fd_sc_hd__o21ai_1
XFILLER_0_1_385 VGND VGND VPWR VPWR sky130_fd_sc_hd__decap_6
XFILLER_0_49_355 VGND VGND VPWR VPWR sky130_fd_sc_hd__decap_3
X_3089_ clknet_2_3__leaf_clock _0006_ VGND VGND VPWR VPWR net49 sky130_fd_sc_hd__dfxtp_2
X_2109_ _1113_ VGND VGND VPWR VPWR _1193_ sky130_fd_sc_hd__buf_4
XFILLER_0_67_196 VGND VGND VPWR VPWR sky130_fd_sc_hd__fill_1
XFILLER_0_63_380 VPWR VGND VPWR VGND sky130_ef_sc_hd__decap_12
X_2460_ _0044_ VGND VGND VPWR VPWR _0046_ sky130_fd_sc_hd__inv_2
XFILLER_0_55_369 VPWR VGND VPWR VGND sky130_ef_sc_hd__decap_12
Xrebuffer4 net62 VGND VGND VPWR VPWR net59 sky130_fd_sc_hd__clkbuf_1
X_2391_ _1459_ _1469_ _1473_ _1474_ _1477_ VGND VGND VPWR VPWR _1478_ sky130_fd_sc_hd__a2111o_1
XFILLER_0_48_89 VGND VGND VPWR VPWR sky130_fd_sc_hd__decap_8
XFILLER_0_64_77 VGND VGND VPWR VPWR sky130_fd_sc_hd__decap_4
X_3012_ net38 _0628_ _1188_ VGND VGND VPWR VPWR _0629_ sky130_fd_sc_hd__mux2_1
XFILLER_0_14_222 VGND VGND VPWR VPWR sky130_fd_sc_hd__decap_8
X_2589_ _0185_ _0105_ _0186_ _0135_ VGND VGND VPWR VPWR _0187_ sky130_fd_sc_hd__o211a_1
X_2727_ net65 _0211_ VGND VGND VPWR VPWR _0339_ sky130_fd_sc_hd__or2b_4
X_2658_ _0069_ VGND VGND VPWR VPWR _0263_ sky130_fd_sc_hd__inv_2
X_1609_ _0243_ _0320_ _0647_ VGND VGND VPWR VPWR _0657_ sky130_fd_sc_hd__a21boi_1
XTAP_TAPCELL_ROW_57_548 VGND VPWR sky130_fd_sc_hd__tapvpwrvgnd_1
XFILLER_0_49_174 VGND VGND VPWR VPWR sky130_fd_sc_hd__decap_8
XFILLER_0_52_328 VGND VGND VPWR VPWR sky130_fd_sc_hd__decap_8
XFILLER_0_34_58 VPWR VGND VPWR VGND sky130_ef_sc_hd__decap_12
XFILLER_0_55_111 VGND VGND VPWR VPWR sky130_fd_sc_hd__fill_1
XFILLER_0_43_328 VGND VGND VPWR VPWR sky130_fd_sc_hd__decap_8
X_1891_ _0937_ _0916_ VGND VGND VPWR VPWR _0975_ sky130_fd_sc_hd__xor2_1
X_1960_ _0967_ VGND VGND VPWR VPWR _1044_ sky130_fd_sc_hd__clkbuf_4
X_2512_ _0102_ VGND VGND VPWR VPWR _0103_ sky130_fd_sc_hd__inv_2
XFILLER_0_59_55 VGND VGND VPWR VPWR sky130_fd_sc_hd__fill_1
X_2443_ _1103_ _1267_ VGND VGND VPWR VPWR _1534_ sky130_fd_sc_hd__or2_1
XFILLER_0_11_225 VGND VGND VPWR VPWR sky130_fd_sc_hd__decap_4
X_2374_ _1391_ _1443_ _1376_ _1457_ _1458_ VGND VGND VPWR VPWR _1459_ sky130_fd_sc_hd__a311o_1
XTAP_TAPCELL_ROW_62_584 VGND VPWR sky130_fd_sc_hd__tapvpwrvgnd_1
XTAP_TAPCELL_ROW_54_529 VGND VPWR sky130_fd_sc_hd__tapvpwrvgnd_1
XTAP_TAPCELL_ROW_19_283 VGND VPWR sky130_fd_sc_hd__tapvpwrvgnd_1
XFILLER_0_19_347 VPWR VGND VPWR VGND sky130_ef_sc_hd__decap_12
XFILLER_0_61_125 VGND VGND VPWR VPWR sky130_fd_sc_hd__decap_4
XFILLER_0_46_188 VGND VGND VPWR VPWR sky130_fd_sc_hd__decap_8
XFILLER_0_42_361 VGND VGND VPWR VPWR sky130_fd_sc_hd__decap_3
XFILLER_0_27_391 VGND VGND VPWR VPWR sky130_fd_sc_hd__fill_1
XFILLER_0_69_247 VGND VGND VPWR VPWR sky130_fd_sc_hd__decap_4
XFILLER_0_69_225 VPWR VGND VPWR VGND sky130_ef_sc_hd__decap_12
XTAP_TAPCELL_ROW_2_162 VGND VPWR sky130_fd_sc_hd__tapvpwrvgnd_1
XFILLER_0_37_144 VGND VGND VPWR VPWR sky130_fd_sc_hd__decap_6
XFILLER_0_25_328 VGND VGND VPWR VPWR sky130_fd_sc_hd__fill_1
XFILLER_0_18_380 VPWR VGND VPWR VGND sky130_ef_sc_hd__decap_12
XFILLER_0_40_309 VGND VGND VPWR VPWR sky130_fd_sc_hd__fill_2
X_2090_ _1173_ VGND VGND VPWR VPWR _1174_ sky130_fd_sc_hd__buf_4
XFILLER_0_29_69 VPWR VGND VPWR VGND sky130_ef_sc_hd__decap_12
XFILLER_0_45_57 VPWR VGND VPWR VGND sky130_ef_sc_hd__decap_12
X_2992_ _0610_ VGND VGND VPWR VPWR _0021_ sky130_fd_sc_hd__clkbuf_1
XFILLER_0_0_15 VPWR VGND VPWR VGND sky130_ef_sc_hd__decap_12
XTAP_TAPCELL_ROW_16_264 VGND VPWR sky130_fd_sc_hd__tapvpwrvgnd_1
XFILLER_0_43_125 VGND VGND VPWR VPWR sky130_fd_sc_hd__decap_6
X_1943_ _1011_ _1003_ VGND VGND VPWR VPWR _1027_ sky130_fd_sc_hd__or2b_1
XFILLER_0_9_57 VGND VGND VPWR VPWR sky130_fd_sc_hd__decap_4
XFILLER_0_9_79 VPWR VGND VPWR VGND sky130_ef_sc_hd__decap_12
X_1874_ _0938_ _0955_ _0957_ VGND VGND VPWR VPWR _0958_ sky130_fd_sc_hd__o21ai_1
XFILLER_0_16_339 VPWR VGND VPWR VGND sky130_ef_sc_hd__decap_12
X_2426_ _1496_ _1497_ _1515_ VGND VGND VPWR VPWR _1516_ sky130_fd_sc_hd__and3b_1
XTAP_TAPCELL_ROW_67_621 VGND VPWR sky130_fd_sc_hd__tapvpwrvgnd_1
X_2357_ _1403_ _1404_ _1412_ _1418_ _1440_ VGND VGND VPWR VPWR _1441_ sky130_fd_sc_hd__a2111o_4
X_2288_ _1106_ _1308_ _1315_ _1101_ VGND VGND VPWR VPWR _1372_ sky130_fd_sc_hd__a31o_1
XFILLER_0_36_3 VPWR VGND VPWR VGND sky130_ef_sc_hd__decap_12
XFILLER_0_62_412 VGND VGND VPWR VPWR sky130_fd_sc_hd__decap_3
XFILLER_0_30_342 VPWR VGND VPWR VGND sky130_ef_sc_hd__decap_12
XFILLER_0_25_169 VGND VGND VPWR VPWR sky130_fd_sc_hd__decap_8
XFILLER_0_40_139 VGND VGND VPWR VPWR sky130_fd_sc_hd__fill_1
XFILLER_0_0_225 VPWR VGND VPWR VGND sky130_ef_sc_hd__decap_12
X_1590_ _0199_ _0188_ VGND VGND VPWR VPWR _0470_ sky130_fd_sc_hd__nor2_2
X_2211_ _1247_ _1222_ VGND VGND VPWR VPWR _1295_ sky130_fd_sc_hd__nand2_1
X_2142_ _1207_ _1225_ _1196_ VGND VGND VPWR VPWR _1226_ sky130_fd_sc_hd__a21o_1
X_2073_ _1151_ _1156_ _1011_ VGND VGND VPWR VPWR _1157_ sky130_fd_sc_hd__mux2_1
X_2975_ _0503_ _0534_ _0554_ _0456_ VGND VGND VPWR VPWR _0594_ sky130_fd_sc_hd__o22ai_2
X_1788_ _0858_ _0857_ VGND VGND VPWR VPWR _0872_ sky130_fd_sc_hd__xnor2_1
XFILLER_0_12_353 VGND VGND VPWR VPWR sky130_fd_sc_hd__decap_8
X_1857_ _0905_ _0904_ VGND VGND VPWR VPWR _0941_ sky130_fd_sc_hd__xnor2_2
X_1926_ _0935_ _1008_ _0963_ _1009_ VGND VGND VPWR VPWR _1010_ sky130_fd_sc_hd__and4bb_1
XFILLER_0_16_125 VGND VGND VPWR VPWR sky130_fd_sc_hd__decap_8
X_2409_ _1263_ _1264_ VGND VGND VPWR VPWR _1497_ sky130_fd_sc_hd__xor2_2
XTAP_TAPCELL_ROW_27_337 VGND VPWR sky130_fd_sc_hd__tapvpwrvgnd_1
XFILLER_0_62_253 VPWR VGND VPWR VGND sky130_ef_sc_hd__decap_12
XTAP_TAPCELL_ROW_35_392 VGND VPWR sky130_fd_sc_hd__tapvpwrvgnd_1
XFILLER_0_7_391 VGND VGND VPWR VPWR sky130_fd_sc_hd__fill_1
XFILLER_0_30_194 VGND VGND VPWR VPWR sky130_fd_sc_hd__fill_2
XFILLER_0_26_26 VGND VGND VPWR VPWR sky130_fd_sc_hd__fill_2
X_2691_ _0288_ _0299_ VGND VGND VPWR VPWR _0300_ sky130_fd_sc_hd__or2_1
X_2760_ _0374_ VGND VGND VPWR VPWR _0376_ sky130_fd_sc_hd__buf_2
X_1711_ _0793_ _0794_ VGND VGND VPWR VPWR _0795_ sky130_fd_sc_hd__and2b_1
XFILLER_0_5_317 VPWR VGND VPWR VGND sky130_ef_sc_hd__decap_12
X_1642_ _0265_ _0725_ VGND VGND VPWR VPWR _0726_ sky130_fd_sc_hd__and2b_1
XFILLER_0_67_99 VGND VGND VPWR VPWR sky130_fd_sc_hd__fill_1
XFILLER_0_67_55 VGND VGND VPWR VPWR sky130_fd_sc_hd__fill_1
X_1573_ _0210_ _0188_ net9 VGND VGND VPWR VPWR _0287_ sky130_fd_sc_hd__o21ai_1
Xrebuffer14 _0407_ VGND VGND VPWR VPWR net69 sky130_fd_sc_hd__dlygate4sd1_1
XTAP_TAPCELL_ROW_49_495 VGND VPWR sky130_fd_sc_hd__tapvpwrvgnd_1
Xrebuffer25 net79 VGND VGND VPWR VPWR net80 sky130_fd_sc_hd__dlygate4sd1_1
X_2125_ _1126_ _1017_ VGND VGND VPWR VPWR _1209_ sky130_fd_sc_hd__or2_1
X_2056_ _0993_ _1139_ VGND VGND VPWR VPWR _1140_ sky130_fd_sc_hd__or2_1
X_2958_ _0317_ _0402_ net66 VGND VGND VPWR VPWR _0577_ sky130_fd_sc_hd__mux2_1
XTAP_TAPCELL_ROW_32_373 VGND VPWR sky130_fd_sc_hd__tapvpwrvgnd_1
XFILLER_0_32_91 VPWR VGND VPWR VGND sky130_ef_sc_hd__decap_12
XFILLER_0_29_250 VGND VGND VPWR VPWR sky130_fd_sc_hd__decap_3
XTAP_TAPCELL_ROW_24_318 VGND VPWR sky130_fd_sc_hd__tapvpwrvgnd_1
XFILLER_0_8_133 VGND VGND VPWR VPWR sky130_fd_sc_hd__decap_6
X_1909_ _0979_ VGND VGND VPWR VPWR _0993_ sky130_fd_sc_hd__buf_2
X_2889_ _0462_ _0508_ _0509_ VGND VGND VPWR VPWR _0510_ sky130_fd_sc_hd__mux2_1
XFILLER_0_44_297 VGND VGND VPWR VPWR sky130_fd_sc_hd__decap_8
XFILLER_0_35_264 VPWR VGND VPWR VGND sky130_ef_sc_hd__decap_12
XFILLER_0_2_309 VPWR VGND VPWR VGND sky130_ef_sc_hd__decap_12
Xoutput50 net50 VGND VGND VPWR VPWR io_accOut[6] sky130_fd_sc_hd__buf_2
XFILLER_0_53_57 VGND VGND VPWR VPWR sky130_fd_sc_hd__decap_3
X_2743_ _0190_ _0356_ VGND VGND VPWR VPWR _0357_ sky130_fd_sc_hd__xnor2_1
XFILLER_0_58_389 VPWR VGND VPWR VGND sky130_ef_sc_hd__decap_12
X_2812_ _0432_ net91 _0429_ VGND VGND VPWR VPWR _0433_ sky130_fd_sc_hd__mux2_4
X_2674_ net63 _1190_ VGND VGND VPWR VPWR _0281_ sky130_fd_sc_hd__nor2_1
XFILLER_0_41_289 VGND VGND VPWR VPWR sky130_fd_sc_hd__fill_2
X_1556_ _1530_ _0078_ _0089_ VGND VGND VPWR VPWR _0100_ sky130_fd_sc_hd__or3_1
XFILLER_0_5_169 VPWR VGND VPWR VGND sky130_ef_sc_hd__decap_12
XFILLER_0_5_147 VPWR VGND VPWR VGND sky130_ef_sc_hd__decap_12
X_1625_ _0188_ _0707_ _0708_ VGND VGND VPWR VPWR _0709_ sky130_fd_sc_hd__a21o_1
Xclkbuf_2_3__f_clock clknet_0_clock VGND VGND VPWR VPWR clknet_2_3__leaf_clock sky130_fd_sc_hd__clkbuf_16
X_2108_ _1191_ VGND VGND VPWR VPWR _1192_ sky130_fd_sc_hd__buf_2
XTAP_TAPCELL_ROW_37_410 VGND VPWR sky130_fd_sc_hd__tapvpwrvgnd_1
X_3088_ clknet_2_3__leaf_clock _0005_ VGND VGND VPWR VPWR net48 sky130_fd_sc_hd__dfxtp_2
X_2039_ _1122_ _0971_ _1044_ VGND VGND VPWR VPWR _1123_ sky130_fd_sc_hd__mux2_1
XFILLER_0_32_223 VGND VGND VPWR VPWR sky130_fd_sc_hd__decap_4
XFILLER_0_67_186 VGND VGND VPWR VPWR sky130_fd_sc_hd__fill_1
XFILLER_0_67_131 VGND VGND VPWR VPWR sky130_fd_sc_hd__fill_2
XFILLER_0_55_337 VPWR VGND VPWR VGND sky130_ef_sc_hd__decap_12
XFILLER_0_55_326 VGND VGND VPWR VPWR sky130_fd_sc_hd__decap_8
Xrebuffer5 _1077_ VGND VGND VPWR VPWR net60 sky130_fd_sc_hd__dlymetal6s2s_1
XFILLER_0_2_128 VGND VGND VPWR VPWR sky130_fd_sc_hd__fill_2
X_2390_ _1467_ _1475_ VGND VGND VPWR VPWR _1477_ sky130_fd_sc_hd__and2b_1
XFILLER_0_48_68 VGND VGND VPWR VPWR sky130_fd_sc_hd__decap_4
X_3011_ _1056_ _1046_ VGND VGND VPWR VPWR _0628_ sky130_fd_sc_hd__nor2_1
XFILLER_0_3_15 VGND VGND VPWR VPWR sky130_fd_sc_hd__decap_3
XFILLER_0_58_175 VGND VGND VPWR VPWR sky130_fd_sc_hd__decap_6
X_2726_ _0337_ VGND VGND VPWR VPWR _0338_ sky130_fd_sc_hd__inv_2
XFILLER_0_58_197 VPWR VGND VPWR VGND sky130_ef_sc_hd__decap_12
XFILLER_0_6_401 VPWR VGND VPWR VGND sky130_ef_sc_hd__decap_12
XFILLER_0_13_82 VGND VGND VPWR VPWR sky130_fd_sc_hd__fill_2
XFILLER_0_14_234 VGND VGND VPWR VPWR sky130_fd_sc_hd__decap_3
XFILLER_0_66_3 VPWR VGND VPWR VGND sky130_ef_sc_hd__decap_12
X_2588_ _1289_ _1290_ VGND VGND VPWR VPWR _0186_ sky130_fd_sc_hd__nand2_1
X_2657_ _0120_ _0126_ VGND VGND VPWR VPWR _0262_ sky130_fd_sc_hd__nand2_1
X_1608_ net9 VGND VGND VPWR VPWR _0647_ sky130_fd_sc_hd__buf_2
XTAP_TAPCELL_ROW_57_549 VGND VPWR sky130_fd_sc_hd__tapvpwrvgnd_1
XFILLER_0_64_123 VGND VGND VPWR VPWR sky130_fd_sc_hd__decap_8
XFILLER_0_52_307 VGND VGND VPWR VPWR sky130_fd_sc_hd__fill_1
XFILLER_0_49_131 VGND VGND VPWR VPWR sky130_fd_sc_hd__decap_3
XTAP_TAPCELL_ROW_40_427 VGND VPWR sky130_fd_sc_hd__tapvpwrvgnd_1
XFILLER_0_37_348 VGND VGND VPWR VPWR sky130_fd_sc_hd__decap_8
XFILLER_0_37_337 VGND VGND VPWR VPWR sky130_fd_sc_hd__fill_1
XFILLER_0_9_250 VPWR VGND VPWR VGND sky130_ef_sc_hd__decap_12
XFILLER_0_9_294 VPWR VGND VPWR VGND sky130_ef_sc_hd__decap_12
XFILLER_0_60_351 VGND VGND VPWR VPWR sky130_fd_sc_hd__decap_6
XTAP_TAPCELL_ROW_5_182 VGND VPWR sky130_fd_sc_hd__tapvpwrvgnd_1
XFILLER_0_34_15 VPWR VGND VPWR VGND sky130_ef_sc_hd__decap_12
XPHY_EDGE_ROW_16_Right_16 VGND VGND VPWR VPWR sky130_fd_sc_hd__decap_3
XFILLER_0_36_392 VGND VGND VPWR VPWR sky130_fd_sc_hd__decap_4
XFILLER_0_28_359 VGND VGND VPWR VPWR sky130_fd_sc_hd__decap_4
XFILLER_0_28_337 VGND VGND VPWR VPWR sky130_fd_sc_hd__decap_6
XPHY_EDGE_ROW_25_Right_25 VGND VGND VPWR VPWR sky130_fd_sc_hd__decap_3
X_1890_ _0972_ _0973_ _0943_ _0952_ _0941_ VGND VGND VPWR VPWR _0974_ sky130_fd_sc_hd__a311o_1
X_2511_ _1482_ _1483_ VGND VGND VPWR VPWR _0102_ sky130_fd_sc_hd__nand2_1
X_2442_ _1531_ _1532_ VGND VGND VPWR VPWR _1533_ sky130_fd_sc_hd__nor2b_2
X_2373_ _1374_ _1375_ VGND VGND VPWR VPWR _1458_ sky130_fd_sc_hd__and2_1
XFILLER_0_11_248 VGND VGND VPWR VPWR sky130_fd_sc_hd__decap_8
XPHY_EDGE_ROW_34_Right_34 VGND VGND VPWR VPWR sky130_fd_sc_hd__decap_3
XTAP_TAPCELL_ROW_62_585 VGND VPWR sky130_fd_sc_hd__tapvpwrvgnd_1
XFILLER_0_46_101 VPWR VGND VPWR VGND sky130_ef_sc_hd__decap_12
XFILLER_0_24_81 VGND VGND VPWR VPWR sky130_fd_sc_hd__decap_3
XFILLER_0_24_70 VGND VGND VPWR VPWR sky130_fd_sc_hd__fill_2
XTAP_TAPCELL_ROW_19_284 VGND VPWR sky130_fd_sc_hd__tapvpwrvgnd_1
XFILLER_0_19_337 VGND VGND VPWR VPWR sky130_fd_sc_hd__fill_2
XFILLER_0_19_359 VPWR VGND VPWR VGND sky130_ef_sc_hd__decap_12
X_2709_ _0184_ _0318_ VGND VGND VPWR VPWR _0319_ sky130_fd_sc_hd__xnor2_2
XPHY_EDGE_ROW_43_Right_43 VGND VGND VPWR VPWR sky130_fd_sc_hd__decap_3
XFILLER_0_6_220 VGND VGND VPWR VPWR sky130_fd_sc_hd__decap_6
XFILLER_0_6_253 VGND VGND VPWR VPWR sky130_fd_sc_hd__decap_4
XPHY_EDGE_ROW_52_Right_52 VGND VGND VPWR VPWR sky130_fd_sc_hd__decap_3
XFILLER_0_69_237 VGND VGND VPWR VPWR sky130_fd_sc_hd__decap_4
XFILLER_0_4_80 VGND VGND VPWR VPWR sky130_fd_sc_hd__decap_4
XTAP_TAPCELL_ROW_2_163 VGND VPWR sky130_fd_sc_hd__tapvpwrvgnd_1
XPHY_EDGE_ROW_61_Right_61 VGND VGND VPWR VPWR sky130_fd_sc_hd__decap_3
XFILLER_0_52_104 VGND VGND VPWR VPWR sky130_fd_sc_hd__decap_4
XFILLER_0_18_392 VPWR VGND VPWR VGND sky130_ef_sc_hd__decap_12
XFILLER_0_45_69 VPWR VGND VPWR VGND sky130_ef_sc_hd__decap_12
XFILLER_0_68_281 VGND VGND VPWR VPWR sky130_fd_sc_hd__decap_8
XFILLER_0_61_57 VPWR VGND VPWR VGND sky130_ef_sc_hd__decap_12
X_2991_ _0604_ _0607_ _0609_ VGND VGND VPWR VPWR _0610_ sky130_fd_sc_hd__and3_1
X_1942_ _1025_ _1021_ VGND VGND VPWR VPWR _1026_ sky130_fd_sc_hd__xnor2_4
XFILLER_0_0_27 VGND VGND VPWR VPWR sky130_fd_sc_hd__fill_1
XFILLER_0_16_307 VGND VGND VPWR VPWR sky130_fd_sc_hd__fill_1
XTAP_TAPCELL_ROW_16_265 VGND VPWR sky130_fd_sc_hd__tapvpwrvgnd_1
XFILLER_0_51_181 VGND VGND VPWR VPWR sky130_fd_sc_hd__fill_1
XFILLER_0_24_351 VGND VGND VPWR VPWR sky130_fd_sc_hd__fill_2
XFILLER_0_3_212 VPWR VGND VPWR VGND sky130_ef_sc_hd__decap_12
X_1873_ _0956_ _0918_ VGND VGND VPWR VPWR _0957_ sky130_fd_sc_hd__xor2_1
X_2425_ _1507_ _1514_ VGND VGND VPWR VPWR _1515_ sky130_fd_sc_hd__and2_1
X_2356_ _1294_ _1428_ _1433_ _1439_ VGND VGND VPWR VPWR _1440_ sky130_fd_sc_hd__a2bb2o_4
XFILLER_0_10_83 VGND VGND VPWR VPWR sky130_fd_sc_hd__fill_1
XTAP_TAPCELL_ROW_67_622 VGND VPWR sky130_fd_sc_hd__tapvpwrvgnd_1
X_2287_ _1361_ _1370_ VGND VGND VPWR VPWR _1371_ sky130_fd_sc_hd__nor2_1
XFILLER_0_59_281 VPWR VGND VPWR VGND sky130_ef_sc_hd__decap_12
XTAP_TAPCELL_ROW_50_500 VGND VPWR sky130_fd_sc_hd__tapvpwrvgnd_1
XFILLER_0_34_115 VGND VGND VPWR VPWR sky130_fd_sc_hd__decap_4
XFILLER_0_30_365 VGND VGND VPWR VPWR sky130_fd_sc_hd__decap_8
XFILLER_0_30_354 VGND VGND VPWR VPWR sky130_fd_sc_hd__fill_2
XTAP_TAPCELL_ROW_7_200 VGND VPWR sky130_fd_sc_hd__tapvpwrvgnd_1
XFILLER_0_15_373 VPWR VGND VPWR VGND sky130_ef_sc_hd__decap_12
XPHY_EDGE_ROW_8_Left_78 VGND VGND VPWR VPWR sky130_fd_sc_hd__decap_3
XFILLER_0_38_410 VGND VGND VPWR VPWR sky130_fd_sc_hd__fill_1
XFILLER_0_40_107 VPWR VGND VPWR VGND sky130_ef_sc_hd__decap_12
X_2210_ _1088_ net72 VGND VGND VPWR VPWR _1294_ sky130_fd_sc_hd__nand2_4
XFILLER_0_0_237 VPWR VGND VPWR VGND sky130_ef_sc_hd__decap_12
X_2141_ net30 _1224_ _1092_ VGND VGND VPWR VPWR _1225_ sky130_fd_sc_hd__mux2_2
X_2072_ _0993_ _1153_ _1155_ VGND VGND VPWR VPWR _1156_ sky130_fd_sc_hd__o21ai_1
X_2974_ _0374_ _0565_ _0592_ VGND VGND VPWR VPWR _0593_ sky130_fd_sc_hd__a21oi_1
X_1925_ _0930_ _0925_ _0931_ _0932_ VGND VGND VPWR VPWR _1009_ sky130_fd_sc_hd__o211a_1
XFILLER_0_16_137 VGND VGND VPWR VPWR sky130_fd_sc_hd__decap_3
X_1787_ _0866_ _0868_ _0870_ VGND VGND VPWR VPWR _0871_ sky130_fd_sc_hd__a21bo_4
X_1856_ _0908_ _0939_ VGND VGND VPWR VPWR _0940_ sky130_fd_sc_hd__xnor2_1
XFILLER_0_12_365 VPWR VGND VPWR VGND sky130_ef_sc_hd__decap_12
X_2408_ _1493_ _1495_ VGND VGND VPWR VPWR _1496_ sky130_fd_sc_hd__nor2_1
X_2339_ _1331_ _1332_ _1174_ VGND VGND VPWR VPWR _1423_ sky130_fd_sc_hd__a21o_1
XPHY_EDGE_ROW_2_Right_2 VGND VGND VPWR VPWR sky130_fd_sc_hd__decap_3
XTAP_TAPCELL_ROW_27_338 VGND VPWR sky130_fd_sc_hd__tapvpwrvgnd_1
XFILLER_0_1_70 VGND VGND VPWR VPWR sky130_fd_sc_hd__fill_2
XFILLER_0_62_265 VGND VGND VPWR VPWR sky130_fd_sc_hd__decap_8
XTAP_TAPCELL_ROW_35_393 VGND VPWR sky130_fd_sc_hd__tapvpwrvgnd_1
XFILLER_0_22_129 VGND VGND VPWR VPWR sky130_fd_sc_hd__fill_2
XFILLER_0_15_181 VGND VGND VPWR VPWR sky130_fd_sc_hd__decap_3
XFILLER_0_42_37 VGND VGND VPWR VPWR sky130_fd_sc_hd__fill_1
XFILLER_0_42_15 VPWR VGND VPWR VGND sky130_ef_sc_hd__decap_12
XFILLER_0_26_413 VGND VGND VPWR VPWR sky130_fd_sc_hd__fill_2
XFILLER_0_5_329 VGND VGND VPWR VPWR sky130_fd_sc_hd__decap_6
XFILLER_0_53_276 VGND VGND VPWR VPWR sky130_fd_sc_hd__decap_4
X_2690_ _0295_ _0297_ VGND VGND VPWR VPWR _0299_ sky130_fd_sc_hd__or2b_4
X_1710_ _0774_ _0788_ VGND VGND VPWR VPWR _0794_ sky130_fd_sc_hd__xor2_1
X_1641_ net10 _0166_ _0232_ _0254_ VGND VGND VPWR VPWR _0725_ sky130_fd_sc_hd__a22o_1
X_1572_ net9 _0210_ _0188_ VGND VGND VPWR VPWR _0276_ sky130_fd_sc_hd__and3_1
XFILLER_0_21_140 VGND VGND VPWR VPWR sky130_fd_sc_hd__fill_1
X_2124_ _1149_ _1158_ _1147_ VGND VGND VPWR VPWR _1208_ sky130_fd_sc_hd__mux2_1
XTAP_TAPCELL_ROW_49_496 VGND VPWR sky130_fd_sc_hd__tapvpwrvgnd_1
Xrebuffer15 _1259_ VGND VGND VPWR VPWR net70 sky130_fd_sc_hd__dlygate4sd3_1
XTAP_TAPCELL_ROW_24_319 VGND VPWR sky130_fd_sc_hd__tapvpwrvgnd_1
XFILLER_0_16_93 VPWR VGND VPWR VGND sky130_ef_sc_hd__decap_12
X_2055_ _1138_ _1044_ VGND VGND VPWR VPWR _1139_ sky130_fd_sc_hd__or2b_1
X_2888_ _0372_ VGND VGND VPWR VPWR _0509_ sky130_fd_sc_hd__clkbuf_4
XFILLER_0_44_221 VGND VGND VPWR VPWR sky130_fd_sc_hd__decap_6
X_2957_ net29 _1476_ _0557_ _0520_ VGND VGND VPWR VPWR _0576_ sky130_fd_sc_hd__a22o_1
XTAP_TAPCELL_ROW_32_374 VGND VPWR sky130_fd_sc_hd__tapvpwrvgnd_1
X_1839_ _0832_ VGND VGND VPWR VPWR _0923_ sky130_fd_sc_hd__inv_2
X_1908_ _0979_ _0991_ VGND VGND VPWR VPWR _0992_ sky130_fd_sc_hd__nor2_1
XFILLER_0_12_195 VGND VGND VPWR VPWR sky130_fd_sc_hd__fill_1
XFILLER_0_12_29 VGND VGND VPWR VPWR sky130_fd_sc_hd__decap_4
XFILLER_0_50_246 VGND VGND VPWR VPWR sky130_fd_sc_hd__decap_3
XFILLER_0_35_276 VGND VGND VPWR VPWR sky130_fd_sc_hd__decap_4
XFILLER_0_23_405 VGND VGND VPWR VPWR sky130_fd_sc_hd__decap_8
XFILLER_0_37_15 VPWR VGND VPWR VGND sky130_ef_sc_hd__decap_12
Xoutput51 net51 VGND VGND VPWR VPWR io_accOut[7] sky130_fd_sc_hd__buf_2
Xoutput40 net40 VGND VGND VPWR VPWR io_accOut[26] sky130_fd_sc_hd__buf_2
XFILLER_0_58_357 VGND VGND VPWR VPWR sky130_fd_sc_hd__decap_6
XFILLER_0_58_335 VGND VGND VPWR VPWR sky130_fd_sc_hd__decap_8
X_2742_ _0168_ _0237_ VGND VGND VPWR VPWR _0356_ sky130_fd_sc_hd__nor2_1
X_2811_ net69 VGND VGND VPWR VPWR _0432_ sky130_fd_sc_hd__inv_2
XFILLER_0_26_221 VPWR VGND VPWR VGND sky130_ef_sc_hd__decap_12
XFILLER_0_5_159 VGND VGND VPWR VPWR sky130_fd_sc_hd__fill_2
X_2673_ _0158_ _0160_ VGND VGND VPWR VPWR _0280_ sky130_fd_sc_hd__nand2_1
X_1555_ net17 net15 VGND VGND VPWR VPWR _0089_ sky130_fd_sc_hd__nor2_1
X_1624_ _0419_ _0451_ VGND VGND VPWR VPWR _0708_ sky130_fd_sc_hd__nor2_1
X_2107_ _1088_ _1096_ VGND VGND VPWR VPWR _1191_ sky130_fd_sc_hd__and2b_1
XTAP_TAPCELL_ROW_37_411 VGND VPWR sky130_fd_sc_hd__tapvpwrvgnd_1
X_3087_ clknet_2_1__leaf_clock _0004_ VGND VGND VPWR VPWR net47 sky130_fd_sc_hd__dfxtp_2
XFILLER_0_27_92 VPWR VGND VPWR VGND sky130_ef_sc_hd__decap_12
XFILLER_0_64_349 VGND VGND VPWR VPWR sky130_fd_sc_hd__fill_1
XFILLER_0_49_335 VGND VGND VPWR VPWR sky130_fd_sc_hd__fill_1
XFILLER_0_11_3 VPWR VGND VPWR VGND sky130_ef_sc_hd__decap_12
X_2038_ _1121_ VGND VGND VPWR VPWR _1122_ sky130_fd_sc_hd__inv_2
XFILLER_0_55_349 VPWR VGND VPWR VGND sky130_ef_sc_hd__decap_12
XFILLER_0_55_316 VGND VGND VPWR VPWR sky130_fd_sc_hd__fill_1
XFILLER_0_63_393 VPWR VGND VPWR VGND sky130_ef_sc_hd__decap_12
Xrebuffer6 _1400_ VGND VGND VPWR VPWR net61 sky130_fd_sc_hd__clkbuf_1
XFILLER_0_23_268 VGND VGND VPWR VPWR sky130_fd_sc_hd__decap_3
X_3010_ _0501_ _0625_ _0626_ _0523_ VGND VGND VPWR VPWR _0024_ sky130_fd_sc_hd__o211a_1
XFILLER_0_58_110 VGND VGND VPWR VPWR sky130_fd_sc_hd__fill_1
X_2725_ _0202_ _0336_ VGND VGND VPWR VPWR _0337_ sky130_fd_sc_hd__xnor2_2
X_2656_ _0069_ _0260_ VGND VGND VPWR VPWR _0261_ sky130_fd_sc_hd__xnor2_2
XFILLER_0_6_413 VGND VGND VPWR VPWR sky130_fd_sc_hd__fill_2
X_2587_ _0087_ _0104_ VGND VGND VPWR VPWR _0185_ sky130_fd_sc_hd__nand2_1
XFILLER_0_59_3 VPWR VGND VPWR VGND sky130_ef_sc_hd__decap_12
X_1607_ _0375_ _0386_ VGND VGND VPWR VPWR _0636_ sky130_fd_sc_hd__xor2_1
XTAP_TAPCELL_ROW_40_428 VGND VPWR sky130_fd_sc_hd__tapvpwrvgnd_1
XFILLER_0_37_327 VGND VGND VPWR VPWR sky130_fd_sc_hd__fill_1
XFILLER_0_9_262 VGND VGND VPWR VPWR sky130_fd_sc_hd__decap_4
XFILLER_0_60_363 VGND VGND VPWR VPWR sky130_fd_sc_hd__fill_1
XFILLER_0_45_393 VPWR VGND VPWR VGND sky130_ef_sc_hd__decap_12
XTAP_TAPCELL_ROW_5_183 VGND VPWR sky130_fd_sc_hd__tapvpwrvgnd_1
XFILLER_0_0_3 VPWR VGND VPWR VGND sky130_ef_sc_hd__decap_12
XFILLER_0_18_39 VPWR VGND VPWR VGND sky130_ef_sc_hd__decap_12
XFILLER_0_55_113 VGND VGND VPWR VPWR sky130_fd_sc_hd__decap_6
XFILLER_0_50_15 VPWR VGND VPWR VGND sky130_ef_sc_hd__decap_12
XFILLER_0_34_27 VGND VGND VPWR VPWR sky130_fd_sc_hd__fill_1
XFILLER_0_28_305 VGND VGND VPWR VPWR sky130_fd_sc_hd__decap_3
X_2510_ _1319_ _1320_ VGND VGND VPWR VPWR _0101_ sky130_fd_sc_hd__and2b_1
XFILLER_0_3_405 VGND VGND VPWR VPWR sky130_fd_sc_hd__decap_8
X_2372_ _1454_ _1456_ VGND VGND VPWR VPWR _1457_ sky130_fd_sc_hd__and2b_1
XFILLER_0_59_57 VPWR VGND VPWR VGND sky130_ef_sc_hd__decap_12
X_2441_ _1528_ _1529_ VGND VGND VPWR VPWR _1532_ sky130_fd_sc_hd__nand2_1
XTAP_TAPCELL_ROW_62_586 VGND VPWR sky130_fd_sc_hd__tapvpwrvgnd_1
XFILLER_0_46_113 VGND VGND VPWR VPWR sky130_fd_sc_hd__fill_1
XFILLER_0_34_319 VGND VGND VPWR VPWR sky130_fd_sc_hd__decap_6
XFILLER_0_27_371 VGND VGND VPWR VPWR sky130_fd_sc_hd__decap_6
XTAP_TAPCELL_ROW_19_285 VGND VPWR sky130_fd_sc_hd__tapvpwrvgnd_1
X_2639_ _1497_ _0241_ VGND VGND VPWR VPWR _0242_ sky130_fd_sc_hd__xnor2_2
X_2708_ _0168_ _0244_ VGND VGND VPWR VPWR _0318_ sky130_fd_sc_hd__and2b_1
XFILLER_0_42_330 VGND VGND VPWR VPWR sky130_fd_sc_hd__fill_1
XFILLER_0_27_393 VGND VGND VPWR VPWR sky130_fd_sc_hd__decap_4
XTAP_TAPCELL_ROW_53_520 VGND VPWR sky130_fd_sc_hd__tapvpwrvgnd_1
XTAP_TAPCELL_ROW_2_164 VGND VPWR sky130_fd_sc_hd__tapvpwrvgnd_1
XFILLER_0_20_29 VGND VGND VPWR VPWR sky130_fd_sc_hd__decap_8
XFILLER_0_45_15 VPWR VGND VPWR VGND sky130_ef_sc_hd__decap_12
XFILLER_0_61_69 VPWR VGND VPWR VGND sky130_ef_sc_hd__decap_12
X_2990_ net34 _0441_ _0504_ _0549_ _0481_ VGND VGND VPWR VPWR _0609_ sky130_fd_sc_hd__o221a_1
XFILLER_0_28_124 VGND VGND VPWR VPWR sky130_fd_sc_hd__decap_3
X_1941_ _1023_ _1024_ VGND VGND VPWR VPWR _1025_ sky130_fd_sc_hd__nor2_2
X_1872_ _0845_ _0846_ VGND VGND VPWR VPWR _0956_ sky130_fd_sc_hd__xor2_1
XFILLER_0_36_190 VGND VGND VPWR VPWR sky130_fd_sc_hd__decap_6
XPHY_EDGE_ROW_24_Left_94 VGND VGND VPWR VPWR sky130_fd_sc_hd__decap_3
X_2424_ _1512_ _1513_ VGND VGND VPWR VPWR _1514_ sky130_fd_sc_hd__or2b_1
X_2355_ _1436_ _1438_ _1097_ VGND VGND VPWR VPWR _1439_ sky130_fd_sc_hd__a21oi_1
X_2286_ _1366_ _1369_ _1222_ VGND VGND VPWR VPWR _1370_ sky130_fd_sc_hd__mux2_1
XFILLER_0_66_208 VGND VGND VPWR VPWR sky130_fd_sc_hd__decap_4
XFILLER_0_59_293 VPWR VGND VPWR VGND sky130_ef_sc_hd__decap_12
XTAP_TAPCELL_ROW_50_501 VGND VPWR sky130_fd_sc_hd__tapvpwrvgnd_1
XFILLER_0_34_127 VGND VGND VPWR VPWR sky130_fd_sc_hd__decap_8
XTAP_TAPCELL_ROW_7_201 VGND VPWR sky130_fd_sc_hd__tapvpwrvgnd_1
XFILLER_0_15_385 VGND VGND VPWR VPWR sky130_fd_sc_hd__decap_6
XFILLER_0_53_414 VGND VGND VPWR VPWR sky130_fd_sc_hd__fill_1
XFILLER_0_40_119 VPWR VGND VPWR VGND sky130_ef_sc_hd__decap_12
XFILLER_0_21_300 VPWR VGND VPWR VGND sky130_ef_sc_hd__decap_12
X_2140_ _1021_ _1156_ _1223_ VGND VGND VPWR VPWR _1224_ sky130_fd_sc_hd__a21o_1
XFILLER_0_0_249 VGND VGND VPWR VPWR sky130_fd_sc_hd__decap_3
XFILLER_0_29_411 VGND VGND VPWR VPWR sky130_fd_sc_hd__fill_1
X_2071_ _1132_ _1154_ VGND VGND VPWR VPWR _1155_ sky130_fd_sc_hd__or2_1
X_2973_ _0374_ _0591_ VGND VGND VPWR VPWR _0592_ sky130_fd_sc_hd__nor2_1
X_1855_ _0913_ _0912_ VGND VGND VPWR VPWR _0939_ sky130_fd_sc_hd__or2b_1
X_1924_ _0976_ _0961_ _0936_ _1007_ VGND VGND VPWR VPWR _1008_ sky130_fd_sc_hd__and4b_1
X_1786_ _0792_ _0869_ _0823_ VGND VGND VPWR VPWR _0870_ sky130_fd_sc_hd__or3_4
XFILLER_0_12_377 VPWR VGND VPWR VGND sky130_ef_sc_hd__decap_12
X_2407_ _1494_ VGND VGND VPWR VPWR _1495_ sky130_fd_sc_hd__inv_2
X_2269_ net49 _1322_ _1352_ VGND VGND VPWR VPWR _1353_ sky130_fd_sc_hd__and3_1
X_2338_ _1327_ _1328_ _1271_ VGND VGND VPWR VPWR _1422_ sky130_fd_sc_hd__a21o_1
XFILLER_0_41_3 VPWR VGND VPWR VGND sky130_ef_sc_hd__decap_12
XTAP_TAPCELL_ROW_35_394 VGND VPWR sky130_fd_sc_hd__tapvpwrvgnd_1
XTAP_TAPCELL_ROW_27_339 VGND VPWR sky130_fd_sc_hd__tapvpwrvgnd_1
XFILLER_0_7_393 VPWR VGND VPWR VGND sky130_ef_sc_hd__decap_12
XTAP_TAPCELL_ROW_10_217 VGND VPWR sky130_fd_sc_hd__tapvpwrvgnd_1
XFILLER_0_15_193 VPWR VGND VPWR VGND sky130_ef_sc_hd__decap_12
XFILLER_0_53_255 VGND VGND VPWR VPWR sky130_fd_sc_hd__decap_3
XFILLER_0_42_27 VGND VGND VPWR VPWR sky130_fd_sc_hd__fill_1
XFILLER_0_38_230 VGND VGND VPWR VPWR sky130_fd_sc_hd__fill_1
XFILLER_0_67_57 VPWR VGND VPWR VGND sky130_ef_sc_hd__decap_12
XFILLER_0_53_288 VPWR VGND VPWR VGND sky130_ef_sc_hd__decap_12
X_1640_ net13 _0265_ _0723_ VGND VGND VPWR VPWR _0724_ sky130_fd_sc_hd__o21a_1
X_1571_ net10 _0166_ _0232_ _0254_ VGND VGND VPWR VPWR _0265_ sky130_fd_sc_hd__and4_2
Xrebuffer16 net70 VGND VGND VPWR VPWR net71 sky130_fd_sc_hd__dlygate4sd1_1
X_2123_ _1113_ VGND VGND VPWR VPWR _1207_ sky130_fd_sc_hd__buf_2
XFILLER_0_16_83 VGND VGND VPWR VPWR sky130_fd_sc_hd__fill_1
X_2054_ _0647_ _0763_ VGND VGND VPWR VPWR _1138_ sky130_fd_sc_hd__nand2_1
X_2887_ _0401_ _0506_ _0507_ VGND VGND VPWR VPWR _0508_ sky130_fd_sc_hd__o21ai_1
X_2956_ _0573_ _0574_ _0575_ _0439_ VGND VGND VPWR VPWR _0016_ sky130_fd_sc_hd__a31oi_1
XTAP_TAPCELL_ROW_32_375 VGND VPWR sky130_fd_sc_hd__tapvpwrvgnd_1
X_1907_ _0100_ _0990_ VGND VGND VPWR VPWR _0991_ sky130_fd_sc_hd__xor2_1
XFILLER_0_4_363 VGND VGND VPWR VPWR sky130_fd_sc_hd__fill_1
X_1838_ _0921_ VGND VGND VPWR VPWR _0922_ sky130_fd_sc_hd__inv_2
XFILLER_0_12_163 VPWR VGND VPWR VGND sky130_ef_sc_hd__decap_12
X_1769_ _0848_ _0852_ _0836_ _0777_ VGND VGND VPWR VPWR _0853_ sky130_fd_sc_hd__o22a_1
XPHY_EDGE_ROW_11_Left_81 VGND VGND VPWR VPWR sky130_fd_sc_hd__decap_3
XFILLER_0_35_255 VGND VGND VPWR VPWR sky130_fd_sc_hd__fill_1
Xoutput30 net30 VGND VGND VPWR VPWR io_accOut[17] sky130_fd_sc_hd__buf_2
Xoutput52 net52 VGND VGND VPWR VPWR io_accOut[8] sky130_fd_sc_hd__buf_2
Xoutput41 net41 VGND VGND VPWR VPWR io_accOut[27] sky130_fd_sc_hd__buf_2
XFILLER_0_37_27 VPWR VGND VPWR VGND sky130_ef_sc_hd__decap_12
XFILLER_0_53_15 VPWR VGND VPWR VGND sky130_ef_sc_hd__decap_12
X_2741_ _0344_ _0347_ _0350_ _0354_ VGND VGND VPWR VPWR _0355_ sky130_fd_sc_hd__and4_1
X_2810_ _0385_ _0334_ _0429_ VGND VGND VPWR VPWR _0431_ sky130_fd_sc_hd__mux2_4
X_2672_ _0139_ _0278_ VGND VGND VPWR VPWR _0279_ sky130_fd_sc_hd__xnor2_1
XFILLER_0_41_247 VGND VGND VPWR VPWR sky130_fd_sc_hd__decap_8
XFILLER_0_41_225 VGND VGND VPWR VPWR sky130_fd_sc_hd__decap_4
XFILLER_0_26_233 VPWR VGND VPWR VGND sky130_ef_sc_hd__decap_12
X_1554_ _0034_ _0067_ VGND VGND VPWR VPWR _0078_ sky130_fd_sc_hd__or2_1
X_1623_ _0419_ _0451_ VGND VGND VPWR VPWR _0707_ sky130_fd_sc_hd__nand2_1
.ends
